* PEX produced on Mon Oct 27 04:15:46 AM CET 2025 using ./iic-pex.sh with m=2 and s=1
* NGSPICE file created from tt_um_tadc_its.ext - technology: sky130A

.subckt tt_um_tadc_its_pex VDPWR VGND clk uo_out[0] uo_out[1] uo_out[2] uo_out[3] uo_out[4] uo_out[5] uo_out[6] uo_out[7] uio_out[0]
+ uio_out[1] ua[0] ua[2] ua[1] ui_in[0]
X0 VDPWR single_9b_cdac_0.cdac_sw_9b_0.cdac_sw_3_4.nooverlap_clk_0.x3.Y single_9b_cdac_0.cdac_sw_9b_0.cdac_sw_3_4.nooverlap_clk_0.x4.A VDPWR sky130_fd_pr__pfet_01v8 ad=0.3192 pd=2.81 as=0.168 ps=1.42 w=1.12 l=0.15
X1 a_13968_19822# a_12887_19450# a_13621_19418# VDPWR sky130_fd_pr__pfet_01v8_hvt ad=0.0588 pd=0.7 as=0.12915 ps=1.185 w=0.42 l=0.15
X2 VDPWR single_9b_cdac_1.cdac_sw_9b_0.cdac_sw_3_6.nooverlap_clk_0.x10.A single_9b_cdac_1.cdac_sw_9b_0.cdac_sw_3_6.tg_sw_3_3.SWN VDPWR sky130_fd_pr__pfet_01v8 ad=0.196 pd=1.47 as=0.168 ps=1.42 w=1.12 l=0.15
X3 th_dif_sw_0.VCN single_9b_cdac_0.cdac_sw_9b_0.S[0] sky130_fd_pr__cap_mim_m3_1 l=2 w=2
X4 th_dif_sw_0.VCN single_9b_cdac_0.cdac_sw_9b_0.S[0] sky130_fd_pr__cap_mim_m3_1 l=2 w=2
X5 VGND sar9b_0.net3 a_8697_27426# VGND sky130_fd_pr__nfet_01v8 ad=0.1346 pd=1.15 as=0.0441 ps=0.63 w=0.42 l=0.15
X6 a_6149_23770# sar9b_0.clknet_0_CLK VGND VGND sky130_fd_pr__nfet_01v8 ad=0.0588 pd=0.7 as=0.0588 ps=0.7 w=0.42 l=0.15
X7 a_6483_23618# a_5619_23252# a_6226_23364# VDPWR sky130_fd_pr__pfet_01v8_hvt ad=0.0567 pd=0.69 as=0.1095 ps=1.075 w=0.42 l=0.15
X8 VGND a_6070_19721# a_5999_19822# VGND sky130_fd_pr__nfet_01v8 ad=0.12095 pd=1.085 as=0.0989 ps=0.995 w=0.64 l=0.15
X9 single_9b_cdac_1.cdac_sw_9b_0.S[1] single_9b_cdac_1.cdac_sw_9b_0.cdac_sw_3_1.tg_sw_3_3.SWN ua[0] VDPWR sky130_fd_pr__pfet_01v8 ad=0.435 pd=3.58 as=0.435 ps=3.58 w=1.5 l=0.5
X10 th_dif_sw_0.VCP single_9b_cdac_1.cdac_sw_9b_0.S[0] sky130_fd_pr__cap_mim_m3_1 l=2 w=2
X11 single_9b_cdac_0.cdac_sw_9b_0.S[4] single_9b_cdac_0.cdac_sw_9b_0.cdac_sw_3_3.tg_sw_3_3.SWP single_9b_cdac_0.cdac_sw_9b_0.S[4] VDPWR sky130_fd_pr__pfet_01v8 ad=0.435 pd=3.58 as=6.96 ps=57.28 w=1.5 l=0.5
X12 VDPWR VGND VDPWR VDPWR sky130_fd_pr__pfet_01v8_hvt ad=0.2262 pd=2.26 as=466.4364 ps=4.11008k w=0.87 l=0.59
X13 single_9b_cdac_1.cdac_sw_9b_0.cdac_sw_3_6.nooverlap_clk_0.CLK0 single_9b_cdac_1.cdac_sw_9b_0.cdac_sw_3_6.nooverlap_clk_0.CLKB0 VGND VGND sky130_fd_pr__nfet_01v8_lvt ad=0.1036 pd=1.02 as=0.1554 ps=1.16 w=0.74 l=0.15
X14 single_9b_cdac_1.cdac_sw_9b_0.cdac_sw_3_6.tg_sw_3_3.SWN single_9b_cdac_1.cdac_sw_9b_0.cdac_sw_3_6.nooverlap_clk_0.x10.A VDPWR VDPWR sky130_fd_pr__pfet_01v8 ad=0.168 pd=1.42 as=0.168 ps=1.42 w=1.12 l=0.15
X15 VGND single_9b_cdac_1.cdac_sw_9b_0.cdac_sw_3_5.nooverlap_clk_0.sky130_fd_sc_hs__inv_8_0.A single_9b_cdac_1.cdac_sw_9b_0.cdac_sw_3_5.nooverlap_clk_0.CLKB0 VGND sky130_fd_pr__nfet_01v8_lvt ad=0.1554 pd=1.16 as=0.1036 ps=1.02 w=0.74 l=0.15
X16 th_dif_sw_0.VCN single_9b_cdac_0.cdac_sw_9b_0.S[0] sky130_fd_pr__cap_mim_m3_1 l=2 w=2
X17 single_9b_cdac_0.cdac_sw_9b_0.cdac_sw_3_4.nooverlap_clk_0.x4.A single_9b_cdac_0.cdac_sw_9b_0.cdac_sw_3_4.nooverlap_clk_0.x1.A VDPWR VDPWR sky130_fd_pr__pfet_01v8 ad=0.168 pd=1.42 as=0.3192 ps=2.81 w=1.12 l=0.15
X18 a_6153_23618# a_5619_23252# a_6058_23618# VDPWR sky130_fd_pr__pfet_01v8_hvt ad=0.07665 pd=0.785 as=0.06825 ps=0.745 w=0.42 l=0.15
X19 th_dif_sw_0.VCN single_9b_cdac_0.cdac_sw_9b_0.S[1] sky130_fd_pr__cap_mim_m3_1 l=2 w=2
X20 single_9b_cdac_0.cdac_sw_9b_0.cdac_sw_3_2.nooverlap_clk_0.CLK0 single_9b_cdac_0.cdac_sw_9b_0.cdac_sw_3_2.nooverlap_clk_0.CLKB0 VGND VGND sky130_fd_pr__nfet_01v8_lvt ad=0.1036 pd=1.02 as=0.2146 ps=2.06 w=0.74 l=0.15
X21 VDPWR VGND VDPWR VDPWR sky130_fd_pr__pfet_01v8_hvt ad=0.2262 pd=2.26 as=0 ps=0 w=0.87 l=0.59
X22 single_9b_cdac_1.cdac_sw_9b_0.cdac_sw_3_0.tg_sw_3_3.SWN single_9b_cdac_1.cdac_sw_9b_0.cdac_sw_3_0.nooverlap_clk_0.x10.A VGND VGND sky130_fd_pr__nfet_01v8_lvt ad=0.1036 pd=1.02 as=0.1554 ps=1.16 w=0.74 l=0.15
X23 th_dif_sw_0.VCN single_9b_cdac_0.cdac_sw_9b_0.S[2] sky130_fd_pr__cap_mim_m3_1 l=2 w=2
X24 VGND a_7145_23226# sar9b_0._13_ VGND sky130_fd_pr__nfet_01v8 ad=0.25675 pd=1.44 as=0.169 ps=1.82 w=0.65 l=0.15
X25 ua[0] single_9b_cdac_1.cdac_sw_9b_0.cdac_sw_3_7.tg_sw_3_3.SWN ua[0] VGND sky130_fd_pr__nfet_01v8 ad=0.145 pd=1.58 as=31.32 ps=341.28 w=0.5 l=0.5
X26 VDPWR single_9b_cdac_1.cdac_sw_9b_0.cdac_sw_3_6.nooverlap_clk_0.x10.A single_9b_cdac_1.cdac_sw_9b_0.cdac_sw_3_6.tg_sw_3_3.SWN VDPWR sky130_fd_pr__pfet_01v8 ad=0.168 pd=1.42 as=0.168 ps=1.42 w=1.12 l=0.15
X27 single_9b_cdac_1.cdac_sw_9b_0.cdac_sw_3_6.tg_sw_3_3.SWN single_9b_cdac_1.cdac_sw_9b_0.cdac_sw_3_6.nooverlap_clk_0.x10.A VGND VGND sky130_fd_pr__nfet_01v8_lvt ad=0.1036 pd=1.02 as=0.2109 ps=2.05 w=0.74 l=0.15
X28 VDPWR single_9b_cdac_0.cdac_sw_9b_0.cdac_sw_3_8.nooverlap_clk_0.x4.A single_9b_cdac_0.cdac_sw_9b_0.cdac_sw_3_8.nooverlap_clk_0.x6.A VDPWR sky130_fd_pr__pfet_01v8 ad=0.3864 pd=2.93 as=0.3304 ps=2.83 w=1.12 l=0.15
X29 VGND VDPWR VGND VGND sky130_fd_pr__nfet_01v8 ad=0.143 pd=1.62 as=296.81079 ps=2.85812k w=0.55 l=0.59
X30 a_38738_16877# single_9b_cdac_1.SW[5] VDPWR VDPWR sky130_fd_pr__pfet_01v8 ad=0.435 pd=3.58 as=0.435 ps=3.58 w=1.5 l=0.5
X31 th_dif_sw_0.VCN single_9b_cdac_0.cdac_sw_9b_0.S[2] sky130_fd_pr__cap_mim_m3_1 l=2 w=2
X32 a_54032_26990# single_9b_cdac_0.cdac_sw_9b_0.cdac_sw_3_0.nooverlap_clk_0.CLK0 single_9b_cdac_0.cdac_sw_9b_0.S[2] VGND sky130_fd_pr__nfet_01v8 ad=0.145 pd=1.58 as=0.145 ps=1.58 w=0.5 l=0.5
X33 VDPWR single_9b_cdac_1.cdac_sw_9b_0.cdac_sw_3_6.nooverlap_clk_0.sky130_fd_sc_hs__inv_8_0.A single_9b_cdac_1.cdac_sw_9b_0.cdac_sw_3_6.nooverlap_clk_0.CLKB0 VDPWR sky130_fd_pr__pfet_01v8 ad=0.3864 pd=2.93 as=0.168 ps=1.42 w=1.12 l=0.15
X34 single_9b_cdac_0.cdac_sw_9b_0.S[8] single_9b_cdac_0.cdac_sw_9b_0.cdac_sw_3_8.tg_sw_3_3.SWP single_9b_cdac_0.cdac_sw_9b_0.S[8] VDPWR sky130_fd_pr__pfet_01v8 ad=0.435 pd=3.58 as=6.96 ps=57.28 w=1.5 l=0.5
X35 a_9535_19962# a_9738_20240# VDPWR VDPWR sky130_fd_pr__pfet_01v8_hvt ad=0.0567 pd=0.69 as=0.1134 ps=1.38 w=0.42 l=0.15
X36 single_9b_cdac_1.cdac_sw_9b_0.cdac_sw_3_6.tg_sw_3_3.SWN single_9b_cdac_1.cdac_sw_9b_0.cdac_sw_3_6.nooverlap_clk_0.x10.A VDPWR VDPWR sky130_fd_pr__pfet_01v8 ad=0.168 pd=1.42 as=0.196 ps=1.47 w=1.12 l=0.15
X37 th_dif_sw_0.VCN single_9b_cdac_0.cdac_sw_9b_0.S[0] sky130_fd_pr__cap_mim_m3_1 l=2 w=2
X38 a_8653_27034# a_8435_27438# VDPWR VDPWR sky130_fd_pr__pfet_01v8_hvt ad=0.12915 pd=1.185 as=0.2184 ps=2.2 w=0.84 l=0.15
X39 VGND single_9b_cdac_0.cdac_sw_9b_0.cdac_sw_3_8.nooverlap_clk_0.CLKB0 single_9b_cdac_0.cdac_sw_9b_0.cdac_sw_3_8.nooverlap_clk_0.CLK0 VGND sky130_fd_pr__nfet_01v8_lvt ad=0.1036 pd=1.02 as=0.1036 ps=1.02 w=0.74 l=0.15
X40 single_9b_cdac_0.cdac_sw_9b_0.S[4] single_9b_cdac_0.cdac_sw_9b_0.cdac_sw_3_3.tg_sw_3_3.SWP ua[0] VGND sky130_fd_pr__nfet_01v8 ad=0.145 pd=1.58 as=0.145 ps=1.58 w=0.5 l=0.5
X41 a_40321_15495# single_9b_cdac_1.cdac_sw_9b_0.cdac_sw_3_5.nooverlap_clk_0.x3.Y VGND VGND sky130_fd_pr__nfet_01v8_lvt ad=0.0888 pd=0.98 as=0.2109 ps=2.05 w=0.74 l=0.15
X42 VDPWR single_9b_cdac_1.cdac_sw_9b_0.cdac_sw_3_4.nooverlap_clk_0.CLKB0 single_9b_cdac_1.cdac_sw_9b_0.cdac_sw_3_4.nooverlap_clk_0.CLK0 VDPWR sky130_fd_pr__pfet_01v8 ad=0.196 pd=1.47 as=0.168 ps=1.42 w=1.12 l=0.15
X43 VGND single_9b_cdac_1.cdac_sw_9b_0.cdac_sw_3_2.nooverlap_clk_0.x10.A single_9b_cdac_1.cdac_sw_9b_0.cdac_sw_3_2.tg_sw_3_3.SWN VGND sky130_fd_pr__nfet_01v8_lvt ad=0.2146 pd=2.06 as=0.1036 ps=1.02 w=0.74 l=0.15
X44 VDPWR a_6537_25670# a_6427_25794# VDPWR sky130_fd_pr__pfet_01v8_hvt ad=0.07035 pd=0.755 as=0.1155 ps=0.97 w=0.42 l=0.15
X45 VGND VDPWR VGND VGND sky130_fd_pr__nfet_01v8 ad=0.143 pd=1.62 as=0 ps=0 w=0.55 l=0.59
X46 VGND a_6315_21050# sar9b_0._01_ VGND sky130_fd_pr__nfet_01v8 ad=0.25837 pd=1.445 as=0.169 ps=1.82 w=0.65 l=0.15
X47 tdc_0.phase_detector_0.pd_out_0.A tdc_0.phase_detector_0.pd_out_0.B a_16970_11404# VGND sky130_fd_pr__nfet_01v8 ad=0.29 pd=2.58 as=0.145 ps=1.29 w=1 l=0.15
X48 VGND single_9b_cdac_0.cdac_sw_9b_0.cdac_sw_3_4.tg_sw_3_3.SWN single_9b_cdac_0.cdac_sw_9b_0.cdac_sw_3_4.tg_sw_3_3.SWP VGND sky130_fd_pr__nfet_01v8_lvt ad=0.1295 pd=1.09 as=0.1036 ps=1.02 w=0.74 l=0.15
X49 a_9552_23252# a_8637_23252# a_9205_23494# VGND sky130_fd_pr__special_nfet_01v8 ad=0.0711 pd=0.755 as=0.0999 ps=0.985 w=0.36 l=0.15
X50 a_10827_19822# a_10477_19450# a_10732_19810# VDPWR sky130_fd_pr__pfet_01v8_hvt ad=0.07245 pd=0.765 as=0.0651 ps=0.73 w=0.42 l=0.15
X51 single_9b_cdac_1.cdac_sw_9b_0.cdac_sw_3_6.nooverlap_clk_0.CLKB0 single_9b_cdac_1.cdac_sw_9b_0.cdac_sw_3_6.nooverlap_clk_0.sky130_fd_sc_hs__inv_8_0.A VDPWR VDPWR sky130_fd_pr__pfet_01v8 ad=0.168 pd=1.42 as=0.196 ps=1.47 w=1.12 l=0.15
X52 th_dif_sw_0.VCP single_9b_cdac_1.cdac_sw_9b_0.S[0] sky130_fd_pr__cap_mim_m3_1 l=2 w=2
X53 VGND sar9b_0.net9 a_10955_21076# VGND sky130_fd_pr__nfet_01v8 ad=0.0567 pd=0.69 as=0.1092 ps=1.36 w=0.42 l=0.15
X54 VDPWR a_11689_19142# a_11579_19266# VDPWR sky130_fd_pr__pfet_01v8_hvt ad=0.07035 pd=0.755 as=0.1155 ps=0.97 w=0.42 l=0.15
X55 VDPWR a_7735_17812# sar9b_0.net4 VDPWR sky130_fd_pr__pfet_01v8_hvt ad=0.26 pd=2.52 as=0.135 ps=1.27 w=1 l=0.15
X56 VDPWR single_9b_cdac_0.cdac_sw_9b_0.cdac_sw_3_8.nooverlap_clk_0.sky130_fd_sc_hs__inv_8_0.A single_9b_cdac_0.cdac_sw_9b_0.cdac_sw_3_8.nooverlap_clk_0.CLKB0 VDPWR sky130_fd_pr__pfet_01v8 ad=0.3304 pd=2.83 as=0.168 ps=1.42 w=1.12 l=0.15
X57 single_9b_cdac_0.cdac_sw_9b_0.S[8] single_9b_cdac_0.cdac_sw_9b_0.cdac_sw_3_8.tg_sw_3_3.SWN single_9b_cdac_0.cdac_sw_9b_0.S[8] VGND sky130_fd_pr__nfet_01v8 ad=0.145 pd=1.58 as=2.32 ps=25.28 w=0.5 l=0.5
X58 single_9b_cdac_1.cdac_sw_9b_0.cdac_sw_3_4.nooverlap_clk_0.CLK0 single_9b_cdac_1.cdac_sw_9b_0.cdac_sw_3_4.nooverlap_clk_0.CLKB0 VDPWR VDPWR sky130_fd_pr__pfet_01v8 ad=0.168 pd=1.42 as=0.168 ps=1.42 w=1.12 l=0.15
X59 VDPWR single_9b_cdac_0.cdac_sw_9b_0.cdac_sw_3_3.nooverlap_clk_0.x10.A single_9b_cdac_0.cdac_sw_9b_0.cdac_sw_3_3.tg_sw_3_3.SWN VDPWR sky130_fd_pr__pfet_01v8 ad=0.196 pd=1.47 as=0.168 ps=1.42 w=1.12 l=0.15
X60 VDPWR a_12427_17812# sar9b_0.net2 VDPWR sky130_fd_pr__pfet_01v8_hvt ad=0.26 pd=2.52 as=0.135 ps=1.27 w=1 l=0.15
X61 single_9b_cdac_1.cdac_sw_9b_0.S[3] single_9b_cdac_1.cdac_sw_9b_0.cdac_sw_3_4.tg_sw_3_3.SWP single_9b_cdac_1.cdac_sw_9b_0.S[3] VDPWR sky130_fd_pr__pfet_01v8 ad=0.435 pd=3.58 as=6.96 ps=57.28 w=1.5 l=0.5
X62 VDPWR a_7345_21594# sar9b_0.clknet_0_CLK VDPWR sky130_fd_pr__pfet_01v8_hvt ad=0.14 pd=1.28 as=0.14 ps=1.28 w=1 l=0.15
X63 VGND VDPWR VGND VGND sky130_fd_pr__nfet_01v8 ad=0.143 pd=1.62 as=0 ps=0 w=0.55 l=0.59
X64 th_dif_sw_0.VCN single_9b_cdac_0.cdac_sw_9b_0.S[0] sky130_fd_pr__cap_mim_m3_1 l=2 w=2
X65 ua[0] single_9b_cdac_1.cdac_sw_9b_0.cdac_sw_3_3.tg_sw_3_3.SWN ua[0] VGND sky130_fd_pr__nfet_01v8 ad=0.145 pd=1.58 as=0 ps=0 w=0.5 l=0.5
X66 VDPWR single_9b_cdac_1.cdac_sw_9b_0.cdac_sw_3_4.nooverlap_clk_0.CLKB0 single_9b_cdac_1.cdac_sw_9b_0.cdac_sw_3_4.nooverlap_clk_0.CLK0 VDPWR sky130_fd_pr__pfet_01v8 ad=0.168 pd=1.42 as=0.168 ps=1.42 w=1.12 l=0.15
X67 single_9b_cdac_0.cdac_sw_9b_0.cdac_sw_3_8.nooverlap_clk_0.CLKB0 single_9b_cdac_0.cdac_sw_9b_0.cdac_sw_3_8.nooverlap_clk_0.sky130_fd_sc_hs__inv_8_0.A VDPWR VDPWR sky130_fd_pr__pfet_01v8 ad=0.168 pd=1.42 as=0.196 ps=1.47 w=1.12 l=0.15
X68 single_9b_cdac_0.cdac_sw_9b_0.cdac_sw_3_3.tg_sw_3_3.SWN single_9b_cdac_0.cdac_sw_9b_0.cdac_sw_3_3.nooverlap_clk_0.x10.A VDPWR VDPWR sky130_fd_pr__pfet_01v8 ad=0.168 pd=1.42 as=0.3864 ps=2.93 w=1.12 l=0.15
X69 a_8803_19822# a_8287_19450# a_8708_19810# VGND sky130_fd_pr__special_nfet_01v8 ad=0.0594 pd=0.69 as=0.066 ps=0.745 w=0.36 l=0.15
X70 a_11501_19822# a_10311_19450# a_11392_19822# VGND sky130_fd_pr__special_nfet_01v8 ad=0.0669 pd=0.75 as=0.0711 ps=0.755 w=0.36 l=0.15
X71 VDPWR single_9b_cdac_1.cdac_sw_9b_0.cdac_sw_3_4.nooverlap_clk_0.x8.A single_9b_cdac_1.cdac_sw_9b_0.cdac_sw_3_4.nooverlap_clk_0.x10.A VDPWR sky130_fd_pr__pfet_01v8 ad=0.3304 pd=2.83 as=0.168 ps=1.42 w=1.12 l=0.15
X72 single_9b_cdac_0.cdac_sw_9b_0.cdac_sw_3_8.tg_sw_3_3.SWP single_9b_cdac_0.cdac_sw_9b_0.cdac_sw_3_8.tg_sw_3_3.SWN VDPWR VDPWR sky130_fd_pr__pfet_01v8 ad=0.168 pd=1.42 as=0.3864 ps=2.93 w=1.12 l=0.15
X73 ua[0] single_9b_cdac_0.cdac_sw_9b_0.cdac_sw_3_3.tg_sw_3_3.SWN ua[0] VGND sky130_fd_pr__nfet_01v8 ad=0.145 pd=1.58 as=0 ps=0 w=0.5 l=0.5
X74 VDPWR single_9b_cdac_0.cdac_sw_9b_0.cdac_sw_3_4.tg_sw_3_3.SWN single_9b_cdac_0.cdac_sw_9b_0.cdac_sw_3_4.tg_sw_3_3.SWP VDPWR sky130_fd_pr__pfet_01v8 ad=0.196 pd=1.47 as=0.168 ps=1.42 w=1.12 l=0.15
X75 VDPWR sar9b_0._15_ a_7735_21076# VDPWR sky130_fd_pr__pfet_01v8_hvt ad=0.14222 pd=1.335 as=0.06615 ps=0.735 w=0.42 l=0.15
X76 a_43540_16877# single_9b_cdac_1.SW[4] VDPWR VDPWR sky130_fd_pr__pfet_01v8 ad=0.435 pd=3.58 as=0.435 ps=3.58 w=1.5 l=0.5
X77 th_dif_sw_0.VCN single_9b_cdac_0.cdac_sw_9b_0.S[0] sky130_fd_pr__cap_mim_m3_1 l=2 w=2
X78 single_9b_cdac_0.SW[8] a_14451_27060# VDPWR VDPWR sky130_fd_pr__pfet_01v8_hvt ad=0.2054 pd=2.1 as=0.11455 ps=1.08 w=0.79 l=0.15
X79 a_11089_25250# a_11045_24858# a_10923_25262# VGND sky130_fd_pr__nfet_01v8 ad=0.0441 pd=0.63 as=0.1401 ps=1.1 w=0.42 l=0.15
X80 single_9b_cdac_1.cdac_sw_9b_0.cdac_sw_3_4.nooverlap_clk_0.CLK0 single_9b_cdac_1.cdac_sw_9b_0.cdac_sw_3_4.nooverlap_clk_0.CLKB0 VDPWR VDPWR sky130_fd_pr__pfet_01v8 ad=0.168 pd=1.42 as=0.196 ps=1.47 w=1.12 l=0.15
X81 a_13621_22406# a_13403_22164# VDPWR VDPWR sky130_fd_pr__pfet_01v8_hvt ad=0.12915 pd=1.185 as=0.2184 ps=2.2 w=0.84 l=0.15
X82 th_dif_sw_0.VCP single_9b_cdac_1.cdac_sw_9b_0.S[3] sky130_fd_pr__cap_mim_m3_1 l=2 w=2
X83 single_9b_cdac_1.cdac_sw_9b_0.cdac_sw_3_4.nooverlap_clk_0.x10.A single_9b_cdac_1.cdac_sw_9b_0.cdac_sw_3_4.nooverlap_clk_0.x8.A VDPWR VDPWR sky130_fd_pr__pfet_01v8 ad=0.168 pd=1.42 as=0.168 ps=1.42 w=1.12 l=0.15
X84 VGND single_9b_cdac_1.SW[1] a_58824_17740# VGND sky130_fd_pr__nfet_01v8 ad=0.145 pd=1.58 as=0.145 ps=1.58 w=0.5 l=0.5
X85 VGND single_9b_cdac_0.cdac_sw_9b_0.cdac_sw_3_0.nooverlap_clk_0.x1.A single_9b_cdac_0.cdac_sw_9b_0.cdac_sw_3_0.nooverlap_clk_0.sky130_fd_sc_hs__inv_8_0.A VGND sky130_fd_pr__nfet_01v8_lvt ad=0.2331 pd=2.11 as=0.1184 ps=1.06 w=0.74 l=0.15
X86 a_49221_26990# single_9b_cdac_0.cdac_sw_9b_0.cdac_sw_3_4.nooverlap_clk_0.CLK0 single_9b_cdac_0.cdac_sw_9b_0.S[3] VGND sky130_fd_pr__nfet_01v8 ad=0.145 pd=1.58 as=0.145 ps=1.58 w=0.5 l=0.5
X87 a_7325_26681# sar9b_0.net18 VGND VGND sky130_fd_pr__nfet_01v8 ad=0.1352 pd=1.56 as=0.0754 ps=0.81 w=0.52 l=0.15
X88 single_9b_cdac_0.cdac_sw_9b_0.cdac_sw_3_1.nooverlap_clk_0.CLKB0 single_9b_cdac_0.cdac_sw_9b_0.cdac_sw_3_1.nooverlap_clk_0.sky130_fd_sc_hs__inv_8_0.A VGND VGND sky130_fd_pr__nfet_01v8_lvt ad=0.1036 pd=1.02 as=0.1554 ps=1.16 w=0.74 l=0.15
X89 a_6226_23364# a_6058_23618# VGND VGND sky130_fd_pr__nfet_01v8 ad=0.0989 pd=0.995 as=0.12095 ps=1.085 w=0.64 l=0.15
X90 VDPWR VGND VDPWR VDPWR sky130_fd_pr__pfet_01v8_hvt ad=0.2262 pd=2.26 as=0 ps=0 w=0.87 l=0.59
X91 th_dif_sw_0.VCP single_9b_cdac_1.cdac_sw_9b_0.S[1] sky130_fd_pr__cap_mim_m3_1 l=2 w=2
X92 th_dif_sw_0.VCN single_9b_cdac_0.cdac_sw_9b_0.S[2] sky130_fd_pr__cap_mim_m3_1 l=2 w=2
X93 sar9b_0._00_ a_5884_21326# VDPWR VDPWR sky130_fd_pr__pfet_01v8_hvt ad=0.28 pd=2.56 as=0.3275 ps=1.655 w=1 l=0.15
X94 VGND VDPWR VGND VGND sky130_fd_pr__nfet_01v8 ad=0.143 pd=1.62 as=0 ps=0 w=0.55 l=0.59
X95 VDPWR single_9b_cdac_1.cdac_sw_9b_0.cdac_sw_3_4.nooverlap_clk_0.x8.A single_9b_cdac_1.cdac_sw_9b_0.cdac_sw_3_4.nooverlap_clk_0.x10.A VDPWR sky130_fd_pr__pfet_01v8 ad=0.168 pd=1.42 as=0.168 ps=1.42 w=1.12 l=0.15
X96 dw_12589_1395# a_10166_3438# sky130_fd_pr__cap_mim_m3_1 l=2 w=2
X97 VDPWR a_6226_23364# a_6153_23618# VDPWR sky130_fd_pr__pfet_01v8_hvt ad=0.17887 pd=1.26 as=0.07665 ps=0.785 w=0.42 l=0.15
X98 VGND single_9b_cdac_1.cdac_sw_9b_0.cdac_sw_3_7.nooverlap_clk_0.sky130_fd_sc_hs__inv_8_0.A single_9b_cdac_1.cdac_sw_9b_0.cdac_sw_3_7.nooverlap_clk_0.CLKB0 VGND sky130_fd_pr__nfet_01v8_lvt ad=0.2146 pd=2.06 as=0.1036 ps=1.02 w=0.74 l=0.15
X99 VDPWR single_9b_cdac_1.cdac_sw_9b_0.cdac_sw_3_0.nooverlap_clk_0.sky130_fd_sc_hs__inv_8_0.A single_9b_cdac_1.cdac_sw_9b_0.cdac_sw_3_0.nooverlap_clk_0.CLKB0 VDPWR sky130_fd_pr__pfet_01v8 ad=0.196 pd=1.47 as=0.168 ps=1.42 w=1.12 l=0.15
X100 th_dif_sw_0.VCN single_9b_cdac_0.cdac_sw_9b_0.S[0] sky130_fd_pr__cap_mim_m3_1 l=2 w=2
X101 VGND single_9b_cdac_0.cdac_sw_9b_0.cdac_sw_3_6.nooverlap_clk_0.x10.A single_9b_cdac_0.cdac_sw_9b_0.cdac_sw_3_6.tg_sw_3_3.SWN VGND sky130_fd_pr__nfet_01v8_lvt ad=0.2109 pd=2.05 as=0.1036 ps=1.02 w=0.74 l=0.15
X102 a_44418_26990# single_9b_cdac_0.cdac_sw_9b_0.cdac_sw_3_3.nooverlap_clk_0.CLK0 single_9b_cdac_0.cdac_sw_9b_0.S[4] VGND sky130_fd_pr__nfet_01v8 ad=0.145 pd=1.58 as=0.145 ps=1.58 w=0.5 l=0.5
X103 single_9b_cdac_1.cdac_sw_9b_0.cdac_sw_3_4.nooverlap_clk_0.x10.A single_9b_cdac_1.cdac_sw_9b_0.cdac_sw_3_4.nooverlap_clk_0.x8.A VDPWR VDPWR sky130_fd_pr__pfet_01v8 ad=0.168 pd=1.42 as=0.3304 ps=2.83 w=1.12 l=0.15
X104 th_dif_sw_0.VCP single_9b_cdac_1.cdac_sw_9b_0.S[1] sky130_fd_pr__cap_mim_m3_1 l=2 w=2
X105 VDPWR single_9b_cdac_0.cdac_sw_9b_0.cdac_sw_3_3.nooverlap_clk_0.CLKB0 single_9b_cdac_0.cdac_sw_9b_0.cdac_sw_3_3.nooverlap_clk_0.CLK0 VDPWR sky130_fd_pr__pfet_01v8 ad=0.196 pd=1.47 as=0.168 ps=1.42 w=1.12 l=0.15
X106 single_9b_cdac_0.cdac_sw_9b_0.cdac_sw_3_2.tg_sw_3_3.SWP single_9b_cdac_0.cdac_sw_9b_0.cdac_sw_3_2.tg_sw_3_3.SWN VGND VGND sky130_fd_pr__nfet_01v8_lvt ad=0.1036 pd=1.02 as=0.1295 ps=1.09 w=0.74 l=0.15
X107 single_9b_cdac_1.cdac_sw_9b_0.S[4] single_9b_cdac_1.cdac_sw_9b_0.cdac_sw_3_3.tg_sw_3_3.SWP ua[0] VGND sky130_fd_pr__nfet_01v8 ad=0.145 pd=1.58 as=0.145 ps=1.58 w=0.5 l=0.5
X108 single_9b_cdac_1.cdac_sw_9b_0.cdac_sw_3_0.nooverlap_clk_0.CLKB0 single_9b_cdac_1.cdac_sw_9b_0.cdac_sw_3_0.nooverlap_clk_0.sky130_fd_sc_hs__inv_8_0.A VDPWR VDPWR sky130_fd_pr__pfet_01v8 ad=0.168 pd=1.42 as=0.168 ps=1.42 w=1.12 l=0.15
X109 a_10211_20225# a_10055_20130# a_10356_20354# VDPWR sky130_fd_pr__pfet_01v8_hvt ad=0.07245 pd=0.765 as=0.1155 ps=0.97 w=0.42 l=0.15
X110 VGND a_6679_22316# sar9b_0._07_ VGND sky130_fd_pr__nfet_01v8 ad=0.10187 pd=0.99 as=0.17875 ps=1.85 w=0.65 l=0.15
X111 VDPWR single_9b_cdac_1.cdac_sw_9b_0.cdac_sw_3_5.nooverlap_clk_0.sky130_fd_sc_hs__inv_8_0.A single_9b_cdac_1.cdac_sw_9b_0.cdac_sw_3_5.nooverlap_clk_0.CLKB0 VDPWR sky130_fd_pr__pfet_01v8 ad=0.3864 pd=2.93 as=0.168 ps=1.42 w=1.12 l=0.15
X112 single_9b_cdac_0.cdac_sw_9b_0.cdac_sw_3_3.nooverlap_clk_0.CLK0 single_9b_cdac_0.cdac_sw_9b_0.cdac_sw_3_3.nooverlap_clk_0.CLKB0 VDPWR VDPWR sky130_fd_pr__pfet_01v8 ad=0.168 pd=1.42 as=0.168 ps=1.42 w=1.12 l=0.15
X113 VDPWR VGND VDPWR VDPWR sky130_fd_pr__pfet_01v8_hvt ad=0.2262 pd=2.26 as=0 ps=0 w=0.87 l=0.59
X114 VGND VDPWR VGND VGND sky130_fd_pr__nfet_01v8 ad=0.143 pd=1.62 as=0 ps=0 w=0.55 l=0.59
X115 VGND single_9b_cdac_1.cdac_sw_9b_0.cdac_sw_3_3.nooverlap_clk_0.x8.A single_9b_cdac_1.cdac_sw_9b_0.cdac_sw_3_3.nooverlap_clk_0.x10.A VGND sky130_fd_pr__nfet_01v8_lvt ad=0.2109 pd=2.05 as=0.1036 ps=1.02 w=0.74 l=0.15
X116 VDPWR single_9b_cdac_1.cdac_sw_9b_0.cdac_sw_3_0.nooverlap_clk_0.sky130_fd_sc_hs__inv_8_0.A single_9b_cdac_1.cdac_sw_9b_0.cdac_sw_3_0.nooverlap_clk_0.CLKB0 VDPWR sky130_fd_pr__pfet_01v8 ad=0.168 pd=1.42 as=0.168 ps=1.42 w=1.12 l=0.15
X117 sar9b_0.clknet_0_CLK a_7345_21594# VDPWR VDPWR sky130_fd_pr__pfet_01v8_hvt ad=0.14 pd=1.28 as=0.14 ps=1.28 w=1 l=0.15
X118 sar9b_0.clknet_1_0__leaf_CLK a_6701_20506# VGND VGND sky130_fd_pr__nfet_01v8 ad=0.0588 pd=0.7 as=0.05775 ps=0.695 w=0.42 l=0.15
X119 single_9b_cdac_1.cdac_sw_9b_0.cdac_sw_3_5.nooverlap_clk_0.CLKB0 single_9b_cdac_1.cdac_sw_9b_0.cdac_sw_3_5.nooverlap_clk_0.sky130_fd_sc_hs__inv_8_0.A VDPWR VDPWR sky130_fd_pr__pfet_01v8 ad=0.168 pd=1.42 as=0.196 ps=1.47 w=1.12 l=0.15
X120 th_dif_sw_0.th_sw_1.th_sw_main_0.VGS a_10254_2858# dw_12589_1395# dw_12589_1395# sky130_fd_pr__pfet_01v8 ad=0.58 pd=4.58 as=0.58 ps=4.58 w=2 l=0.15
X121 single_9b_cdac_0.cdac_sw_9b_0.S[4] single_9b_cdac_0.cdac_sw_9b_0.cdac_sw_3_3.tg_sw_3_3.SWN ua[0] VDPWR sky130_fd_pr__pfet_01v8 ad=0.435 pd=3.58 as=0.435 ps=3.58 w=1.5 l=0.5
X122 VDPWR sar9b_0.net4 a_8287_19450# VDPWR sky130_fd_pr__pfet_01v8_hvt ad=0.0864 pd=0.91 as=0.1664 ps=1.8 w=0.64 l=0.15
X123 th_dif_sw_0.VCN single_9b_cdac_0.cdac_sw_9b_0.S[0] sky130_fd_pr__cap_mim_m3_1 l=2 w=2
X124 a_26951_29911# single_9b_cdac_0.cdac_sw_9b_0.cdac_sw_3_8.nooverlap_clk_0.x8.A VGND VGND sky130_fd_pr__nfet_01v8_lvt ad=0.0888 pd=0.98 as=0.2109 ps=2.05 w=0.74 l=0.15
X125 VDPWR single_9b_cdac_0.cdac_sw_9b_0.cdac_sw_3_3.nooverlap_clk_0.CLKB0 single_9b_cdac_0.cdac_sw_9b_0.cdac_sw_3_3.nooverlap_clk_0.CLK0 VDPWR sky130_fd_pr__pfet_01v8 ad=0.168 pd=1.42 as=0.168 ps=1.42 w=1.12 l=0.15
X126 single_9b_cdac_1.cdac_sw_9b_0.cdac_sw_3_0.nooverlap_clk_0.CLKB0 single_9b_cdac_1.cdac_sw_9b_0.cdac_sw_3_0.nooverlap_clk_0.sky130_fd_sc_hs__inv_8_0.A VDPWR VDPWR sky130_fd_pr__pfet_01v8 ad=0.168 pd=1.42 as=0.196 ps=1.47 w=1.12 l=0.15
X127 single_9b_cdac_1.cdac_sw_9b_0.cdac_sw_3_8.nooverlap_clk_0.CLKB0 single_9b_cdac_1.cdac_sw_9b_0.cdac_sw_3_8.nooverlap_clk_0.sky130_fd_sc_hs__inv_8_0.A VDPWR VDPWR sky130_fd_pr__pfet_01v8 ad=0.168 pd=1.42 as=0.3304 ps=2.83 w=1.12 l=0.15
X128 VGND single_9b_cdac_1.cdac_sw_9b_0.cdac_sw_3_3.nooverlap_clk_0.x10.A single_9b_cdac_1.cdac_sw_9b_0.cdac_sw_3_3.tg_sw_3_3.SWN VGND sky130_fd_pr__nfet_01v8_lvt ad=0.1554 pd=1.16 as=0.1036 ps=1.02 w=0.74 l=0.15
X129 th_dif_sw_0.VCN single_9b_cdac_0.cdac_sw_9b_0.S[2] sky130_fd_pr__cap_mim_m3_1 l=2 w=2
X130 VDPWR VGND VDPWR VDPWR sky130_fd_pr__pfet_01v8_hvt ad=0.2262 pd=2.26 as=0 ps=0 w=0.87 l=0.59
X131 a_11392_19822# a_10311_19450# a_11045_19418# VDPWR sky130_fd_pr__pfet_01v8_hvt ad=0.0588 pd=0.7 as=0.12915 ps=1.185 w=0.42 l=0.15
X132 VDPWR single_9b_cdac_1.cdac_sw_9b_0.cdac_sw_3_5.tg_sw_3_3.SWN single_9b_cdac_1.cdac_sw_9b_0.cdac_sw_3_5.tg_sw_3_3.SWP VDPWR sky130_fd_pr__pfet_01v8 ad=0.196 pd=1.47 as=0.168 ps=1.42 w=1.12 l=0.15
X133 th_dif_sw_0.VCP single_9b_cdac_1.cdac_sw_9b_0.S[0] sky130_fd_pr__cap_mim_m3_1 l=2 w=2
X134 th_dif_sw_0.VCN single_9b_cdac_0.cdac_sw_9b_0.S[0] sky130_fd_pr__cap_mim_m3_1 l=2 w=2
X135 VGND VDPWR VGND VGND sky130_fd_pr__nfet_01v8 ad=0.143 pd=1.62 as=0 ps=0 w=0.55 l=0.59
X136 VGND single_9b_cdac_0.cdac_sw_9b_0.cdac_sw_3_3.nooverlap_clk_0.x1.A single_9b_cdac_0.cdac_sw_9b_0.cdac_sw_3_3.nooverlap_clk_0.sky130_fd_sc_hs__inv_8_0.A VGND sky130_fd_pr__nfet_01v8_lvt ad=0.2331 pd=2.11 as=0.1184 ps=1.06 w=0.74 l=0.15
X137 VDPWR VGND VDPWR VDPWR sky130_fd_pr__pfet_01v8_hvt ad=0.2262 pd=2.26 as=0 ps=0 w=0.87 l=0.59
X138 single_9b_cdac_1.cdac_sw_9b_0.cdac_sw_3_5.tg_sw_3_3.SWP single_9b_cdac_1.cdac_sw_9b_0.cdac_sw_3_5.tg_sw_3_3.SWN VDPWR VDPWR sky130_fd_pr__pfet_01v8 ad=0.168 pd=1.42 as=0.3304 ps=2.83 w=1.12 l=0.15
X139 th_dif_sw_0.VCP single_9b_cdac_1.cdac_sw_9b_0.S[1] sky130_fd_pr__cap_mim_m3_1 l=2 w=2
X140 th_dif_sw_0.VCN single_9b_cdac_0.cdac_sw_9b_0.S[2] sky130_fd_pr__cap_mim_m3_1 l=2 w=2
X141 VGND single_9b_cdac_1.SW[0] a_63626_17740# VGND sky130_fd_pr__nfet_01v8 ad=0.145 pd=1.58 as=0.145 ps=1.58 w=0.5 l=0.5
X142 a_9814_24340# sar9b_0.net15 VGND VGND sky130_fd_pr__nfet_01v8 ad=0.06405 pd=0.725 as=0.12495 ps=1.015 w=0.42 l=0.15
X143 VGND VDPWR VGND VGND sky130_fd_pr__nfet_01v8 ad=0.143 pd=1.62 as=0 ps=0 w=0.55 l=0.59
X144 th_dif_sw_0.VCP single_9b_cdac_1.cdac_sw_9b_0.S[0] sky130_fd_pr__cap_mim_m3_1 l=2 w=2
X145 th_dif_sw_0.VCN single_9b_cdac_0.cdac_sw_9b_0.S[0] sky130_fd_pr__cap_mim_m3_1 l=2 w=2
X146 single_9b_cdac_0.cdac_sw_9b_0.cdac_sw_3_7.nooverlap_clk_0.CLK0 single_9b_cdac_0.cdac_sw_9b_0.cdac_sw_3_7.nooverlap_clk_0.CLKB0 VGND VGND sky130_fd_pr__nfet_01v8_lvt ad=0.1036 pd=1.02 as=0.1295 ps=1.09 w=0.74 l=0.15
X147 th_dif_sw_0.VCP single_9b_cdac_1.cdac_sw_9b_0.S[1] sky130_fd_pr__cap_mim_m3_1 l=2 w=2
X148 a_9543_19748# sar9b_0.net15 VDPWR VDPWR sky130_fd_pr__pfet_01v8_hvt ad=0.0567 pd=0.69 as=0.0819 ps=0.81 w=0.42 l=0.15
X149 a_24332_16877# single_9b_cdac_1.SW[8] VDPWR VDPWR sky130_fd_pr__pfet_01v8 ad=0.435 pd=3.58 as=0.435 ps=3.58 w=1.5 l=0.5
X150 single_9b_cdac_0.cdac_sw_9b_0.S[3] single_9b_cdac_0.cdac_sw_9b_0.cdac_sw_3_4.tg_sw_3_3.SWP ua[0] VGND sky130_fd_pr__nfet_01v8 ad=0.145 pd=1.58 as=0.145 ps=1.58 w=0.5 l=0.5
X151 VDPWR single_9b_cdac_0.cdac_sw_9b_0.cdac_sw_3_8.nooverlap_clk_0.x6.A single_9b_cdac_0.cdac_sw_9b_0.cdac_sw_3_8.nooverlap_clk_0.x8.A VDPWR sky130_fd_pr__pfet_01v8 ad=0.3864 pd=2.93 as=0.3304 ps=2.83 w=1.12 l=0.15
X152 VDPWR a_13621_24858# a_13511_24884# VDPWR sky130_fd_pr__pfet_01v8_hvt ad=0.07035 pd=0.755 as=0.1155 ps=0.97 w=0.42 l=0.15
X153 a_13621_22682# a_13403_23086# VGND VGND sky130_fd_pr__nfet_01v8 ad=0.0999 pd=0.985 as=0.1346 ps=1.15 w=0.64 l=0.15
X154 th_dif_sw_0.VCN single_9b_cdac_0.cdac_sw_9b_0.S[1] sky130_fd_pr__cap_mim_m3_1 l=2 w=2
X155 th_dif_sw_0.VCN single_9b_cdac_0.cdac_sw_9b_0.S[0] sky130_fd_pr__cap_mim_m3_1 l=2 w=2
X156 VGND a_7345_21594# sar9b_0.clknet_0_CLK VGND sky130_fd_pr__nfet_01v8 ad=0.05775 pd=0.695 as=0.0588 ps=0.7 w=0.42 l=0.15
X157 th_dif_sw_0.VCP single_9b_cdac_1.cdac_sw_9b_0.S[1] sky130_fd_pr__cap_mim_m3_1 l=2 w=2
X158 VGND sar9b_0.net3 a_9893_26516# VGND sky130_fd_pr__nfet_01v8 ad=0.1346 pd=1.15 as=0.0441 ps=0.63 w=0.42 l=0.15
X159 single_9b_cdac_0.cdac_sw_9b_0.cdac_sw_3_5.nooverlap_clk_0.CLKB0 single_9b_cdac_0.cdac_sw_9b_0.cdac_sw_3_5.nooverlap_clk_0.sky130_fd_sc_hs__inv_8_0.A VGND VGND sky130_fd_pr__nfet_01v8_lvt ad=0.1036 pd=1.02 as=0.2146 ps=2.06 w=0.74 l=0.15
X160 a_11291_25428# a_10845_25428# a_11195_25428# VGND sky130_fd_pr__special_nfet_01v8 ad=0.1401 pd=1.1 as=0.0594 ps=0.69 w=0.36 l=0.15
X161 single_9b_cdac_1.cdac_sw_9b_0.S[5] single_9b_cdac_1.cdac_sw_9b_0.cdac_sw_3_5.tg_sw_3_3.SWN single_9b_cdac_1.cdac_sw_9b_0.S[5] VGND sky130_fd_pr__nfet_01v8 ad=0.145 pd=1.58 as=2.32 ps=25.28 w=0.5 l=0.5
X162 a_13621_26758# a_13403_26516# VGND VGND sky130_fd_pr__nfet_01v8 ad=0.0999 pd=0.985 as=0.1346 ps=1.15 w=0.64 l=0.15
X163 a_6610_22708# a_6171_22714# a_6525_22708# VGND sky130_fd_pr__special_nfet_01v8 ad=0.0621 pd=0.705 as=0.0813 ps=0.83 w=0.36 l=0.15
X164 a_11383_22164# a_10937_22164# a_11287_22164# VGND sky130_fd_pr__special_nfet_01v8 ad=0.1401 pd=1.1 as=0.0594 ps=0.69 w=0.36 l=0.15
X165 single_9b_cdac_1.cdac_sw_9b_0.cdac_sw_3_4.nooverlap_clk_0.x1.A single_9b_cdac_1.cdac_sw_9b_0.cdac_sw_3_4.nooverlap_clk_0.sky130_fd_sc_hs__inv_1_1.A VDPWR VDPWR sky130_fd_pr__pfet_01v8 ad=0.3304 pd=2.83 as=0.3864 ps=2.93 w=1.12 l=0.15
X166 a_6625_26516# a_5435_26516# a_6516_26516# VGND sky130_fd_pr__special_nfet_01v8 ad=0.0669 pd=0.75 as=0.0711 ps=0.755 w=0.36 l=0.15
X167 th_dif_sw_0.VCP single_9b_cdac_1.cdac_sw_9b_0.S[0] sky130_fd_pr__cap_mim_m3_1 l=2 w=2
X168 th_dif_sw_0.VCN single_9b_cdac_0.cdac_sw_9b_0.S[0] sky130_fd_pr__cap_mim_m3_1 l=2 w=2
X169 th_dif_sw_0.VCP single_9b_cdac_1.cdac_sw_9b_0.S[0] sky130_fd_pr__cap_mim_m3_1 l=2 w=2
X170 single_9b_cdac_0.cdac_sw_9b_0.cdac_sw_3_6.nooverlap_clk_0.CLK0 single_9b_cdac_0.cdac_sw_9b_0.cdac_sw_3_6.nooverlap_clk_0.CLKB0 VGND VGND sky130_fd_pr__nfet_01v8_lvt ad=0.1036 pd=1.02 as=0.2146 ps=2.06 w=0.74 l=0.15
X171 single_9b_cdac_0.SW[6] a_13899_25972# VGND VGND sky130_fd_pr__nfet_01v8 ad=0.1352 pd=1.56 as=0.0754 ps=0.81 w=0.52 l=0.15
X172 VDPWR VGND VDPWR VDPWR sky130_fd_pr__pfet_01v8_hvt ad=0.2262 pd=2.26 as=0 ps=0 w=0.87 l=0.59
X173 a_13308_23074# sar9b_0.net1 VGND VGND sky130_fd_pr__nfet_01v8 ad=0.066 pd=0.745 as=0.2205 ps=1.89 w=0.42 l=0.15
X174 th_dif_sw_0.VCP single_9b_cdac_1.cdac_sw_9b_0.S[0] sky130_fd_pr__cap_mim_m3_1 l=2 w=2
X175 a_11689_26758# a_11471_26516# VDPWR VDPWR sky130_fd_pr__pfet_01v8_hvt ad=0.12915 pd=1.185 as=0.2184 ps=2.2 w=0.84 l=0.15
X176 single_9b_cdac_0.cdac_sw_9b_0.S[5] single_9b_cdac_0.cdac_sw_9b_0.cdac_sw_3_5.tg_sw_3_3.SWP ua[0] VGND sky130_fd_pr__nfet_01v8 ad=0.145 pd=1.58 as=0.145 ps=1.58 w=0.5 l=0.5
X177 ua[0] single_9b_cdac_0.cdac_sw_9b_0.cdac_sw_3_4.tg_sw_3_3.SWN ua[0] VGND sky130_fd_pr__nfet_01v8 ad=0.145 pd=1.58 as=0 ps=0 w=0.5 l=0.5
X178 VGND a_9635_24314# a_9569_24340# VGND sky130_fd_pr__nfet_01v8 ad=0.12495 pd=1.015 as=0.0669 ps=0.75 w=0.42 l=0.15
X179 a_9021_19418# a_8803_19822# VGND VGND sky130_fd_pr__nfet_01v8 ad=0.0999 pd=0.985 as=0.1346 ps=1.15 w=0.64 l=0.15
X180 th_dif_sw_0.VCN single_9b_cdac_0.cdac_sw_9b_0.S[1] sky130_fd_pr__cap_mim_m3_1 l=2 w=2
X181 single_9b_cdac_1.cdac_sw_9b_0.cdac_sw_3_1.nooverlap_clk_0.x3.Y single_9b_cdac_1.CF[1] VGND VGND sky130_fd_pr__nfet_01v8_lvt ad=0.2109 pd=2.05 as=0.2627 ps=2.19 w=0.74 l=0.15
X182 single_9b_cdac_0.cdac_sw_9b_0.cdac_sw_3_2.tg_sw_3_3.SWN single_9b_cdac_0.cdac_sw_9b_0.cdac_sw_3_2.nooverlap_clk_0.x10.A VGND VGND sky130_fd_pr__nfet_01v8_lvt ad=0.1036 pd=1.02 as=0.1554 ps=1.16 w=0.74 l=0.15
X183 dw_17224_1400# a_21368_4076# sky130_fd_pr__cap_mim_m3_1 l=2 w=2
X184 th_dif_sw_0.VCP single_9b_cdac_1.cdac_sw_9b_0.S[1] sky130_fd_pr__cap_mim_m3_1 l=2 w=2
X185 VGND a_9132_7271# th_dif_sw_0.th_sw_1.CK VGND sky130_fd_pr__nfet_01v8_lvt ad=0.1036 pd=1.02 as=0.1036 ps=1.02 w=0.74 l=0.15
X186 VDPWR VGND VDPWR VDPWR sky130_fd_pr__pfet_01v8_hvt ad=0.2262 pd=2.26 as=0 ps=0 w=0.87 l=0.59
X187 a_14130_19266# a_13053_18900# a_13968_18900# VDPWR sky130_fd_pr__pfet_01v8_hvt ad=0.0567 pd=0.69 as=0.0588 ps=0.7 w=0.42 l=0.15
X188 VDPWR VGND VDPWR VDPWR sky130_fd_pr__pfet_01v8_hvt ad=0.2262 pd=2.26 as=0 ps=0 w=0.87 l=0.59
X189 VDPWR sar9b_0.clk_div_0.COUNT\[0\] a_7363_23502# VDPWR sky130_fd_pr__pfet_01v8_hvt ad=0.14 pd=1.28 as=0.1375 ps=1.275 w=1 l=0.15
X190 th_dif_sw_0.VCP single_9b_cdac_1.cdac_sw_9b_0.S[0] sky130_fd_pr__cap_mim_m3_1 l=2 w=2
X191 VGND single_9b_cdac_0.cdac_sw_9b_0.cdac_sw_3_6.nooverlap_clk_0.x10.A single_9b_cdac_0.cdac_sw_9b_0.cdac_sw_3_6.tg_sw_3_3.SWN VGND sky130_fd_pr__nfet_01v8_lvt ad=0.1036 pd=1.02 as=0.1036 ps=1.02 w=0.74 l=0.15
X192 single_9b_cdac_0.cdac_sw_9b_0.cdac_sw_3_0.tg_sw_3_3.SWN single_9b_cdac_0.cdac_sw_9b_0.cdac_sw_3_0.nooverlap_clk_0.x10.A VGND VGND sky130_fd_pr__nfet_01v8_lvt ad=0.1036 pd=1.02 as=0.1036 ps=1.02 w=0.74 l=0.15
X193 a_6249_19988# sar9b_0._01_ VGND VGND sky130_fd_pr__nfet_01v8 ad=0.066 pd=0.745 as=0.1092 ps=1.36 w=0.42 l=0.15
X194 VGND single_9b_cdac_0.cdac_sw_9b_0.cdac_sw_3_4.nooverlap_clk_0.sky130_fd_sc_hs__inv_8_0.A single_9b_cdac_0.cdac_sw_9b_0.cdac_sw_3_4.nooverlap_clk_0.CLKB0 VGND sky130_fd_pr__nfet_01v8_lvt ad=0.1295 pd=1.09 as=0.1036 ps=1.02 w=0.74 l=0.15
X195 a_9107_22682# a_8912_22824# a_9417_23074# VGND sky130_fd_pr__special_nfet_01v8 ad=0.0594 pd=0.69 as=0.1401 ps=1.1 w=0.36 l=0.15
X196 th_dif_sw_0.VCP single_9b_cdac_1.cdac_sw_9b_0.S[2] sky130_fd_pr__cap_mim_m3_1 l=2 w=2
X197 VDPWR single_9b_cdac_1.cdac_sw_9b_0.cdac_sw_3_4.nooverlap_clk_0.x10.A single_9b_cdac_1.cdac_sw_9b_0.cdac_sw_3_4.tg_sw_3_3.SWN VDPWR sky130_fd_pr__pfet_01v8 ad=0.196 pd=1.47 as=0.168 ps=1.42 w=1.12 l=0.15
X198 th_dif_sw_0.VCN single_9b_cdac_0.cdac_sw_9b_0.S[1] sky130_fd_pr__cap_mim_m3_1 l=2 w=2
X199 VDPWR single_9b_cdac_0.cdac_sw_9b_0.cdac_sw_3_1.nooverlap_clk_0.CLKB0 single_9b_cdac_0.cdac_sw_9b_0.cdac_sw_3_1.nooverlap_clk_0.CLK0 VDPWR sky130_fd_pr__pfet_01v8 ad=0.196 pd=1.47 as=0.168 ps=1.42 w=1.12 l=0.15
X200 VDPWR single_9b_cdac_0.cdac_sw_9b_0.cdac_sw_3_3.nooverlap_clk_0.sky130_fd_sc_hs__nand2_1_0.Y single_9b_cdac_0.cdac_sw_9b_0.cdac_sw_3_3.nooverlap_clk_0.sky130_fd_sc_hs__inv_1_1.A VDPWR sky130_fd_pr__pfet_01v8 ad=0.3864 pd=2.93 as=0.3304 ps=2.83 w=1.12 l=0.15
X201 VGND a_7035_22708# a_7203_22682# VGND sky130_fd_pr__nfet_01v8 ad=0.08775 pd=0.92 as=0.169 ps=1.82 w=0.65 l=0.15
X202 VGND sar9b_0.net6 a_12059_18362# VGND sky130_fd_pr__nfet_01v8 ad=0.0567 pd=0.69 as=0.1092 ps=1.36 w=0.42 l=0.15
X203 th_dif_sw_0.VCN single_9b_cdac_0.cdac_sw_9b_0.S[0] sky130_fd_pr__cap_mim_m3_1 l=2 w=2
X204 ua[0] single_9b_cdac_0.cdac_sw_9b_0.cdac_sw_3_0.tg_sw_3_3.SWP ua[0] VDPWR sky130_fd_pr__pfet_01v8 ad=0.435 pd=3.58 as=93.96 ps=773.28003 w=1.5 l=0.5
X205 VGND sar9b_0.net3 a_6859_21710# VGND sky130_fd_pr__nfet_01v8 ad=0.1092 pd=1.36 as=0.1092 ps=1.36 w=0.42 l=0.15
X206 th_dif_sw_0.VCP single_9b_cdac_1.cdac_sw_9b_0.S[1] sky130_fd_pr__cap_mim_m3_1 l=2 w=2
X207 VGND a_10211_20225# a_10142_20354# VGND sky130_fd_pr__nfet_01v8 ad=0.1346 pd=1.15 as=0.0999 ps=0.985 w=0.64 l=0.15
X208 th_dif_sw_0.VCN single_9b_cdac_0.cdac_sw_9b_0.S[0] sky130_fd_pr__cap_mim_m3_1 l=2 w=2
X209 single_9b_cdac_0.cdac_sw_9b_0.cdac_sw_3_1.nooverlap_clk_0.CLK0 single_9b_cdac_0.cdac_sw_9b_0.cdac_sw_3_1.nooverlap_clk_0.CLKB0 VDPWR VDPWR sky130_fd_pr__pfet_01v8 ad=0.168 pd=1.42 as=0.168 ps=1.42 w=1.12 l=0.15
X210 VDPWR VGND VDPWR VDPWR sky130_fd_pr__pfet_01v8_hvt ad=0.2262 pd=2.26 as=0 ps=0 w=0.87 l=0.59
X211 a_10371_21050# a_10196_21076# a_10550_21076# VGND sky130_fd_pr__nfet_01v8 ad=0.1092 pd=1.36 as=0.06405 ps=0.725 w=0.42 l=0.15
X212 single_9b_cdac_1.cdac_sw_9b_0.S[3] single_9b_cdac_1.cdac_sw_9b_0.cdac_sw_3_4.tg_sw_3_3.SWN single_9b_cdac_1.cdac_sw_9b_0.S[3] VGND sky130_fd_pr__nfet_01v8 ad=0.145 pd=1.58 as=2.32 ps=25.28 w=0.5 l=0.5
X213 VDPWR single_9b_cdac_0.cdac_sw_9b_0.cdac_sw_3_2.nooverlap_clk_0.x10.A single_9b_cdac_0.cdac_sw_9b_0.cdac_sw_3_2.tg_sw_3_3.SWN VDPWR sky130_fd_pr__pfet_01v8 ad=0.3304 pd=2.83 as=0.168 ps=1.42 w=1.12 l=0.15
X214 VDPWR single_9b_cdac_0.cdac_sw_9b_0.cdac_sw_3_1.nooverlap_clk_0.CLKB0 single_9b_cdac_0.cdac_sw_9b_0.cdac_sw_3_1.nooverlap_clk_0.CLK0 VDPWR sky130_fd_pr__pfet_01v8 ad=0.168 pd=1.42 as=0.168 ps=1.42 w=1.12 l=0.15
X215 single_9b_cdac_0.cdac_sw_9b_0.cdac_sw_3_2.tg_sw_3_3.SWN single_9b_cdac_0.cdac_sw_9b_0.cdac_sw_3_2.nooverlap_clk_0.x10.A VDPWR VDPWR sky130_fd_pr__pfet_01v8 ad=0.168 pd=1.42 as=0.196 ps=1.47 w=1.12 l=0.15
X216 single_9b_cdac_1.cdac_sw_9b_0.cdac_sw_3_4.nooverlap_clk_0.CLKB0 single_9b_cdac_1.cdac_sw_9b_0.cdac_sw_3_4.nooverlap_clk_0.sky130_fd_sc_hs__inv_8_0.A VGND VGND sky130_fd_pr__nfet_01v8_lvt ad=0.1036 pd=1.02 as=0.2109 ps=2.05 w=0.74 l=0.15
X217 a_8543_27060# sar9b_0.net3 VDPWR VDPWR sky130_fd_pr__pfet_01v8_hvt ad=0.1092 pd=1.36 as=0.07035 ps=0.755 w=0.42 l=0.15
X218 VDPWR single_9b_cdac_0.cdac_sw_9b_0.cdac_sw_3_2.nooverlap_clk_0.sky130_fd_sc_hs__inv_8_0.A single_9b_cdac_0.cdac_sw_9b_0.cdac_sw_3_2.nooverlap_clk_0.CLKB0 VDPWR sky130_fd_pr__pfet_01v8 ad=0.196 pd=1.47 as=0.168 ps=1.42 w=1.12 l=0.15
X219 single_9b_cdac_1.cdac_sw_9b_0.S[4] single_9b_cdac_1.cdac_sw_9b_0.cdac_sw_3_3.tg_sw_3_3.SWN single_9b_cdac_1.cdac_sw_9b_0.S[4] VGND sky130_fd_pr__nfet_01v8 ad=0.145 pd=1.58 as=2.32 ps=25.28 w=0.5 l=0.5
X220 th_dif_sw_0.VCP single_9b_cdac_1.cdac_sw_9b_0.S[1] sky130_fd_pr__cap_mim_m3_1 l=2 w=2
X221 th_dif_sw_0.VCN single_9b_cdac_0.cdac_sw_9b_0.S[3] sky130_fd_pr__cap_mim_m3_1 l=2 w=2
X222 single_9b_cdac_0.cdac_sw_9b_0.cdac_sw_3_7.nooverlap_clk_0.CLKB0 single_9b_cdac_0.cdac_sw_9b_0.cdac_sw_3_7.nooverlap_clk_0.sky130_fd_sc_hs__inv_8_0.A VGND VGND sky130_fd_pr__nfet_01v8_lvt ad=0.1036 pd=1.02 as=0.1554 ps=1.16 w=0.74 l=0.15
X223 a_13621_20230# a_13403_19988# VGND VGND sky130_fd_pr__nfet_01v8 ad=0.0999 pd=0.985 as=0.1346 ps=1.15 w=0.64 l=0.15
X224 VDPWR a_11045_19418# a_10935_19444# VDPWR sky130_fd_pr__pfet_01v8_hvt ad=0.07035 pd=0.755 as=0.1155 ps=0.97 w=0.42 l=0.15
X225 single_9b_cdac_0.cdac_sw_9b_0.cdac_sw_3_2.nooverlap_clk_0.CLKB0 single_9b_cdac_0.cdac_sw_9b_0.cdac_sw_3_2.nooverlap_clk_0.sky130_fd_sc_hs__inv_8_0.A VDPWR VDPWR sky130_fd_pr__pfet_01v8 ad=0.168 pd=1.42 as=0.3864 ps=2.93 w=1.12 l=0.15
X226 a_14143_26490# a_13968_26516# a_14322_26516# VGND sky130_fd_pr__nfet_01v8 ad=0.1092 pd=1.36 as=0.06405 ps=0.725 w=0.42 l=0.15
X227 th_dif_sw_0.VCP single_9b_cdac_1.cdac_sw_9b_0.S[0] sky130_fd_pr__cap_mim_m3_1 l=2 w=2
X228 single_9b_cdac_0.cdac_sw_9b_0.cdac_sw_3_3.nooverlap_clk_0.CLK0 single_9b_cdac_0.cdac_sw_9b_0.cdac_sw_3_3.nooverlap_clk_0.CLKB0 VDPWR VDPWR sky130_fd_pr__pfet_01v8 ad=0.168 pd=1.42 as=0.3864 ps=2.93 w=1.12 l=0.15
X229 a_12315_25972# a_11691_25978# a_12207_26350# VDPWR sky130_fd_pr__pfet_01v8_hvt ad=0.1155 pd=0.97 as=0.07245 ps=0.765 w=0.42 l=0.15
X230 th_dif_sw_0.VCP single_9b_cdac_1.cdac_sw_9b_0.S[2] sky130_fd_pr__cap_mim_m3_1 l=2 w=2
X231 VDPWR VGND VDPWR VDPWR sky130_fd_pr__pfet_01v8_hvt ad=0.2262 pd=2.26 as=0 ps=0 w=0.87 l=0.59
X232 single_9b_cdac_1.cdac_sw_9b_0.S[0] single_9b_cdac_1.cdac_sw_9b_0.cdac_sw_3_2.tg_sw_3_3.SWN ua[0] VDPWR sky130_fd_pr__pfet_01v8 ad=0.435 pd=3.58 as=0.435 ps=3.58 w=1.5 l=0.5
X233 single_9b_cdac_1.cdac_sw_9b_0.cdac_sw_3_0.nooverlap_clk_0.x6.A single_9b_cdac_1.cdac_sw_9b_0.cdac_sw_3_0.nooverlap_clk_0.x4.A VDPWR VDPWR sky130_fd_pr__pfet_01v8 ad=0.3304 pd=2.83 as=0.3864 ps=2.93 w=1.12 l=0.15
X234 VGND a_6149_23770# sar9b_0.clknet_1_1__leaf_CLK VGND sky130_fd_pr__nfet_01v8 ad=0.0588 pd=0.7 as=0.0588 ps=0.7 w=0.42 l=0.15
X235 th_dif_sw_0.VCP single_9b_cdac_1.cdac_sw_9b_0.S[0] sky130_fd_pr__cap_mim_m3_1 l=2 w=2
X236 a_5951_26516# a_5601_26516# a_5856_26516# VDPWR sky130_fd_pr__pfet_01v8_hvt ad=0.07245 pd=0.765 as=0.0651 ps=0.73 w=0.42 l=0.15
X237 th_dif_sw_0.VCP single_9b_cdac_1.cdac_sw_9b_0.S[0] sky130_fd_pr__cap_mim_m3_1 l=2 w=2
X238 a_9109_27438# a_7919_27066# a_9000_27438# VGND sky130_fd_pr__special_nfet_01v8 ad=0.0669 pd=0.75 as=0.0711 ps=0.755 w=0.36 l=0.15
X239 a_9809_27279# sar9b_0.net21 VGND VGND sky130_fd_pr__nfet_01v8 ad=0.1352 pd=1.56 as=0.0754 ps=0.81 w=0.52 l=0.15
X240 a_6901_22414# sar9b_0.clk_div_0.COUNT\[1\] a_6814_22414# VDPWR sky130_fd_pr__pfet_01v8_hvt ad=0.0441 pd=0.63 as=0.05985 ps=0.705 w=0.42 l=0.15
X241 th_dif_sw_0.VCN single_9b_cdac_0.cdac_sw_9b_0.S[1] sky130_fd_pr__cap_mim_m3_1 l=2 w=2
X242 VGND a_6778_22682# a_6736_23086# VGND sky130_fd_pr__nfet_01v8 ad=0.12095 pd=1.085 as=0.0696 ps=0.765 w=0.42 l=0.15
X243 a_6315_21050# a_6674_21050# a_6451_21326# VDPWR sky130_fd_pr__pfet_01v8_hvt ad=0.265 pd=2.53 as=0.135 ps=1.27 w=1 l=0.15
X244 a_5690_27192# a_5968_27176# a_5924_27060# VDPWR sky130_fd_pr__pfet_01v8_hvt ad=0.0588 pd=0.7 as=0.0567 ps=0.69 w=0.42 l=0.15
X245 single_9b_cdac_0.cdac_sw_9b_0.cdac_sw_3_7.tg_sw_3_3.SWP single_9b_cdac_0.cdac_sw_9b_0.cdac_sw_3_7.tg_sw_3_3.SWN VGND VGND sky130_fd_pr__nfet_01v8_lvt ad=0.1036 pd=1.02 as=0.1036 ps=1.02 w=0.74 l=0.15
X246 single_9b_cdac_0.cdac_sw_9b_0.S[5] single_9b_cdac_0.cdac_sw_9b_0.cdac_sw_3_5.nooverlap_clk_0.CLKB0 a_38738_26999# VDPWR sky130_fd_pr__pfet_01v8 ad=0.435 pd=3.58 as=0.435 ps=3.58 w=1.5 l=0.5
X247 VDPWR sar9b_0.net28 a_14175_24340# VDPWR sky130_fd_pr__pfet_01v8_hvt ad=0.11455 pd=1.08 as=0.2054 ps=2.1 w=0.79 l=0.15
X248 a_11392_19822# a_10477_19450# a_11045_19418# VGND sky130_fd_pr__special_nfet_01v8 ad=0.0711 pd=0.755 as=0.0999 ps=0.985 w=0.36 l=0.15
X249 single_9b_cdac_0.cdac_sw_9b_0.cdac_sw_3_3.tg_sw_3_3.SWN single_9b_cdac_0.cdac_sw_9b_0.cdac_sw_3_3.nooverlap_clk_0.x10.A VGND VGND sky130_fd_pr__nfet_01v8_lvt ad=0.1036 pd=1.02 as=0.2146 ps=2.06 w=0.74 l=0.15
X250 th_dif_sw_0.VCP single_9b_cdac_1.cdac_sw_9b_0.S[0] sky130_fd_pr__cap_mim_m3_1 l=2 w=2
X251 single_9b_cdac_0.cdac_sw_9b_0.S[8] single_9b_cdac_0.cdac_sw_9b_0.cdac_sw_3_8.tg_sw_3_3.SWN single_9b_cdac_0.cdac_sw_9b_0.S[8] VGND sky130_fd_pr__nfet_01v8 ad=0.145 pd=1.58 as=0 ps=0 w=0.5 l=0.5
X252 single_9b_cdac_1.cdac_sw_9b_0.cdac_sw_3_8.tg_sw_3_3.SWP single_9b_cdac_1.cdac_sw_9b_0.cdac_sw_3_8.tg_sw_3_3.SWN VGND VGND sky130_fd_pr__nfet_01v8_lvt ad=0.1036 pd=1.02 as=0.1295 ps=1.09 w=0.74 l=0.15
X253 VGND single_9b_cdac_0.cdac_sw_9b_0.cdac_sw_3_2.nooverlap_clk_0.sky130_fd_sc_hs__inv_1_1.A single_9b_cdac_0.cdac_sw_9b_0.cdac_sw_3_2.nooverlap_clk_0.x1.A VGND sky130_fd_pr__nfet_01v8_lvt ad=0.2627 pd=2.19 as=0.2109 ps=2.05 w=0.74 l=0.15
X254 a_6679_22316# a_7039_22138# a_6973_22414# VDPWR sky130_fd_pr__pfet_01v8_hvt ad=0.1092 pd=1.36 as=0.1215 ps=1.33 w=0.42 l=0.15
X255 single_9b_cdac_1.cdac_sw_9b_0.cdac_sw_3_4.tg_sw_3_3.SWN single_9b_cdac_1.cdac_sw_9b_0.cdac_sw_3_4.nooverlap_clk_0.x10.A VGND VGND sky130_fd_pr__nfet_01v8_lvt ad=0.1036 pd=1.02 as=0.1554 ps=1.16 w=0.74 l=0.15
X256 ua[0] single_9b_cdac_1.cdac_sw_9b_0.cdac_sw_3_1.tg_sw_3_3.SWP ua[0] VDPWR sky130_fd_pr__pfet_01v8 ad=0.435 pd=3.58 as=0 ps=0 w=1.5 l=0.5
X257 th_dif_sw_0.VCN single_9b_cdac_0.cdac_sw_9b_0.S[1] sky130_fd_pr__cap_mim_m3_1 l=2 w=2
X258 single_9b_cdac_0.cdac_sw_9b_0.cdac_sw_3_4.tg_sw_3_3.SWN single_9b_cdac_0.cdac_sw_9b_0.cdac_sw_3_4.nooverlap_clk_0.x10.A VDPWR VDPWR sky130_fd_pr__pfet_01v8 ad=0.168 pd=1.42 as=0.196 ps=1.47 w=1.12 l=0.15
X259 VGND sar9b_0.net16 a_5711_21076# VGND sky130_fd_pr__nfet_01v8 ad=0.08775 pd=0.92 as=0.169 ps=1.82 w=0.65 l=0.15
X260 VGND VDPWR VGND VGND sky130_fd_pr__nfet_01v8 ad=0.143 pd=1.62 as=0 ps=0 w=0.55 l=0.59
X261 VDPWR VGND VDPWR VDPWR sky130_fd_pr__pfet_01v8_hvt ad=0.2262 pd=2.26 as=0 ps=0 w=0.87 l=0.59
X262 th_dif_sw_0.VCP single_9b_cdac_1.cdac_sw_9b_0.S[0] sky130_fd_pr__cap_mim_m3_1 l=2 w=2
X263 th_dif_sw_0.VCN single_9b_cdac_0.cdac_sw_9b_0.S[0] sky130_fd_pr__cap_mim_m3_1 l=2 w=2
X264 VDPWR single_9b_cdac_0.cdac_sw_9b_0.cdac_sw_3_8.nooverlap_clk_0.x3.Y single_9b_cdac_0.cdac_sw_9b_0.cdac_sw_3_8.nooverlap_clk_0.x4.A VDPWR sky130_fd_pr__pfet_01v8 ad=0.3192 pd=2.81 as=0.168 ps=1.42 w=1.12 l=0.15
X265 VGND single_9b_cdac_0.SW[7] a_30012_26990# VGND sky130_fd_pr__nfet_01v8 ad=0.145 pd=1.58 as=0.145 ps=1.58 w=0.5 l=0.5
X266 a_9536_21076# sar9b_0.net8 VDPWR VDPWR sky130_fd_pr__pfet_01v8_hvt ad=0.0651 pd=0.73 as=0.1092 ps=1.36 w=0.42 l=0.15
X267 VDPWR a_6701_20506# sar9b_0.clknet_1_0__leaf_CLK VDPWR sky130_fd_pr__pfet_01v8_hvt ad=0.1375 pd=1.275 as=0.14 ps=1.28 w=1 l=0.15
X268 sar9b_0.net4 a_7735_17812# VGND VGND sky130_fd_pr__nfet_01v8 ad=0.0567 pd=0.69 as=0.06825 ps=0.745 w=0.42 l=0.15
X269 single_9b_cdac_1.cdac_sw_9b_0.cdac_sw_3_2.tg_sw_3_3.SWN single_9b_cdac_1.cdac_sw_9b_0.cdac_sw_3_2.nooverlap_clk_0.x10.A VDPWR VDPWR sky130_fd_pr__pfet_01v8 ad=0.168 pd=1.42 as=0.3304 ps=2.83 w=1.12 l=0.15
X270 a_58824_17740# single_9b_cdac_1.cdac_sw_9b_0.cdac_sw_3_1.nooverlap_clk_0.CLK0 single_9b_cdac_1.cdac_sw_9b_0.S[1] VGND sky130_fd_pr__nfet_01v8 ad=0.145 pd=1.58 as=0.145 ps=1.58 w=0.5 l=0.5
X271 VDPWR sar9b_0.clknet_0_CLK a_6701_20506# VDPWR sky130_fd_pr__pfet_01v8_hvt ad=0.14 pd=1.28 as=0.14 ps=1.28 w=1 l=0.15
X272 a_24332_16877# single_9b_cdac_1.SW[8] VDPWR VDPWR sky130_fd_pr__pfet_01v8 ad=0.435 pd=3.58 as=0.435 ps=3.58 w=1.5 l=0.5
X273 th_dif_sw_0.VCP single_9b_cdac_1.cdac_sw_9b_0.S[1] sky130_fd_pr__cap_mim_m3_1 l=2 w=2
X274 th_dif_sw_0.th_sw_1.CK a_9132_7271# VGND VGND sky130_fd_pr__nfet_01v8_lvt ad=0.1036 pd=1.02 as=0.1036 ps=1.02 w=0.74 l=0.15
X275 VGND single_9b_cdac_0.cdac_sw_9b_0.cdac_sw_3_4.nooverlap_clk_0.sky130_fd_sc_hs__inv_8_0.A single_9b_cdac_0.cdac_sw_9b_0.cdac_sw_3_4.nooverlap_clk_0.CLKB0 VGND sky130_fd_pr__nfet_01v8_lvt ad=0.2109 pd=2.05 as=0.1036 ps=1.02 w=0.74 l=0.15
X276 single_9b_cdac_0.cdac_sw_9b_0.cdac_sw_3_0.tg_sw_3_3.SWN single_9b_cdac_0.cdac_sw_9b_0.cdac_sw_3_0.nooverlap_clk_0.x10.A VGND VGND sky130_fd_pr__nfet_01v8_lvt ad=0.1036 pd=1.02 as=0.1295 ps=1.09 w=0.74 l=0.15
X277 sar9b_0.net13 a_11567_25188# VGND VGND sky130_fd_pr__nfet_01v8 ad=0.169 pd=1.82 as=0.2087 ps=2.02 w=0.65 l=0.15
X278 a_13968_18900# a_13053_18900# a_13621_19142# VGND sky130_fd_pr__special_nfet_01v8 ad=0.0711 pd=0.755 as=0.0999 ps=0.985 w=0.36 l=0.15
X279 dw_17224_1400# a_21368_4076# sky130_fd_pr__cap_mim_m3_1 l=2 w=2
X280 single_9b_cdac_0.cdac_sw_9b_0.cdac_sw_3_8.nooverlap_clk_0.x4.A single_9b_cdac_0.cdac_sw_9b_0.cdac_sw_3_8.nooverlap_clk_0.x1.A VDPWR VDPWR sky130_fd_pr__pfet_01v8 ad=0.168 pd=1.42 as=0.3192 ps=2.81 w=1.12 l=0.15
X281 a_13511_25794# sar9b_0.net15 VDPWR VDPWR sky130_fd_pr__pfet_01v8_hvt ad=0.1092 pd=1.36 as=0.07035 ps=0.755 w=0.42 l=0.15
X282 a_13403_25428# a_12887_25428# a_13308_25428# VGND sky130_fd_pr__special_nfet_01v8 ad=0.0594 pd=0.69 as=0.066 ps=0.745 w=0.36 l=0.15
X283 a_9038_22708# a_8951_22950# a_8634_22840# VDPWR sky130_fd_pr__pfet_01v8_hvt ad=0.12915 pd=1.185 as=0.0588 ps=0.7 w=0.42 l=0.15
X284 sar9b_0.net2 a_12427_17812# VGND VGND sky130_fd_pr__nfet_01v8 ad=0.0567 pd=0.69 as=0.06825 ps=0.745 w=0.42 l=0.15
X285 th_dif_sw_0.VCP single_9b_cdac_1.cdac_sw_9b_0.S[0] sky130_fd_pr__cap_mim_m3_1 l=2 w=2
X286 dw_17224_1400# a_21368_4076# sky130_fd_pr__cap_mim_m3_1 l=2 w=2
X287 th_dif_sw_0.VCN single_9b_cdac_0.cdac_sw_9b_0.S[2] sky130_fd_pr__cap_mim_m3_1 l=2 w=2
X288 VDPWR single_9b_cdac_0.cdac_sw_9b_0.cdac_sw_3_6.nooverlap_clk_0.x1.A single_9b_cdac_0.cdac_sw_9b_0.cdac_sw_3_6.nooverlap_clk_0.sky130_fd_sc_hs__inv_8_0.A VDPWR sky130_fd_pr__pfet_01v8 ad=0.3304 pd=2.83 as=0.168 ps=1.42 w=1.12 l=0.15
X289 VGND single_9b_cdac_0.cdac_sw_9b_0.cdac_sw_3_8.nooverlap_clk_0.CLKB0 single_9b_cdac_0.cdac_sw_9b_0.cdac_sw_3_8.nooverlap_clk_0.CLK0 VGND sky130_fd_pr__nfet_01v8_lvt ad=0.1554 pd=1.16 as=0.1036 ps=1.02 w=0.74 l=0.15
X290 a_49221_26990# single_9b_cdac_0.cdac_sw_9b_0.cdac_sw_3_4.nooverlap_clk_0.CLK0 single_9b_cdac_0.cdac_sw_9b_0.S[3] VGND sky130_fd_pr__nfet_01v8 ad=0.145 pd=1.58 as=0.145 ps=1.58 w=0.5 l=0.5
X291 single_9b_cdac_1.cdac_sw_9b_0.S[5] single_9b_cdac_1.cdac_sw_9b_0.cdac_sw_3_5.tg_sw_3_3.SWP single_9b_cdac_1.cdac_sw_9b_0.S[5] VDPWR sky130_fd_pr__pfet_01v8 ad=0.435 pd=3.58 as=6.96 ps=57.28 w=1.5 l=0.5
X292 ua[0] single_9b_cdac_0.cdac_sw_9b_0.cdac_sw_3_5.tg_sw_3_3.SWP ua[0] VDPWR sky130_fd_pr__pfet_01v8 ad=0.435 pd=3.58 as=0 ps=0 w=1.5 l=0.5
X293 sar9b_0.clknet_1_1__leaf_CLK a_6149_23770# VGND VGND sky130_fd_pr__nfet_01v8 ad=0.0588 pd=0.7 as=0.0588 ps=0.7 w=0.42 l=0.15
X294 sar9b_0.net43 a_12211_24100# VGND VGND sky130_fd_pr__nfet_01v8 ad=0.169 pd=1.82 as=0.2087 ps=2.02 w=0.65 l=0.15
X295 sar9b_0.net5 a_9543_19748# VDPWR VDPWR sky130_fd_pr__pfet_01v8_hvt ad=0.26 pd=2.52 as=0.3012 ps=2.66 w=1 l=0.15
X296 th_dif_sw_0.VCP single_9b_cdac_1.cdac_sw_9b_0.S[1] sky130_fd_pr__cap_mim_m3_1 l=2 w=2
X297 dw_17224_1400# a_21368_4076# sky130_fd_pr__cap_mim_m3_1 l=2 w=2
X298 th_dif_sw_0.VCP single_9b_cdac_1.cdac_sw_9b_0.S[0] sky130_fd_pr__cap_mim_m3_1 l=2 w=2
X299 th_dif_sw_0.th_sw_1.CK a_9132_7271# VGND VGND sky130_fd_pr__nfet_01v8_lvt ad=0.1036 pd=1.02 as=0.1036 ps=1.02 w=0.74 l=0.15
X300 a_14143_19962# a_13968_19988# a_14322_19988# VGND sky130_fd_pr__nfet_01v8 ad=0.1092 pd=1.36 as=0.06405 ps=0.725 w=0.42 l=0.15
X301 single_9b_cdac_1.cdac_sw_9b_0.cdac_sw_3_6.tg_sw_3_3.SWP single_9b_cdac_1.cdac_sw_9b_0.cdac_sw_3_6.tg_sw_3_3.SWN VGND VGND sky130_fd_pr__nfet_01v8_lvt ad=0.1036 pd=1.02 as=0.2109 ps=2.05 w=0.74 l=0.15
X302 VGND single_9b_cdac_1.cdac_sw_9b_0.cdac_sw_3_0.tg_sw_3_3.SWN single_9b_cdac_1.cdac_sw_9b_0.cdac_sw_3_0.tg_sw_3_3.SWP VGND sky130_fd_pr__nfet_01v8_lvt ad=0.1036 pd=1.02 as=0.1036 ps=1.02 w=0.74 l=0.15
X303 single_9b_cdac_1.cdac_sw_9b_0.S[8] single_9b_cdac_1.cdac_sw_9b_0.cdac_sw_3_8.tg_sw_3_3.SWN ua[0] VDPWR sky130_fd_pr__pfet_01v8 ad=0.435 pd=3.58 as=0.435 ps=3.58 w=1.5 l=0.5
X304 th_dif_sw_0.VCP single_9b_cdac_1.cdac_sw_9b_0.S[0] sky130_fd_pr__cap_mim_m3_1 l=2 w=2
X305 VDPWR single_9b_cdac_0.cdac_sw_9b_0.cdac_sw_3_7.nooverlap_clk_0.x10.A single_9b_cdac_0.cdac_sw_9b_0.cdac_sw_3_7.tg_sw_3_3.SWN VDPWR sky130_fd_pr__pfet_01v8 ad=0.196 pd=1.47 as=0.168 ps=1.42 w=1.12 l=0.15
X306 VGND VDPWR VGND VGND sky130_fd_pr__nfet_01v8 ad=0.143 pd=1.62 as=0 ps=0 w=0.55 l=0.59
X307 single_9b_cdac_0.cdac_sw_9b_0.S[4] single_9b_cdac_0.cdac_sw_9b_0.cdac_sw_3_3.tg_sw_3_3.SWN ua[0] VDPWR sky130_fd_pr__pfet_01v8 ad=0.435 pd=3.58 as=0.435 ps=3.58 w=1.5 l=0.5
X308 VDPWR single_9b_cdac_0.cdac_sw_9b_0.cdac_sw_3_1.nooverlap_clk_0.sky130_fd_sc_hs__nand2_1_0.Y single_9b_cdac_0.cdac_sw_9b_0.cdac_sw_3_1.nooverlap_clk_0.sky130_fd_sc_hs__inv_1_1.A VDPWR sky130_fd_pr__pfet_01v8 ad=0.3864 pd=2.93 as=0.3304 ps=2.83 w=1.12 l=0.15
X309 VDPWR a_11935_25402# a_11922_25794# VDPWR sky130_fd_pr__pfet_01v8_hvt ad=0.0819 pd=0.81 as=0.0567 ps=0.69 w=0.42 l=0.15
X310 VGND a_14051_24100# a_13985_24174# VGND sky130_fd_pr__nfet_01v8 ad=0.12495 pd=1.015 as=0.0669 ps=0.75 w=0.42 l=0.15
X311 th_dif_sw_0.VCP single_9b_cdac_1.cdac_sw_9b_0.S[0] sky130_fd_pr__cap_mim_m3_1 l=2 w=2
X312 VGND single_9b_cdac_1.cdac_sw_9b_0.cdac_sw_3_8.nooverlap_clk_0.x1.A single_9b_cdac_1.cdac_sw_9b_0.cdac_sw_3_8.nooverlap_clk_0.sky130_fd_sc_hs__inv_8_0.A VGND sky130_fd_pr__nfet_01v8_lvt ad=0.1221 pd=1.07 as=0.1184 ps=1.06 w=0.74 l=0.15
X313 VDPWR single_9b_cdac_0.cdac_sw_9b_0.cdac_sw_3_4.nooverlap_clk_0.CLKB0 single_9b_cdac_0.cdac_sw_9b_0.cdac_sw_3_4.nooverlap_clk_0.CLK0 VDPWR sky130_fd_pr__pfet_01v8 ad=0.3304 pd=2.83 as=0.168 ps=1.42 w=1.12 l=0.15
X314 single_9b_cdac_0.cdac_sw_9b_0.cdac_sw_3_7.tg_sw_3_3.SWN single_9b_cdac_0.cdac_sw_9b_0.cdac_sw_3_7.nooverlap_clk_0.x10.A VDPWR VDPWR sky130_fd_pr__pfet_01v8 ad=0.168 pd=1.42 as=0.3864 ps=2.93 w=1.12 l=0.15
X315 a_6843_20354# a_6061_19988# a_6759_20354# VDPWR sky130_fd_pr__pfet_01v8_hvt ad=0.09135 pd=0.855 as=0.0567 ps=0.69 w=0.42 l=0.15
X316 VGND single_9b_cdac_1.cdac_sw_9b_0.cdac_sw_3_4.nooverlap_clk_0.x8.A a_50962_15501# VGND sky130_fd_pr__nfet_01v8_lvt ad=0.2109 pd=2.05 as=0.0888 ps=0.98 w=0.74 l=0.15
X317 th_dif_sw_0.VCN single_9b_cdac_0.cdac_sw_9b_0.S[0] sky130_fd_pr__cap_mim_m3_1 l=2 w=2
X318 single_9b_cdac_0.cdac_sw_9b_0.cdac_sw_3_4.nooverlap_clk_0.CLK0 single_9b_cdac_0.cdac_sw_9b_0.cdac_sw_3_4.nooverlap_clk_0.CLKB0 VDPWR VDPWR sky130_fd_pr__pfet_01v8 ad=0.168 pd=1.42 as=0.196 ps=1.47 w=1.12 l=0.15
X319 single_9b_cdac_0.cdac_sw_9b_0.S[4] single_9b_cdac_0.cdac_sw_9b_0.cdac_sw_3_3.nooverlap_clk_0.CLKB0 a_43540_26999# VDPWR sky130_fd_pr__pfet_01v8 ad=0.435 pd=3.58 as=0.435 ps=3.58 w=1.5 l=0.5
X320 single_9b_cdac_1.cdac_sw_9b_0.S[7] single_9b_cdac_1.cdac_sw_9b_0.cdac_sw_3_7.tg_sw_3_3.SWN ua[0] VDPWR sky130_fd_pr__pfet_01v8 ad=0.435 pd=3.58 as=0.435 ps=3.58 w=1.5 l=0.5
X321 a_54032_17740# single_9b_cdac_1.cdac_sw_9b_0.cdac_sw_3_0.nooverlap_clk_0.CLK0 single_9b_cdac_1.cdac_sw_9b_0.S[2] VGND sky130_fd_pr__nfet_01v8 ad=0.145 pd=1.58 as=0.145 ps=1.58 w=0.5 l=0.5
X322 a_6516_26516# a_5435_26516# a_6169_26758# VDPWR sky130_fd_pr__pfet_01v8_hvt ad=0.0588 pd=0.7 as=0.12915 ps=1.185 w=0.42 l=0.15
X323 VDPWR single_9b_cdac_0.cdac_sw_9b_0.cdac_sw_3_3.nooverlap_clk_0.sky130_fd_sc_hs__inv_1_1.A single_9b_cdac_0.cdac_sw_9b_0.cdac_sw_3_3.nooverlap_clk_0.x1.A VDPWR sky130_fd_pr__pfet_01v8 ad=0.3864 pd=2.93 as=0.3304 ps=2.83 w=1.12 l=0.15
X324 single_9b_cdac_0.cdac_sw_9b_0.cdac_sw_3_1.tg_sw_3_3.SWP single_9b_cdac_0.cdac_sw_9b_0.cdac_sw_3_1.tg_sw_3_3.SWN VDPWR VDPWR sky130_fd_pr__pfet_01v8 ad=0.168 pd=1.42 as=0.196 ps=1.47 w=1.12 l=0.15
X325 th_dif_sw_0.VCN single_9b_cdac_0.cdac_sw_9b_0.S[0] sky130_fd_pr__cap_mim_m3_1 l=2 w=2
X326 a_7273_25946# a_7055_26350# VGND VGND sky130_fd_pr__nfet_01v8 ad=0.0999 pd=0.985 as=0.1346 ps=1.15 w=0.64 l=0.15
X327 single_9b_cdac_1.cdac_sw_9b_0.cdac_sw_3_8.nooverlap_clk_0.CLKB0 single_9b_cdac_1.cdac_sw_9b_0.cdac_sw_3_8.nooverlap_clk_0.sky130_fd_sc_hs__inv_8_0.A VGND VGND sky130_fd_pr__nfet_01v8_lvt ad=0.1036 pd=1.02 as=0.1036 ps=1.02 w=0.74 l=0.15
X328 single_9b_cdac_1.cdac_sw_9b_0.cdac_sw_3_1.nooverlap_clk_0.x4.A single_9b_cdac_1.cdac_sw_9b_0.cdac_sw_3_1.nooverlap_clk_0.x1.A a_59529_15495# VGND sky130_fd_pr__nfet_01v8_lvt ad=0.2109 pd=2.05 as=0.0888 ps=0.98 w=0.74 l=0.15
X329 a_6701_20506# sar9b_0.clknet_0_CLK VGND VGND sky130_fd_pr__nfet_01v8 ad=0.0588 pd=0.7 as=0.0588 ps=0.7 w=0.42 l=0.15
X330 VDPWR single_9b_cdac_1.cdac_sw_9b_0.cdac_sw_3_8.nooverlap_clk_0.x8.A single_9b_cdac_1.cdac_sw_9b_0.cdac_sw_3_8.nooverlap_clk_0.x10.A VDPWR sky130_fd_pr__pfet_01v8 ad=0.3304 pd=2.83 as=0.168 ps=1.42 w=1.12 l=0.15
X331 VDPWR single_9b_cdac_0.cdac_sw_9b_0.cdac_sw_3_8.tg_sw_3_3.SWN single_9b_cdac_0.cdac_sw_9b_0.cdac_sw_3_8.tg_sw_3_3.SWP VDPWR sky130_fd_pr__pfet_01v8 ad=0.196 pd=1.47 as=0.168 ps=1.42 w=1.12 l=0.15
X332 VGND VDPWR VGND VGND sky130_fd_pr__nfet_01v8 ad=0.143 pd=1.62 as=0 ps=0 w=0.55 l=0.59
X333 th_dif_sw_0.VCN single_9b_cdac_0.cdac_sw_9b_0.S[0] sky130_fd_pr__cap_mim_m3_1 l=2 w=2
X334 single_9b_cdac_1.cdac_sw_9b_0.cdac_sw_3_3.nooverlap_clk_0.x3.Y single_9b_cdac_1.CF[4] VDPWR VDPWR sky130_fd_pr__pfet_01v8 ad=0.3304 pd=2.83 as=0.3864 ps=2.93 w=1.12 l=0.15
X335 ua[0] single_9b_cdac_0.cdac_sw_9b_0.cdac_sw_3_0.tg_sw_3_3.SWP ua[0] VDPWR sky130_fd_pr__pfet_01v8 ad=0.435 pd=3.58 as=0 ps=0 w=1.5 l=0.5
X336 single_9b_cdac_0.cdac_sw_9b_0.S[3] single_9b_cdac_0.cdac_sw_9b_0.cdac_sw_3_4.tg_sw_3_3.SWN ua[0] VDPWR sky130_fd_pr__pfet_01v8 ad=0.435 pd=3.58 as=0.435 ps=3.58 w=1.5 l=0.5
X337 VDPWR VGND VDPWR VDPWR sky130_fd_pr__pfet_01v8_hvt ad=0.2262 pd=2.26 as=0 ps=0 w=0.87 l=0.59
X338 VDPWR a_7345_21594# sar9b_0.clknet_0_CLK VDPWR sky130_fd_pr__pfet_01v8_hvt ad=0.14 pd=1.28 as=0.14 ps=1.28 w=1 l=0.15
X339 single_9b_cdac_1.cdac_sw_9b_0.S[8] single_9b_cdac_1.cdac_sw_9b_0.cdac_sw_3_8.tg_sw_3_3.SWN single_9b_cdac_1.cdac_sw_9b_0.S[8] VGND sky130_fd_pr__nfet_01v8 ad=0.145 pd=1.58 as=2.32 ps=25.28 w=0.5 l=0.5
X340 single_9b_cdac_0.cdac_sw_9b_0.cdac_sw_3_1.nooverlap_clk_0.CLK0 single_9b_cdac_0.cdac_sw_9b_0.cdac_sw_3_1.nooverlap_clk_0.CLKB0 VDPWR VDPWR sky130_fd_pr__pfet_01v8 ad=0.168 pd=1.42 as=0.3864 ps=2.93 w=1.12 l=0.15
X341 VDPWR a_7345_21594# sar9b_0.clknet_0_CLK VDPWR sky130_fd_pr__pfet_01v8_hvt ad=0.14 pd=1.28 as=0.14 ps=1.28 w=1 l=0.15
X342 single_9b_cdac_1.cdac_sw_9b_0.cdac_sw_3_8.nooverlap_clk_0.x10.A single_9b_cdac_1.cdac_sw_9b_0.cdac_sw_3_8.nooverlap_clk_0.x8.A VDPWR VDPWR sky130_fd_pr__pfet_01v8 ad=0.168 pd=1.42 as=0.168 ps=1.42 w=1.12 l=0.15
X343 th_dif_sw_0.VCP single_9b_cdac_1.cdac_sw_9b_0.S[1] sky130_fd_pr__cap_mim_m3_1 l=2 w=2
X344 a_10827_23252# a_10477_23252# a_10732_23252# VDPWR sky130_fd_pr__pfet_01v8_hvt ad=0.07245 pd=0.765 as=0.0651 ps=0.73 w=0.42 l=0.15
X345 VDPWR single_9b_cdac_1.cdac_sw_9b_0.cdac_sw_3_3.nooverlap_clk_0.x10.A single_9b_cdac_1.cdac_sw_9b_0.cdac_sw_3_3.tg_sw_3_3.SWN VDPWR sky130_fd_pr__pfet_01v8 ad=0.3864 pd=2.93 as=0.168 ps=1.42 w=1.12 l=0.15
X346 ua[0] single_9b_cdac_1.cdac_sw_9b_0.cdac_sw_3_0.tg_sw_3_3.SWN ua[0] VGND sky130_fd_pr__nfet_01v8 ad=0.145 pd=1.58 as=0 ps=0 w=0.5 l=0.5
X347 th_dif_sw_0.VCP single_9b_cdac_1.cdac_sw_9b_0.S[2] sky130_fd_pr__cap_mim_m3_1 l=2 w=2
X348 VDPWR single_9b_cdac_0.cdac_sw_9b_0.cdac_sw_3_7.nooverlap_clk_0.CLKB0 single_9b_cdac_0.cdac_sw_9b_0.cdac_sw_3_7.nooverlap_clk_0.CLK0 VDPWR sky130_fd_pr__pfet_01v8 ad=0.196 pd=1.47 as=0.168 ps=1.42 w=1.12 l=0.15
X349 th_dif_sw_0.VCP single_9b_cdac_1.cdac_sw_9b_0.S[0] sky130_fd_pr__cap_mim_m3_1 l=2 w=2
X350 VGND VDPWR VGND VGND sky130_fd_pr__nfet_01v8 ad=0.143 pd=1.62 as=0 ps=0 w=0.55 l=0.59
X351 th_dif_sw_0.VCP single_9b_cdac_1.cdac_sw_9b_0.S[7] sky130_fd_pr__cap_mim_m3_1 l=2 w=2
X352 th_dif_sw_0.VCP single_9b_cdac_1.cdac_sw_9b_0.S[1] sky130_fd_pr__cap_mim_m3_1 l=2 w=2
X353 th_dif_sw_0.VCN single_9b_cdac_0.cdac_sw_9b_0.S[1] sky130_fd_pr__cap_mim_m3_1 l=2 w=2
X354 ua[0] single_9b_cdac_0.cdac_sw_9b_0.cdac_sw_3_0.tg_sw_3_3.SWN ua[0] VGND sky130_fd_pr__nfet_01v8 ad=0.145 pd=1.58 as=0 ps=0 w=0.5 l=0.5
X355 VGND sar9b_0.clknet_1_1__leaf_CLK a_5619_23252# VGND sky130_fd_pr__nfet_01v8 ad=0.0567 pd=0.69 as=0.1092 ps=1.36 w=0.42 l=0.15
X356 a_11376_21076# sar9b_0.net2 VGND VGND sky130_fd_pr__nfet_01v8 ad=0.066 pd=0.745 as=0.2205 ps=1.89 w=0.42 l=0.15
X357 VDPWR single_9b_cdac_1.cdac_sw_9b_0.cdac_sw_3_8.nooverlap_clk_0.x8.A single_9b_cdac_1.cdac_sw_9b_0.cdac_sw_3_8.nooverlap_clk_0.x10.A VDPWR sky130_fd_pr__pfet_01v8 ad=0.168 pd=1.42 as=0.168 ps=1.42 w=1.12 l=0.15
X358 ua[0] single_9b_cdac_0.cdac_sw_9b_0.cdac_sw_3_5.tg_sw_3_3.SWP ua[0] VDPWR sky130_fd_pr__pfet_01v8 ad=0.435 pd=3.58 as=0 ps=0 w=1.5 l=0.5
X359 VDPWR single_9b_cdac_0.cdac_sw_9b_0.cdac_sw_3_5.nooverlap_clk_0.x1.A single_9b_cdac_0.cdac_sw_9b_0.cdac_sw_3_5.nooverlap_clk_0.sky130_fd_sc_hs__inv_8_0.A VDPWR sky130_fd_pr__pfet_01v8 ad=0.3304 pd=2.83 as=0.168 ps=1.42 w=1.12 l=0.15
X360 single_9b_cdac_1.cdac_sw_9b_0.cdac_sw_3_3.tg_sw_3_3.SWN single_9b_cdac_1.cdac_sw_9b_0.cdac_sw_3_3.nooverlap_clk_0.x10.A VDPWR VDPWR sky130_fd_pr__pfet_01v8 ad=0.168 pd=1.42 as=0.196 ps=1.47 w=1.12 l=0.15
X361 a_21368_4076# th_dif_sw_0.th_sw_1.CK VGND VGND sky130_fd_pr__nfet_01v8 ad=0.58 pd=4.58 as=0.58 ps=4.58 w=2 l=0.15
X362 a_6516_26516# a_5601_26516# a_6169_26758# VGND sky130_fd_pr__special_nfet_01v8 ad=0.0711 pd=0.755 as=0.0999 ps=0.985 w=0.36 l=0.15
X363 single_9b_cdac_0.cdac_sw_9b_0.cdac_sw_3_7.nooverlap_clk_0.CLK0 single_9b_cdac_0.cdac_sw_9b_0.cdac_sw_3_7.nooverlap_clk_0.CLKB0 VDPWR VDPWR sky130_fd_pr__pfet_01v8 ad=0.168 pd=1.42 as=0.168 ps=1.42 w=1.12 l=0.15
X364 single_9b_cdac_0.cdac_sw_9b_0.S[3] single_9b_cdac_0.cdac_sw_9b_0.cdac_sw_3_4.nooverlap_clk_0.CLKB0 a_48343_26999# VDPWR sky130_fd_pr__pfet_01v8 ad=0.435 pd=3.58 as=0.435 ps=3.58 w=1.5 l=0.5
X365 VGND sar9b_0.net12 a_10311_23252# VGND sky130_fd_pr__nfet_01v8 ad=0.0567 pd=0.69 as=0.1092 ps=1.36 w=0.42 l=0.15
X366 single_9b_cdac_1.cdac_sw_9b_0.cdac_sw_3_6.nooverlap_clk_0.x6.A single_9b_cdac_1.cdac_sw_9b_0.cdac_sw_3_6.nooverlap_clk_0.x4.A VGND VGND sky130_fd_pr__nfet_01v8_lvt ad=0.2109 pd=2.05 as=0.2627 ps=2.19 w=0.74 l=0.15
X367 single_9b_cdac_1.cdac_sw_9b_0.S[4] single_9b_cdac_1.cdac_sw_9b_0.cdac_sw_3_3.tg_sw_3_3.SWP single_9b_cdac_1.cdac_sw_9b_0.S[4] VDPWR sky130_fd_pr__pfet_01v8 ad=0.435 pd=3.58 as=6.96 ps=57.28 w=1.5 l=0.5
X368 th_dif_sw_0.VCP single_9b_cdac_1.cdac_sw_9b_0.S[3] sky130_fd_pr__cap_mim_m3_1 l=2 w=2
X369 VDPWR single_9b_cdac_0.cdac_sw_9b_0.cdac_sw_3_6.nooverlap_clk_0.x10.A single_9b_cdac_0.cdac_sw_9b_0.cdac_sw_3_6.tg_sw_3_3.SWN VDPWR sky130_fd_pr__pfet_01v8 ad=0.3304 pd=2.83 as=0.168 ps=1.42 w=1.12 l=0.15
X370 ua[0] single_9b_cdac_0.cdac_sw_9b_0.cdac_sw_3_3.tg_sw_3_3.SWP ua[0] VDPWR sky130_fd_pr__pfet_01v8 ad=0.435 pd=3.58 as=0 ps=0 w=1.5 l=0.5
X371 VGND sar9b_0.net15 a_6587_21852# VGND sky130_fd_pr__nfet_01v8 ad=0.0567 pd=0.69 as=0.0567 ps=0.69 w=0.42 l=0.15
X372 single_9b_cdac_1.cdac_sw_9b_0.cdac_sw_3_8.nooverlap_clk_0.x10.A single_9b_cdac_1.cdac_sw_9b_0.cdac_sw_3_8.nooverlap_clk_0.x8.A VDPWR VDPWR sky130_fd_pr__pfet_01v8 ad=0.168 pd=1.42 as=0.3304 ps=2.83 w=1.12 l=0.15
X373 th_dif_sw_0.VCP single_9b_cdac_1.cdac_sw_9b_0.S[6] sky130_fd_pr__cap_mim_m3_1 l=2 w=2
X374 a_6319_25428# a_5803_25428# a_6224_25428# VGND sky130_fd_pr__special_nfet_01v8 ad=0.0594 pd=0.69 as=0.066 ps=0.745 w=0.36 l=0.15
X375 VDPWR single_9b_cdac_1.cdac_sw_9b_0.cdac_sw_3_6.nooverlap_clk_0.x8.A single_9b_cdac_1.cdac_sw_9b_0.cdac_sw_3_6.nooverlap_clk_0.sky130_fd_sc_hs__nand2_1_0.Y VDPWR sky130_fd_pr__pfet_01v8 ad=0.3192 pd=2.81 as=0.168 ps=1.42 w=1.12 l=0.15
X376 VDPWR single_9b_cdac_0.cdac_sw_9b_0.cdac_sw_3_7.nooverlap_clk_0.CLKB0 single_9b_cdac_0.cdac_sw_9b_0.cdac_sw_3_7.nooverlap_clk_0.CLK0 VDPWR sky130_fd_pr__pfet_01v8 ad=0.168 pd=1.42 as=0.168 ps=1.42 w=1.12 l=0.15
X377 a_13308_22164# sar9b_0.net1 VGND VGND sky130_fd_pr__nfet_01v8 ad=0.066 pd=0.745 as=0.2205 ps=1.89 w=0.42 l=0.15
X378 single_9b_cdac_1.cdac_sw_9b_0.cdac_sw_3_5.tg_sw_3_3.SWP single_9b_cdac_1.cdac_sw_9b_0.cdac_sw_3_5.tg_sw_3_3.SWN VGND VGND sky130_fd_pr__nfet_01v8_lvt ad=0.1036 pd=1.02 as=0.1295 ps=1.09 w=0.74 l=0.15
X379 a_49221_17740# single_9b_cdac_1.cdac_sw_9b_0.cdac_sw_3_4.nooverlap_clk_0.CLK0 single_9b_cdac_1.cdac_sw_9b_0.S[3] VGND sky130_fd_pr__nfet_01v8 ad=0.145 pd=1.58 as=0.145 ps=1.58 w=0.5 l=0.5
X380 VDPWR VGND VDPWR VDPWR sky130_fd_pr__pfet_01v8_hvt ad=0.2262 pd=2.26 as=0 ps=0 w=0.87 l=0.59
X381 single_9b_cdac_0.cdac_sw_9b_0.cdac_sw_3_6.tg_sw_3_3.SWN single_9b_cdac_0.cdac_sw_9b_0.cdac_sw_3_6.nooverlap_clk_0.x10.A VDPWR VDPWR sky130_fd_pr__pfet_01v8 ad=0.168 pd=1.42 as=0.196 ps=1.47 w=1.12 l=0.15
X382 sar9b_0._05_ a_7735_21076# VGND VGND sky130_fd_pr__nfet_01v8 ad=0.169 pd=1.82 as=0.13165 ps=1.14 w=0.65 l=0.15
X383 single_9b_cdac_1.cdac_sw_9b_0.cdac_sw_3_6.nooverlap_clk_0.sky130_fd_sc_hs__nand2_1_0.Y single_9b_cdac_1.CF[6] VDPWR VDPWR sky130_fd_pr__pfet_01v8 ad=0.168 pd=1.42 as=0.3192 ps=2.81 w=1.12 l=0.15
X384 VDPWR tdc_0.phase_detector_0.pd_out_0.B tdc_0.phase_detector_0.pd_out_0.A VDPWR sky130_fd_pr__pfet_01v8 ad=0.87 pd=6.58 as=0.435 ps=3.29 w=3 l=0.15
X385 th_dif_sw_0.VCN single_9b_cdac_0.cdac_sw_9b_0.S[0] sky130_fd_pr__cap_mim_m3_1 l=2 w=2
X386 VDPWR VGND VDPWR VDPWR sky130_fd_pr__pfet_01v8_hvt ad=0.2262 pd=2.26 as=0 ps=0 w=0.87 l=0.59
X387 a_11089_19810# a_11045_19418# a_10923_19822# VGND sky130_fd_pr__nfet_01v8 ad=0.0441 pd=0.63 as=0.1401 ps=1.1 w=0.42 l=0.15
X388 VDPWR a_6516_26516# a_6691_26490# VDPWR sky130_fd_pr__pfet_01v8_hvt ad=0.1134 pd=1.38 as=0.0567 ps=0.69 w=0.42 l=0.15
X389 VDPWR single_9b_cdac_1.cdac_sw_9b_0.cdac_sw_3_8.nooverlap_clk_0.CLKB0 single_9b_cdac_1.cdac_sw_9b_0.cdac_sw_3_8.nooverlap_clk_0.CLK0 VDPWR sky130_fd_pr__pfet_01v8 ad=0.196 pd=1.47 as=0.168 ps=1.42 w=1.12 l=0.15
X390 single_9b_cdac_1.cdac_sw_9b_0.S[8] single_9b_cdac_1.cdac_sw_9b_0.cdac_sw_3_8.tg_sw_3_3.SWP single_9b_cdac_1.cdac_sw_9b_0.S[8] VDPWR sky130_fd_pr__pfet_01v8 ad=0.435 pd=3.58 as=6.96 ps=57.28 w=1.5 l=0.5
X391 a_44418_17740# single_9b_cdac_1.cdac_sw_9b_0.cdac_sw_3_3.nooverlap_clk_0.CLK0 single_9b_cdac_1.cdac_sw_9b_0.S[4] VGND sky130_fd_pr__nfet_01v8 ad=0.145 pd=1.58 as=0.145 ps=1.58 w=0.5 l=0.5
X392 th_dif_sw_0.VCN single_9b_cdac_0.cdac_sw_9b_0.S[1] sky130_fd_pr__cap_mim_m3_1 l=2 w=2
X393 VGND single_9b_cdac_0.cdac_sw_9b_0.cdac_sw_3_4.nooverlap_clk_0.sky130_fd_sc_hs__inv_8_0.A single_9b_cdac_0.cdac_sw_9b_0.cdac_sw_3_4.nooverlap_clk_0.CLKB0 VGND sky130_fd_pr__nfet_01v8_lvt ad=0.1036 pd=1.02 as=0.1036 ps=1.02 w=0.74 l=0.15
X394 a_14322_21076# sar9b_0.net15 VGND VGND sky130_fd_pr__nfet_01v8 ad=0.06405 pd=0.725 as=0.12495 ps=1.015 w=0.42 l=0.15
X395 a_13968_22164# a_12887_22164# a_13621_22406# VDPWR sky130_fd_pr__pfet_01v8_hvt ad=0.0588 pd=0.7 as=0.12915 ps=1.185 w=0.42 l=0.15
X396 dw_17224_1400# a_21368_4076# sky130_fd_pr__cap_mim_m3_1 l=2 w=2
X397 th_dif_sw_0.VCN single_9b_cdac_0.cdac_sw_9b_0.S[1] sky130_fd_pr__cap_mim_m3_1 l=2 w=2
X398 VDPWR th_dif_sw_0.CKB a_21177_7457# VDPWR sky130_fd_pr__pfet_01v8 ad=0.3304 pd=2.83 as=0.168 ps=1.42 w=1.12 l=0.15
X399 th_dif_sw_0.VCN single_9b_cdac_0.cdac_sw_9b_0.S[0] sky130_fd_pr__cap_mim_m3_1 l=2 w=2
X400 sar9b_0.clknet_0_CLK a_7345_21594# VGND VGND sky130_fd_pr__nfet_01v8 ad=0.0588 pd=0.7 as=0.0588 ps=0.7 w=0.42 l=0.15
X401 VGND VDPWR VGND VGND sky130_fd_pr__nfet_01v8 ad=0.143 pd=1.62 as=0 ps=0 w=0.55 l=0.59
X402 single_9b_cdac_1.cdac_sw_9b_0.cdac_sw_3_8.nooverlap_clk_0.CLK0 single_9b_cdac_1.cdac_sw_9b_0.cdac_sw_3_8.nooverlap_clk_0.CLKB0 VDPWR VDPWR sky130_fd_pr__pfet_01v8 ad=0.168 pd=1.42 as=0.3304 ps=2.83 w=1.12 l=0.15
X403 single_9b_cdac_1.cdac_sw_9b_0.S[6] single_9b_cdac_1.cdac_sw_9b_0.cdac_sw_3_6.tg_sw_3_3.SWN ua[0] VDPWR sky130_fd_pr__pfet_01v8 ad=0.435 pd=3.58 as=0.435 ps=3.58 w=1.5 l=0.5
X404 VDPWR a_14143_25402# a_14130_25794# VDPWR sky130_fd_pr__pfet_01v8_hvt ad=0.0819 pd=0.81 as=0.0567 ps=0.69 w=0.42 l=0.15
X405 a_9132_7271# th_dif_sw_0.CK VDPWR VDPWR sky130_fd_pr__pfet_01v8 ad=0.168 pd=1.42 as=0.3304 ps=2.83 w=1.12 l=0.15
X406 a_16185_12837# tdc_0.phase_detector_0.pd_out_0.A VDPWR VDPWR sky130_fd_pr__pfet_01v8 ad=0.135 pd=1.27 as=0.295 ps=2.59 w=1 l=0.15
X407 a_11579_19266# a_10955_18900# a_11471_18900# VDPWR sky130_fd_pr__pfet_01v8_hvt ad=0.1155 pd=0.97 as=0.07245 ps=0.765 w=0.42 l=0.15
X408 single_9b_cdac_0.cdac_sw_9b_0.cdac_sw_3_6.nooverlap_clk_0.x10.A single_9b_cdac_0.cdac_sw_9b_0.cdac_sw_3_6.nooverlap_clk_0.x8.A VGND VGND sky130_fd_pr__nfet_01v8_lvt ad=0.1036 pd=1.02 as=0.2109 ps=2.05 w=0.74 l=0.15
X409 VGND single_9b_cdac_0.cdac_sw_9b_0.cdac_sw_3_0.nooverlap_clk_0.x8.A single_9b_cdac_0.cdac_sw_9b_0.cdac_sw_3_0.nooverlap_clk_0.x10.A VGND sky130_fd_pr__nfet_01v8_lvt ad=0.1221 pd=1.07 as=0.1036 ps=1.02 w=0.74 l=0.15
X410 a_7729_26350# a_6539_25978# a_7620_26350# VGND sky130_fd_pr__special_nfet_01v8 ad=0.0669 pd=0.75 as=0.0711 ps=0.755 w=0.36 l=0.15
X411 th_dif_sw_0.VCP single_9b_cdac_1.cdac_sw_9b_0.S[2] sky130_fd_pr__cap_mim_m3_1 l=2 w=2
X412 ua[0] single_9b_cdac_1.cdac_sw_9b_0.cdac_sw_3_1.tg_sw_3_3.SWP ua[0] VDPWR sky130_fd_pr__pfet_01v8 ad=0.435 pd=3.58 as=0 ps=0 w=1.5 l=0.5
X413 th_dif_sw_0.VCN single_9b_cdac_0.cdac_sw_9b_0.S[1] sky130_fd_pr__cap_mim_m3_1 l=2 w=2
X414 th_dif_sw_0.VCP single_9b_cdac_1.cdac_sw_9b_0.S[0] sky130_fd_pr__cap_mim_m3_1 l=2 w=2
X415 th_dif_sw_0.VCN single_9b_cdac_0.cdac_sw_9b_0.S[1] sky130_fd_pr__cap_mim_m3_1 l=2 w=2
X416 a_11471_26516# a_11121_26516# a_11376_26516# VDPWR sky130_fd_pr__pfet_01v8_hvt ad=0.07245 pd=0.765 as=0.0651 ps=0.73 w=0.42 l=0.15
X417 VGND single_9b_cdac_0.cdac_sw_9b_0.cdac_sw_3_6.nooverlap_clk_0.sky130_fd_sc_hs__inv_1_1.A single_9b_cdac_0.cdac_sw_9b_0.cdac_sw_3_6.nooverlap_clk_0.x1.A VGND sky130_fd_pr__nfet_01v8_lvt ad=0.2627 pd=2.19 as=0.2109 ps=2.05 w=0.74 l=0.15
X418 VGND single_9b_cdac_0.cdac_sw_9b_0.cdac_sw_3_1.nooverlap_clk_0.x10.A single_9b_cdac_0.cdac_sw_9b_0.cdac_sw_3_1.tg_sw_3_3.SWN VGND sky130_fd_pr__nfet_01v8_lvt ad=0.1295 pd=1.09 as=0.1036 ps=1.02 w=0.74 l=0.15
X419 VGND VDPWR VGND VGND sky130_fd_pr__nfet_01v8 ad=0.143 pd=1.62 as=0 ps=0 w=0.55 l=0.59
X420 a_53154_26999# single_9b_cdac_0.SW[2] VDPWR VDPWR sky130_fd_pr__pfet_01v8 ad=0.435 pd=3.58 as=0.435 ps=3.58 w=1.5 l=0.5
X421 VDPWR VGND VDPWR VDPWR sky130_fd_pr__pfet_01v8_hvt ad=0.2262 pd=2.26 as=0 ps=0 w=0.87 l=0.59
X422 th_dif_sw_0.VCP single_9b_cdac_1.cdac_sw_9b_0.S[4] sky130_fd_pr__cap_mim_m3_1 l=2 w=2
X423 th_dif_sw_0.VCP single_9b_cdac_1.cdac_sw_9b_0.S[1] sky130_fd_pr__cap_mim_m3_1 l=2 w=2
X424 VGND single_9b_cdac_1.cdac_sw_9b_0.cdac_sw_3_2.nooverlap_clk_0.x1.A single_9b_cdac_1.cdac_sw_9b_0.cdac_sw_3_2.nooverlap_clk_0.sky130_fd_sc_hs__inv_8_0.A VGND sky130_fd_pr__nfet_01v8_lvt ad=0.2109 pd=2.05 as=0.1036 ps=1.02 w=0.74 l=0.15
X425 VDPWR a_10637_27279# uo_out[4] VDPWR sky130_fd_pr__pfet_01v8_hvt ad=0.11455 pd=1.08 as=0.2054 ps=2.1 w=0.79 l=0.15
X426 ua[0] single_9b_cdac_0.cdac_sw_9b_0.cdac_sw_3_3.tg_sw_3_3.SWP ua[0] VDPWR sky130_fd_pr__pfet_01v8 ad=0.435 pd=3.58 as=0 ps=0 w=1.5 l=0.5
X427 VDPWR a_8431_22682# sar9b_0.net11 VDPWR sky130_fd_pr__pfet_01v8_hvt ad=0.3012 pd=2.66 as=0.26 ps=2.52 w=1 l=0.15
X428 VGND a_14143_21050# a_14077_21076# VGND sky130_fd_pr__nfet_01v8 ad=0.12495 pd=1.015 as=0.0669 ps=0.75 w=0.42 l=0.15
X429 VDPWR VGND VDPWR VDPWR sky130_fd_pr__pfet_01v8_hvt ad=0.2262 pd=2.26 as=0 ps=0 w=0.87 l=0.59
X430 a_11392_23252# a_10311_23252# a_11045_23494# VDPWR sky130_fd_pr__pfet_01v8_hvt ad=0.0588 pd=0.7 as=0.12915 ps=1.185 w=0.42 l=0.15
X431 VDPWR single_9b_cdac_1.cdac_sw_9b_0.cdac_sw_3_1.nooverlap_clk_0.x10.A single_9b_cdac_1.cdac_sw_9b_0.cdac_sw_3_1.tg_sw_3_3.SWN VDPWR sky130_fd_pr__pfet_01v8 ad=0.196 pd=1.47 as=0.168 ps=1.42 w=1.12 l=0.15
X432 VDPWR a_5343_25972# sar9b_0.net3 VDPWR sky130_fd_pr__pfet_01v8_hvt ad=0.14 pd=1.28 as=0.14 ps=1.28 w=1 l=0.15
X433 VGND VDPWR VGND VGND sky130_fd_pr__nfet_01v8 ad=0.143 pd=1.62 as=0 ps=0 w=0.55 l=0.59
X434 single_9b_cdac_1.cdac_sw_9b_0.S[5] single_9b_cdac_1.cdac_sw_9b_0.cdac_sw_3_5.tg_sw_3_3.SWP single_9b_cdac_1.cdac_sw_9b_0.S[5] VDPWR sky130_fd_pr__pfet_01v8 ad=0.435 pd=3.58 as=0 ps=0 w=1.5 l=0.5
X435 VDPWR single_9b_cdac_0.cdac_sw_9b_0.cdac_sw_3_1.nooverlap_clk_0.sky130_fd_sc_hs__inv_1_1.A single_9b_cdac_0.cdac_sw_9b_0.cdac_sw_3_1.nooverlap_clk_0.x1.A VDPWR sky130_fd_pr__pfet_01v8 ad=0.3864 pd=2.93 as=0.3304 ps=2.83 w=1.12 l=0.15
X436 a_30012_17740# single_9b_cdac_1.cdac_sw_9b_0.cdac_sw_3_7.nooverlap_clk_0.CLK0 single_9b_cdac_1.cdac_sw_9b_0.S[7] VGND sky130_fd_pr__nfet_01v8 ad=0.145 pd=1.58 as=0.145 ps=1.58 w=0.5 l=0.5
X437 single_9b_cdac_1.cdac_sw_9b_0.cdac_sw_3_6.tg_sw_3_3.SWN single_9b_cdac_1.cdac_sw_9b_0.cdac_sw_3_6.nooverlap_clk_0.x10.A VDPWR VDPWR sky130_fd_pr__pfet_01v8 ad=0.168 pd=1.42 as=0.3304 ps=2.83 w=1.12 l=0.15
X438 VDPWR single_9b_cdac_1.cdac_sw_9b_0.cdac_sw_3_5.nooverlap_clk_0.x8.A single_9b_cdac_1.cdac_sw_9b_0.cdac_sw_3_5.nooverlap_clk_0.sky130_fd_sc_hs__nand2_1_0.Y VDPWR sky130_fd_pr__pfet_01v8 ad=0.3192 pd=2.81 as=0.168 ps=1.42 w=1.12 l=0.15
X439 single_9b_cdac_1.cdac_sw_9b_0.cdac_sw_3_3.nooverlap_clk_0.x3.Y single_9b_cdac_1.CF[4] VGND VGND sky130_fd_pr__nfet_01v8_lvt ad=0.2109 pd=2.05 as=0.2627 ps=2.19 w=0.74 l=0.15
X440 th_dif_sw_0.VCP single_9b_cdac_1.cdac_sw_9b_0.S[0] sky130_fd_pr__cap_mim_m3_1 l=2 w=2
X441 VGND single_9b_cdac_1.cdac_sw_9b_0.cdac_sw_3_2.nooverlap_clk_0.sky130_fd_sc_hs__inv_8_0.A single_9b_cdac_1.cdac_sw_9b_0.cdac_sw_3_2.nooverlap_clk_0.CLKB0 VGND sky130_fd_pr__nfet_01v8_lvt ad=0.1554 pd=1.16 as=0.1036 ps=1.02 w=0.74 l=0.15
X442 single_9b_cdac_1.cdac_sw_9b_0.cdac_sw_3_1.tg_sw_3_3.SWN single_9b_cdac_1.cdac_sw_9b_0.cdac_sw_3_1.nooverlap_clk_0.x10.A VDPWR VDPWR sky130_fd_pr__pfet_01v8 ad=0.168 pd=1.42 as=0.168 ps=1.42 w=1.12 l=0.15
X443 a_9113_25946# a_8895_26350# VDPWR VDPWR sky130_fd_pr__pfet_01v8_hvt ad=0.12915 pd=1.185 as=0.2184 ps=2.2 w=0.84 l=0.15
X444 a_7233_21104# sar9b_0._07_ VGND VGND sky130_fd_pr__nfet_01v8 ad=0.0567 pd=0.69 as=0.1118 ps=1.04 w=0.42 l=0.15
X445 single_9b_cdac_0.cdac_sw_9b_0.cdac_sw_3_4.tg_sw_3_3.SWN single_9b_cdac_0.cdac_sw_9b_0.cdac_sw_3_4.nooverlap_clk_0.x10.A VGND VGND sky130_fd_pr__nfet_01v8_lvt ad=0.1036 pd=1.02 as=0.1036 ps=1.02 w=0.74 l=0.15
X446 VDPWR VGND VDPWR VDPWR sky130_fd_pr__pfet_01v8_hvt ad=0.2262 pd=2.26 as=0 ps=0 w=0.87 l=0.59
X447 VDPWR single_9b_cdac_0.cdac_sw_9b_0.cdac_sw_3_0.nooverlap_clk_0.sky130_fd_sc_hs__inv_8_0.A single_9b_cdac_0.cdac_sw_9b_0.cdac_sw_3_0.nooverlap_clk_0.CLKB0 VDPWR sky130_fd_pr__pfet_01v8 ad=0.3304 pd=2.83 as=0.168 ps=1.42 w=1.12 l=0.15
X448 single_9b_cdac_1.cdac_sw_9b_0.cdac_sw_3_5.nooverlap_clk_0.sky130_fd_sc_hs__nand2_1_0.Y single_9b_cdac_1.CF[5] VDPWR VDPWR sky130_fd_pr__pfet_01v8 ad=0.168 pd=1.42 as=0.3192 ps=2.81 w=1.12 l=0.15
X449 th_dif_sw_0.VCN single_9b_cdac_0.cdac_sw_9b_0.S[1] sky130_fd_pr__cap_mim_m3_1 l=2 w=2
X450 a_6705_25978# a_6539_25978# VGND VGND sky130_fd_pr__nfet_01v8 ad=0.1092 pd=1.36 as=0.0567 ps=0.69 w=0.42 l=0.15
X451 VGND a_7345_21594# sar9b_0.clknet_0_CLK VGND sky130_fd_pr__nfet_01v8 ad=0.0588 pd=0.7 as=0.0588 ps=0.7 w=0.42 l=0.15
X452 single_9b_cdac_1.cdac_sw_9b_0.cdac_sw_3_1.tg_sw_3_3.SWN single_9b_cdac_1.cdac_sw_9b_0.cdac_sw_3_1.nooverlap_clk_0.x10.A VGND VGND sky130_fd_pr__nfet_01v8_lvt ad=0.1036 pd=1.02 as=0.2109 ps=2.05 w=0.74 l=0.15
X453 VDPWR single_9b_cdac_1.cdac_sw_9b_0.cdac_sw_3_1.nooverlap_clk_0.x10.A single_9b_cdac_1.cdac_sw_9b_0.cdac_sw_3_1.tg_sw_3_3.SWN VDPWR sky130_fd_pr__pfet_01v8 ad=0.168 pd=1.42 as=0.168 ps=1.42 w=1.12 l=0.15
X454 single_9b_cdac_0.cdac_sw_9b_0.cdac_sw_3_0.nooverlap_clk_0.sky130_fd_sc_hs__nand2_1_0.Y single_9b_cdac_1.CF[2] a_55773_29911# VGND sky130_fd_pr__nfet_01v8_lvt ad=0.2109 pd=2.05 as=0.0888 ps=0.98 w=0.74 l=0.15
X455 single_9b_cdac_0.cdac_sw_9b_0.cdac_sw_3_0.nooverlap_clk_0.CLK0 single_9b_cdac_0.cdac_sw_9b_0.cdac_sw_3_0.nooverlap_clk_0.CLKB0 VGND VGND sky130_fd_pr__nfet_01v8_lvt ad=0.1036 pd=1.02 as=0.1036 ps=1.02 w=0.74 l=0.15
X456 th_dif_sw_0.VCN single_9b_cdac_0.cdac_sw_9b_0.S[0] sky130_fd_pr__cap_mim_m3_1 l=2 w=2
X457 single_9b_cdac_0.cdac_sw_9b_0.cdac_sw_3_0.nooverlap_clk_0.CLKB0 single_9b_cdac_0.cdac_sw_9b_0.cdac_sw_3_0.nooverlap_clk_0.sky130_fd_sc_hs__inv_8_0.A VDPWR VDPWR sky130_fd_pr__pfet_01v8 ad=0.168 pd=1.42 as=0.196 ps=1.47 w=1.12 l=0.15
X458 th_dif_sw_0.VCN single_9b_cdac_0.cdac_sw_9b_0.S[0] sky130_fd_pr__cap_mim_m3_1 l=2 w=2
X459 VDPWR single_9b_cdac_1.CF[4] single_9b_cdac_0.cdac_sw_9b_0.cdac_sw_3_3.nooverlap_clk_0.sky130_fd_sc_hs__nand2_1_0.Y VDPWR sky130_fd_pr__pfet_01v8 ad=0.3192 pd=2.81 as=0.168 ps=1.42 w=1.12 l=0.15
X460 VDPWR VGND VDPWR VDPWR sky130_fd_pr__pfet_01v8_hvt ad=0.2262 pd=2.26 as=0 ps=0 w=0.87 l=0.59
X461 VDPWR a_9078_20506# a_9005_20532# VDPWR sky130_fd_pr__pfet_01v8_hvt ad=0.17887 pd=1.26 as=0.07665 ps=0.785 w=0.42 l=0.15
X462 a_10356_20354# a_10142_20354# VDPWR VDPWR sky130_fd_pr__pfet_01v8_hvt ad=0.1155 pd=0.97 as=0.07035 ps=0.755 w=0.42 l=0.15
X463 ua[0] single_9b_cdac_1.cdac_sw_9b_0.cdac_sw_3_7.tg_sw_3_3.SWN ua[0] VGND sky130_fd_pr__nfet_01v8 ad=0.145 pd=1.58 as=0 ps=0 w=0.5 l=0.5
X464 single_9b_cdac_1.cdac_sw_9b_0.cdac_sw_3_1.tg_sw_3_3.SWN single_9b_cdac_1.cdac_sw_9b_0.cdac_sw_3_1.nooverlap_clk_0.x10.A VDPWR VDPWR sky130_fd_pr__pfet_01v8 ad=0.168 pd=1.42 as=0.196 ps=1.47 w=1.12 l=0.15
X465 VGND single_9b_cdac_0.cdac_sw_9b_0.cdac_sw_3_8.nooverlap_clk_0.x8.A single_9b_cdac_0.cdac_sw_9b_0.cdac_sw_3_8.nooverlap_clk_0.x10.A VGND sky130_fd_pr__nfet_01v8_lvt ad=0.2331 pd=2.11 as=0.1184 ps=1.06 w=0.74 l=0.15
X466 VDPWR single_9b_cdac_0.cdac_sw_9b_0.cdac_sw_3_7.nooverlap_clk_0.sky130_fd_sc_hs__nand2_1_0.Y single_9b_cdac_0.cdac_sw_9b_0.cdac_sw_3_7.nooverlap_clk_0.sky130_fd_sc_hs__inv_1_1.A VDPWR sky130_fd_pr__pfet_01v8 ad=0.3864 pd=2.93 as=0.3304 ps=2.83 w=1.12 l=0.15
X467 a_64331_15495# single_9b_cdac_1.cdac_sw_9b_0.cdac_sw_3_2.nooverlap_clk_0.x3.Y VGND VGND sky130_fd_pr__nfet_01v8_lvt ad=0.0888 pd=0.98 as=0.2109 ps=2.05 w=0.74 l=0.15
X468 ua[0] single_9b_cdac_0.cdac_sw_9b_0.cdac_sw_3_4.tg_sw_3_3.SWP ua[0] VDPWR sky130_fd_pr__pfet_01v8 ad=0.435 pd=3.58 as=0 ps=0 w=1.5 l=0.5
X469 VDPWR a_8951_22950# a_8912_22824# VDPWR sky130_fd_pr__pfet_01v8_hvt ad=0.0864 pd=0.91 as=0.1664 ps=1.8 w=0.64 l=0.15
X470 th_dif_sw_0.VCP single_9b_cdac_1.cdac_sw_9b_0.S[0] sky130_fd_pr__cap_mim_m3_1 l=2 w=2
X471 th_dif_sw_0.VCN single_9b_cdac_0.cdac_sw_9b_0.S[1] sky130_fd_pr__cap_mim_m3_1 l=2 w=2
X472 single_9b_cdac_0.cdac_sw_9b_0.cdac_sw_3_3.nooverlap_clk_0.sky130_fd_sc_hs__nand2_1_0.Y single_9b_cdac_0.cdac_sw_9b_0.cdac_sw_3_3.nooverlap_clk_0.x8.A VDPWR VDPWR sky130_fd_pr__pfet_01v8 ad=0.168 pd=1.42 as=0.3192 ps=2.81 w=1.12 l=0.15
X473 a_54032_26990# single_9b_cdac_0.cdac_sw_9b_0.cdac_sw_3_0.nooverlap_clk_0.CLK0 single_9b_cdac_0.cdac_sw_9b_0.S[2] VGND sky130_fd_pr__nfet_01v8 ad=0.145 pd=1.58 as=0.145 ps=1.58 w=0.5 l=0.5
X474 a_9354_27426# sar9b_0.net3 VGND VGND sky130_fd_pr__nfet_01v8 ad=0.06405 pd=0.725 as=0.12495 ps=1.015 w=0.42 l=0.15
X475 a_38738_26999# single_9b_cdac_0.SW[5] VDPWR VDPWR sky130_fd_pr__pfet_01v8 ad=0.435 pd=3.58 as=0.435 ps=3.58 w=1.5 l=0.5
X476 VDPWR single_9b_cdac_1.cdac_sw_9b_0.cdac_sw_3_8.nooverlap_clk_0.x10.A single_9b_cdac_1.cdac_sw_9b_0.cdac_sw_3_8.tg_sw_3_3.SWN VDPWR sky130_fd_pr__pfet_01v8 ad=0.196 pd=1.47 as=0.168 ps=1.42 w=1.12 l=0.15
X477 th_dif_sw_0.VCP single_9b_cdac_1.cdac_sw_9b_0.S[0] sky130_fd_pr__cap_mim_m3_1 l=2 w=2
X478 th_dif_sw_0.VCN single_9b_cdac_0.cdac_sw_9b_0.S[1] sky130_fd_pr__cap_mim_m3_1 l=2 w=2
X479 single_9b_cdac_0.cdac_sw_9b_0.S[4] single_9b_cdac_0.cdac_sw_9b_0.cdac_sw_3_3.tg_sw_3_3.SWP ua[0] VGND sky130_fd_pr__nfet_01v8 ad=0.145 pd=1.58 as=0.145 ps=1.58 w=0.5 l=0.5
X480 VGND VDPWR VGND VGND sky130_fd_pr__nfet_01v8 ad=0.143 pd=1.62 as=0 ps=0 w=0.55 l=0.59
X481 a_9157_26338# a_9113_25946# a_8991_26350# VGND sky130_fd_pr__nfet_01v8 ad=0.0441 pd=0.63 as=0.1401 ps=1.1 w=0.42 l=0.15
X482 th_dif_sw_0.VCN single_9b_cdac_0.cdac_sw_9b_0.S[0] sky130_fd_pr__cap_mim_m3_1 l=2 w=2
X483 a_9687_19042# sar9b_0.net5 VDPWR VDPWR sky130_fd_pr__pfet_01v8_hvt ad=0.1664 pd=1.8 as=0.0864 ps=0.91 w=0.64 l=0.15
X484 a_5965_27426# a_5487_27034# VGND VGND sky130_fd_pr__nfet_01v8 ad=0.0669 pd=0.75 as=0.12495 ps=1.015 w=0.42 l=0.15
X485 a_6973_22414# a_6943_22316# a_6901_22414# VDPWR sky130_fd_pr__pfet_01v8_hvt ad=0.1215 pd=1.33 as=0.0441 ps=0.63 w=0.42 l=0.15
X486 VGND sar9b_0.net15 a_9709_22164# VGND sky130_fd_pr__nfet_01v8 ad=0.1346 pd=1.15 as=0.0441 ps=0.63 w=0.42 l=0.15
X487 single_9b_cdac_0.cdac_sw_9b_0.S[8] single_9b_cdac_0.cdac_sw_9b_0.cdac_sw_3_8.tg_sw_3_3.SWN single_9b_cdac_0.cdac_sw_9b_0.S[8] VGND sky130_fd_pr__nfet_01v8 ad=0.145 pd=1.58 as=0 ps=0 w=0.5 l=0.5
X488 a_13511_24884# sar9b_0.net15 VDPWR VDPWR sky130_fd_pr__pfet_01v8_hvt ad=0.1092 pd=1.36 as=0.07035 ps=0.755 w=0.42 l=0.15
X489 th_dif_sw_0.VCP single_9b_cdac_1.cdac_sw_9b_0.S[2] sky130_fd_pr__cap_mim_m3_1 l=2 w=2
X490 VGND VDPWR VGND VGND sky130_fd_pr__nfet_01v8 ad=0.143 pd=1.62 as=0 ps=0 w=0.55 l=0.59
X491 single_9b_cdac_1.cdac_sw_9b_0.cdac_sw_3_6.tg_sw_3_3.SWP single_9b_cdac_1.cdac_sw_9b_0.cdac_sw_3_6.tg_sw_3_3.SWN VGND VGND sky130_fd_pr__nfet_01v8_lvt ad=0.1036 pd=1.02 as=0.1036 ps=1.02 w=0.74 l=0.15
X492 VGND single_9b_cdac_1.cdac_sw_9b_0.cdac_sw_3_0.tg_sw_3_3.SWN single_9b_cdac_1.cdac_sw_9b_0.cdac_sw_3_0.tg_sw_3_3.SWP VGND sky130_fd_pr__nfet_01v8_lvt ad=0.1295 pd=1.09 as=0.1036 ps=1.02 w=0.74 l=0.15
X493 th_dif_sw_0.VCN single_9b_cdac_0.cdac_sw_9b_0.S[3] sky130_fd_pr__cap_mim_m3_1 l=2 w=2
X494 single_9b_cdac_0.cdac_sw_9b_0.cdac_sw_3_7.nooverlap_clk_0.CLK0 single_9b_cdac_0.cdac_sw_9b_0.cdac_sw_3_7.nooverlap_clk_0.CLKB0 VDPWR VDPWR sky130_fd_pr__pfet_01v8 ad=0.168 pd=1.42 as=0.3864 ps=2.93 w=1.12 l=0.15
X495 VDPWR sar9b_0.net8 a_12887_22164# VDPWR sky130_fd_pr__pfet_01v8_hvt ad=0.0864 pd=0.91 as=0.1664 ps=1.8 w=0.64 l=0.15
X496 ua[0] single_9b_cdac_1.cdac_sw_9b_0.cdac_sw_3_5.tg_sw_3_3.SWP ua[0] VDPWR sky130_fd_pr__pfet_01v8 ad=0.435 pd=3.58 as=0 ps=0 w=1.5 l=0.5
X497 a_8435_27438# a_8085_27066# a_8340_27426# VDPWR sky130_fd_pr__pfet_01v8_hvt ad=0.07245 pd=0.765 as=0.0651 ps=0.73 w=0.42 l=0.15
X498 single_9b_cdac_0.cdac_sw_9b_0.S[3] single_9b_cdac_0.cdac_sw_9b_0.cdac_sw_3_4.nooverlap_clk_0.CLKB0 a_48343_26999# VDPWR sky130_fd_pr__pfet_01v8 ad=0.435 pd=3.58 as=0.435 ps=3.58 w=1.5 l=0.5
X499 VDPWR sar9b_0.net26 a_13623_24340# VDPWR sky130_fd_pr__pfet_01v8_hvt ad=0.11455 pd=1.08 as=0.2054 ps=2.1 w=0.79 l=0.15
X500 VDPWR sar9b_0._12_ sar9b_0._15_ VDPWR sky130_fd_pr__pfet_01v8_hvt ad=0.26 pd=2.52 as=0.135 ps=1.27 w=1 l=0.15
X501 single_9b_cdac_1.cdac_sw_9b_0.S[4] single_9b_cdac_1.cdac_sw_9b_0.cdac_sw_3_3.tg_sw_3_3.SWP single_9b_cdac_1.cdac_sw_9b_0.S[4] VDPWR sky130_fd_pr__pfet_01v8 ad=0.435 pd=3.58 as=0 ps=0 w=1.5 l=0.5
X502 single_9b_cdac_1.cdac_sw_9b_0.cdac_sw_3_4.nooverlap_clk_0.CLK0 single_9b_cdac_1.cdac_sw_9b_0.cdac_sw_3_4.nooverlap_clk_0.CLKB0 VGND VGND sky130_fd_pr__nfet_01v8_lvt ad=0.1036 pd=1.02 as=0.2109 ps=2.05 w=0.74 l=0.15
X503 a_12036_26516# a_10955_26516# a_11689_26758# VDPWR sky130_fd_pr__pfet_01v8_hvt ad=0.0588 pd=0.7 as=0.12915 ps=1.185 w=0.42 l=0.15
X504 th_dif_sw_0.VCP single_9b_cdac_1.cdac_sw_9b_0.S[0] sky130_fd_pr__cap_mim_m3_1 l=2 w=2
X505 a_13968_23086# a_12887_22714# a_13621_22682# VDPWR sky130_fd_pr__pfet_01v8_hvt ad=0.0588 pd=0.7 as=0.12915 ps=1.185 w=0.42 l=0.15
X506 a_13621_26758# a_13403_26516# VDPWR VDPWR sky130_fd_pr__pfet_01v8_hvt ad=0.12915 pd=1.185 as=0.2184 ps=2.2 w=0.84 l=0.15
X507 VDPWR VGND VDPWR VDPWR sky130_fd_pr__pfet_01v8_hvt ad=0.2262 pd=2.26 as=0 ps=0 w=0.87 l=0.59
X508 VGND VDPWR VGND VGND sky130_fd_pr__nfet_01v8 ad=0.143 pd=1.62 as=0 ps=0 w=0.55 l=0.59
X509 dw_17224_1400# a_21368_4076# sky130_fd_pr__cap_mim_m3_1 l=2 w=2
X510 single_9b_cdac_0.cdac_sw_9b_0.cdac_sw_3_3.nooverlap_clk_0.sky130_fd_sc_hs__nand2_1_0.Y single_9b_cdac_1.CF[4] a_46159_29911# VGND sky130_fd_pr__nfet_01v8_lvt ad=0.2109 pd=2.05 as=0.0888 ps=0.98 w=0.74 l=0.15
X511 a_49221_26990# single_9b_cdac_0.cdac_sw_9b_0.cdac_sw_3_4.nooverlap_clk_0.CLK0 single_9b_cdac_0.cdac_sw_9b_0.S[3] VGND sky130_fd_pr__nfet_01v8 ad=0.145 pd=1.58 as=0.145 ps=1.58 w=0.5 l=0.5
X512 VGND sar9b_0.net9 a_12887_22714# VGND sky130_fd_pr__nfet_01v8 ad=0.0567 pd=0.69 as=0.1092 ps=1.36 w=0.42 l=0.15
X513 a_13857_27279# sar9b_0.net25 VDPWR VDPWR sky130_fd_pr__pfet_01v8_hvt ad=0.2054 pd=2.1 as=0.11455 ps=1.08 w=0.79 l=0.15
X514 single_9b_cdac_0.cdac_sw_9b_0.cdac_sw_3_3.nooverlap_clk_0.CLK0 single_9b_cdac_0.cdac_sw_9b_0.cdac_sw_3_3.nooverlap_clk_0.CLKB0 VGND VGND sky130_fd_pr__nfet_01v8_lvt ad=0.1036 pd=1.02 as=0.1036 ps=1.02 w=0.74 l=0.15
X515 VDPWR single_9b_cdac_0.cdac_sw_9b_0.cdac_sw_3_3.nooverlap_clk_0.CLKB0 single_9b_cdac_0.cdac_sw_9b_0.cdac_sw_3_3.nooverlap_clk_0.CLK0 VDPWR sky130_fd_pr__pfet_01v8 ad=0.196 pd=1.47 as=0.168 ps=1.42 w=1.12 l=0.15
X516 VGND single_9b_cdac_0.cdac_sw_9b_0.cdac_sw_3_1.nooverlap_clk_0.x10.A single_9b_cdac_0.cdac_sw_9b_0.cdac_sw_3_1.tg_sw_3_3.SWN VGND sky130_fd_pr__nfet_01v8_lvt ad=0.2109 pd=2.05 as=0.1036 ps=1.02 w=0.74 l=0.15
X517 VDPWR sar9b_0.net43 a_13071_21620# VDPWR sky130_fd_pr__pfet_01v8_hvt ad=0.11455 pd=1.08 as=0.2054 ps=2.1 w=0.79 l=0.15
X518 a_12480_18722# sar9b_0.net2 VGND VGND sky130_fd_pr__nfet_01v8 ad=0.066 pd=0.745 as=0.2205 ps=1.89 w=0.42 l=0.15
X519 VDPWR single_9b_cdac_1.cdac_sw_9b_0.cdac_sw_3_3.nooverlap_clk_0.x1.A single_9b_cdac_1.cdac_sw_9b_0.cdac_sw_3_3.nooverlap_clk_0.sky130_fd_sc_hs__inv_8_0.A VDPWR sky130_fd_pr__pfet_01v8 ad=0.3304 pd=2.83 as=0.168 ps=1.42 w=1.12 l=0.15
X520 single_9b_cdac_1.cdac_sw_9b_0.cdac_sw_3_0.nooverlap_clk_0.CLKB0 single_9b_cdac_1.cdac_sw_9b_0.cdac_sw_3_0.nooverlap_clk_0.sky130_fd_sc_hs__inv_8_0.A VDPWR VDPWR sky130_fd_pr__pfet_01v8 ad=0.168 pd=1.42 as=0.3304 ps=2.83 w=1.12 l=0.15
X521 single_9b_cdac_1.cdac_sw_9b_0.cdac_sw_3_8.nooverlap_clk_0.sky130_fd_sc_hs__inv_8_0.A single_9b_cdac_1.cdac_sw_9b_0.cdac_sw_3_8.nooverlap_clk_0.x1.A VGND VGND sky130_fd_pr__nfet_01v8_lvt ad=0.1036 pd=1.02 as=0.1221 ps=1.07 w=0.74 l=0.15
X522 th_dif_sw_0.VCN single_9b_cdac_0.cdac_sw_9b_0.S[0] sky130_fd_pr__cap_mim_m3_1 l=2 w=2
X523 a_8895_24340# a_8545_24340# a_8800_24340# VDPWR sky130_fd_pr__pfet_01v8_hvt ad=0.07245 pd=0.765 as=0.0651 ps=0.73 w=0.42 l=0.15
X524 a_7813_22316# sar9b_0._12_ a_7976_22414# VDPWR sky130_fd_pr__pfet_01v8_hvt ad=0.1092 pd=1.36 as=0.0441 ps=0.63 w=0.42 l=0.15
X525 VGND VDPWR VGND VGND sky130_fd_pr__nfet_01v8 ad=0.143 pd=1.62 as=0 ps=0 w=0.55 l=0.59
X526 a_12425_25946# a_12207_26350# VDPWR VDPWR sky130_fd_pr__pfet_01v8_hvt ad=0.12915 pd=1.185 as=0.2184 ps=2.2 w=0.84 l=0.15
X527 single_9b_cdac_1.cdac_sw_9b_0.cdac_sw_3_3.nooverlap_clk_0.sky130_fd_sc_hs__inv_8_0.A single_9b_cdac_1.cdac_sw_9b_0.cdac_sw_3_3.nooverlap_clk_0.x1.A VDPWR VDPWR sky130_fd_pr__pfet_01v8 ad=0.168 pd=1.42 as=0.168 ps=1.42 w=1.12 l=0.15
X528 th_dif_sw_0.VCP single_9b_cdac_1.cdac_sw_9b_0.S[0] sky130_fd_pr__cap_mim_m3_1 l=2 w=2
X529 th_dif_sw_0.VCP single_9b_cdac_1.cdac_sw_9b_0.S[1] sky130_fd_pr__cap_mim_m3_1 l=2 w=2
X530 VDPWR single_9b_cdac_1.cdac_sw_9b_0.cdac_sw_3_2.nooverlap_clk_0.sky130_fd_sc_hs__inv_8_0.A single_9b_cdac_1.cdac_sw_9b_0.cdac_sw_3_2.nooverlap_clk_0.CLKB0 VDPWR sky130_fd_pr__pfet_01v8 ad=0.3864 pd=2.93 as=0.168 ps=1.42 w=1.12 l=0.15
X531 VDPWR sar9b_0.FINAL a_10955_26516# VDPWR sky130_fd_pr__pfet_01v8_hvt ad=0.0864 pd=0.91 as=0.1664 ps=1.8 w=0.64 l=0.15
X532 single_9b_cdac_0.cdac_sw_9b_0.cdac_sw_3_8.nooverlap_clk_0.CLK0 single_9b_cdac_0.cdac_sw_9b_0.cdac_sw_3_8.nooverlap_clk_0.CLKB0 VGND VGND sky130_fd_pr__nfet_01v8_lvt ad=0.1036 pd=1.02 as=0.1554 ps=1.16 w=0.74 l=0.15
X533 a_44418_26990# single_9b_cdac_0.cdac_sw_9b_0.cdac_sw_3_3.nooverlap_clk_0.CLK0 single_9b_cdac_0.cdac_sw_9b_0.S[4] VGND sky130_fd_pr__nfet_01v8 ad=0.145 pd=1.58 as=0.145 ps=1.58 w=0.5 l=0.5
X534 VGND single_9b_cdac_0.SW[4] a_44418_26990# VGND sky130_fd_pr__nfet_01v8 ad=0.145 pd=1.58 as=0.145 ps=1.58 w=0.5 l=0.5
X535 single_9b_cdac_1.cdac_sw_9b_0.S[4] single_9b_cdac_1.cdac_sw_9b_0.cdac_sw_3_3.tg_sw_3_3.SWP ua[0] VGND sky130_fd_pr__nfet_01v8 ad=0.145 pd=1.58 as=0.145 ps=1.58 w=0.5 l=0.5
X536 th_dif_sw_0.VCP single_9b_cdac_1.cdac_sw_9b_0.S[0] sky130_fd_pr__cap_mim_m3_1 l=2 w=2
X537 single_9b_cdac_1.cdac_sw_9b_0.cdac_sw_3_8.nooverlap_clk_0.CLKB0 single_9b_cdac_1.cdac_sw_9b_0.cdac_sw_3_8.nooverlap_clk_0.sky130_fd_sc_hs__inv_8_0.A VGND VGND sky130_fd_pr__nfet_01v8_lvt ad=0.1036 pd=1.02 as=0.1295 ps=1.09 w=0.74 l=0.15
X538 VDPWR a_11045_23494# a_10935_23618# VDPWR sky130_fd_pr__pfet_01v8_hvt ad=0.07035 pd=0.755 as=0.1155 ps=0.97 w=0.42 l=0.15
X539 VDPWR single_9b_cdac_1.cdac_sw_9b_0.cdac_sw_3_3.nooverlap_clk_0.x1.A single_9b_cdac_1.cdac_sw_9b_0.cdac_sw_3_3.nooverlap_clk_0.sky130_fd_sc_hs__inv_8_0.A VDPWR sky130_fd_pr__pfet_01v8 ad=0.168 pd=1.42 as=0.168 ps=1.42 w=1.12 l=0.15
X540 single_9b_cdac_1.cdac_sw_9b_0.cdac_sw_3_2.nooverlap_clk_0.CLKB0 single_9b_cdac_1.cdac_sw_9b_0.cdac_sw_3_2.nooverlap_clk_0.sky130_fd_sc_hs__inv_8_0.A VDPWR VDPWR sky130_fd_pr__pfet_01v8 ad=0.168 pd=1.42 as=0.196 ps=1.47 w=1.12 l=0.15
X541 VDPWR single_9b_cdac_0.cdac_sw_9b_0.cdac_sw_3_4.nooverlap_clk_0.x10.A single_9b_cdac_0.cdac_sw_9b_0.cdac_sw_3_4.tg_sw_3_3.SWN VDPWR sky130_fd_pr__pfet_01v8 ad=0.196 pd=1.47 as=0.168 ps=1.42 w=1.12 l=0.15
X542 VGND a_6149_23770# sar9b_0.clknet_1_1__leaf_CLK VGND sky130_fd_pr__nfet_01v8 ad=0.0588 pd=0.7 as=0.0588 ps=0.7 w=0.42 l=0.15
X543 th_dif_sw_0.VCP single_9b_cdac_1.cdac_sw_9b_0.S[1] sky130_fd_pr__cap_mim_m3_1 l=2 w=2
X544 VGND a_6149_23770# sar9b_0.clknet_1_1__leaf_CLK VGND sky130_fd_pr__nfet_01v8 ad=0.0588 pd=0.7 as=0.0588 ps=0.7 w=0.42 l=0.15
X545 sar9b_0.net28 a_14143_21050# VGND VGND sky130_fd_pr__nfet_01v8 ad=0.169 pd=1.82 as=0.2087 ps=2.02 w=0.65 l=0.15
X546 a_13308_19810# sar9b_0.net1 VDPWR VDPWR sky130_fd_pr__pfet_01v8_hvt ad=0.0651 pd=0.73 as=0.1092 ps=1.36 w=0.42 l=0.15
X547 VDPWR VGND VDPWR VDPWR sky130_fd_pr__pfet_01v8_hvt ad=0.2262 pd=2.26 as=0 ps=0 w=0.87 l=0.59
X548 th_dif_sw_0.VCN single_9b_cdac_0.cdac_sw_9b_0.S[0] sky130_fd_pr__cap_mim_m3_1 l=2 w=2
X549 VGND single_9b_cdac_0.cdac_sw_9b_0.cdac_sw_3_7.nooverlap_clk_0.x10.A single_9b_cdac_0.cdac_sw_9b_0.cdac_sw_3_7.tg_sw_3_3.SWN VGND sky130_fd_pr__nfet_01v8_lvt ad=0.1554 pd=1.16 as=0.1036 ps=1.02 w=0.74 l=0.15
X550 single_9b_cdac_1.cdac_sw_9b_0.cdac_sw_3_3.nooverlap_clk_0.sky130_fd_sc_hs__inv_8_0.A single_9b_cdac_1.cdac_sw_9b_0.cdac_sw_3_3.nooverlap_clk_0.x1.A VDPWR VDPWR sky130_fd_pr__pfet_01v8 ad=0.168 pd=1.42 as=0.3304 ps=2.83 w=1.12 l=0.15
X551 single_9b_cdac_0.cdac_sw_9b_0.cdac_sw_3_4.tg_sw_3_3.SWN single_9b_cdac_0.cdac_sw_9b_0.cdac_sw_3_4.nooverlap_clk_0.x10.A VGND VGND sky130_fd_pr__nfet_01v8_lvt ad=0.1036 pd=1.02 as=0.1295 ps=1.09 w=0.74 l=0.15
X552 a_11689_19142# a_11471_18900# VGND VGND sky130_fd_pr__nfet_01v8 ad=0.0999 pd=0.985 as=0.1346 ps=1.15 w=0.64 l=0.15
X553 single_9b_cdac_1.cdac_sw_9b_0.S[2] single_9b_cdac_1.cdac_sw_9b_0.cdac_sw_3_0.tg_sw_3_3.SWP ua[0] VGND sky130_fd_pr__nfet_01v8 ad=0.145 pd=1.58 as=0.145 ps=1.58 w=0.5 l=0.5
X554 single_9b_cdac_0.cdac_sw_9b_0.cdac_sw_3_4.tg_sw_3_3.SWN single_9b_cdac_0.cdac_sw_9b_0.cdac_sw_3_4.nooverlap_clk_0.x10.A VDPWR VDPWR sky130_fd_pr__pfet_01v8 ad=0.168 pd=1.42 as=0.168 ps=1.42 w=1.12 l=0.15
X555 VGND VDPWR VGND VGND sky130_fd_pr__nfet_01v8 ad=0.143 pd=1.62 as=0 ps=0 w=0.55 l=0.59
X556 th_dif_sw_0.VCP single_9b_cdac_1.cdac_sw_9b_0.S[2] sky130_fd_pr__cap_mim_m3_1 l=2 w=2
X557 VGND VDPWR VGND VGND sky130_fd_pr__nfet_01v8 ad=0.143 pd=1.62 as=0 ps=0 w=0.55 l=0.59
X558 sar9b_0.net39 a_12211_21050# VDPWR VDPWR sky130_fd_pr__pfet_01v8_hvt ad=0.26 pd=2.52 as=0.3012 ps=2.66 w=1 l=0.15
X559 VDPWR single_9b_cdac_1.cdac_sw_9b_0.cdac_sw_3_2.tg_sw_3_3.SWN single_9b_cdac_1.cdac_sw_9b_0.cdac_sw_3_2.tg_sw_3_3.SWP VDPWR sky130_fd_pr__pfet_01v8 ad=0.196 pd=1.47 as=0.168 ps=1.42 w=1.12 l=0.15
X560 VDPWR a_12036_26516# a_12211_26490# VDPWR sky130_fd_pr__pfet_01v8_hvt ad=0.1134 pd=1.38 as=0.0567 ps=0.69 w=0.42 l=0.15
X561 single_9b_cdac_0.cdac_sw_9b_0.cdac_sw_3_8.tg_sw_3_3.SWN single_9b_cdac_0.cdac_sw_9b_0.cdac_sw_3_8.nooverlap_clk_0.x10.A VDPWR VDPWR sky130_fd_pr__pfet_01v8 ad=0.168 pd=1.42 as=0.196 ps=1.47 w=1.12 l=0.15
X562 VDPWR single_9b_cdac_0.cdac_sw_9b_0.cdac_sw_3_4.nooverlap_clk_0.x10.A single_9b_cdac_0.cdac_sw_9b_0.cdac_sw_3_4.tg_sw_3_3.SWN VDPWR sky130_fd_pr__pfet_01v8 ad=0.168 pd=1.42 as=0.168 ps=1.42 w=1.12 l=0.15
X563 a_12469_26338# a_12425_25946# a_12303_26350# VGND sky130_fd_pr__nfet_01v8 ad=0.0441 pd=0.63 as=0.1401 ps=1.1 w=0.42 l=0.15
X564 a_11567_25188# a_11392_25262# a_11746_25250# VGND sky130_fd_pr__nfet_01v8 ad=0.1092 pd=1.36 as=0.06405 ps=0.725 w=0.42 l=0.15
X565 single_9b_cdac_1.cdac_sw_9b_0.cdac_sw_3_7.nooverlap_clk_0.x10.A single_9b_cdac_1.cdac_sw_9b_0.cdac_sw_3_7.nooverlap_clk_0.x8.A VGND VGND sky130_fd_pr__nfet_01v8_lvt ad=0.1184 pd=1.06 as=0.2331 ps=2.11 w=0.74 l=0.15
X566 th_dif_sw_0.th_sw_1.CK a_9132_7271# VDPWR VDPWR sky130_fd_pr__pfet_01v8 ad=0.168 pd=1.42 as=0.168 ps=1.42 w=1.12 l=0.15
X567 VGND single_9b_cdac_1.cdac_sw_9b_0.cdac_sw_3_7.nooverlap_clk_0.x10.A single_9b_cdac_1.cdac_sw_9b_0.cdac_sw_3_7.tg_sw_3_3.SWN VGND sky130_fd_pr__nfet_01v8_lvt ad=0.1295 pd=1.09 as=0.1036 ps=1.02 w=0.74 l=0.15
X568 VGND single_9b_cdac_1.cdac_sw_9b_0.cdac_sw_3_4.tg_sw_3_3.SWN single_9b_cdac_1.cdac_sw_9b_0.cdac_sw_3_4.tg_sw_3_3.SWP VGND sky130_fd_pr__nfet_01v8_lvt ad=0.1036 pd=1.02 as=0.1036 ps=1.02 w=0.74 l=0.15
X569 th_dif_sw_0.VCP single_9b_cdac_1.cdac_sw_9b_0.S[0] sky130_fd_pr__cap_mim_m3_1 l=2 w=2
X570 a_11505_22406# a_11287_22164# VDPWR VDPWR sky130_fd_pr__pfet_01v8_hvt ad=0.12915 pd=1.185 as=0.2184 ps=2.2 w=0.84 l=0.15
X571 single_9b_cdac_1.cdac_sw_9b_0.cdac_sw_3_4.nooverlap_clk_0.sky130_fd_sc_hs__inv_1_1.A single_9b_cdac_1.cdac_sw_9b_0.cdac_sw_3_4.nooverlap_clk_0.sky130_fd_sc_hs__nand2_1_0.Y VGND VGND sky130_fd_pr__nfet_01v8_lvt ad=0.2109 pd=2.05 as=0.2627 ps=2.19 w=0.74 l=0.15
X572 single_9b_cdac_1.cdac_sw_9b_0.cdac_sw_3_2.tg_sw_3_3.SWP single_9b_cdac_1.cdac_sw_9b_0.cdac_sw_3_2.tg_sw_3_3.SWN VDPWR VDPWR sky130_fd_pr__pfet_01v8 ad=0.168 pd=1.42 as=0.3304 ps=2.83 w=1.12 l=0.15
X573 VDPWR single_9b_cdac_1.CF[1] single_9b_cdac_0.cdac_sw_9b_0.cdac_sw_3_1.nooverlap_clk_0.sky130_fd_sc_hs__nand2_1_0.Y VDPWR sky130_fd_pr__pfet_01v8 ad=0.3192 pd=2.81 as=0.168 ps=1.42 w=1.12 l=0.15
X574 VDPWR sar9b_0.net4 a_8379_24340# VDPWR sky130_fd_pr__pfet_01v8_hvt ad=0.0864 pd=0.91 as=0.1664 ps=1.8 w=0.64 l=0.15
X575 a_10142_20354# a_10055_20130# a_9738_20240# VDPWR sky130_fd_pr__pfet_01v8_hvt ad=0.12915 pd=1.185 as=0.0588 ps=0.7 w=0.42 l=0.15
X576 a_8453_19450# a_8287_19450# VGND VGND sky130_fd_pr__nfet_01v8 ad=0.1092 pd=1.36 as=0.0567 ps=0.69 w=0.42 l=0.15
X577 VGND single_9b_cdac_0.cdac_sw_9b_0.cdac_sw_3_5.nooverlap_clk_0.x8.A single_9b_cdac_0.cdac_sw_9b_0.cdac_sw_3_5.nooverlap_clk_0.x10.A VGND sky130_fd_pr__nfet_01v8_lvt ad=0.2331 pd=2.11 as=0.1184 ps=1.06 w=0.74 l=0.15
X578 VGND sar9b_0.net30 a_14451_25972# VGND sky130_fd_pr__nfet_01v8 ad=0.0754 pd=0.81 as=0.1352 ps=1.56 w=0.52 l=0.15
X579 sar9b_0.net26 a_14143_19748# VGND VGND sky130_fd_pr__nfet_01v8 ad=0.169 pd=1.82 as=0.2087 ps=2.02 w=0.65 l=0.15
X580 ua[0] single_9b_cdac_1.cdac_sw_9b_0.cdac_sw_3_3.tg_sw_3_3.SWP ua[0] VDPWR sky130_fd_pr__pfet_01v8 ad=0.435 pd=3.58 as=0 ps=0 w=1.5 l=0.5
X581 th_dif_sw_0.VCN single_9b_cdac_0.cdac_sw_9b_0.S[1] sky130_fd_pr__cap_mim_m3_1 l=2 w=2
X582 single_9b_cdac_0.cdac_sw_9b_0.cdac_sw_3_1.nooverlap_clk_0.sky130_fd_sc_hs__nand2_1_0.Y single_9b_cdac_0.cdac_sw_9b_0.cdac_sw_3_1.nooverlap_clk_0.x8.A VDPWR VDPWR sky130_fd_pr__pfet_01v8 ad=0.168 pd=1.42 as=0.3192 ps=2.81 w=1.12 l=0.15
X583 VGND VDPWR VGND VGND sky130_fd_pr__nfet_01v8 ad=0.143 pd=1.62 as=0 ps=0 w=0.55 l=0.59
X584 VGND single_9b_cdac_0.cdac_sw_9b_0.cdac_sw_3_5.nooverlap_clk_0.sky130_fd_sc_hs__inv_8_0.A single_9b_cdac_0.cdac_sw_9b_0.cdac_sw_3_5.nooverlap_clk_0.CLKB0 VGND sky130_fd_pr__nfet_01v8_lvt ad=0.1295 pd=1.09 as=0.1036 ps=1.02 w=0.74 l=0.15
X585 ua[0] single_9b_cdac_0.cdac_sw_9b_0.cdac_sw_3_0.tg_sw_3_3.SWN ua[0] VGND sky130_fd_pr__nfet_01v8 ad=0.145 pd=1.58 as=0 ps=0 w=0.5 l=0.5
X586 VDPWR a_6701_20506# sar9b_0.clknet_1_0__leaf_CLK VDPWR sky130_fd_pr__pfet_01v8_hvt ad=0.14 pd=1.28 as=0.14 ps=1.28 w=1 l=0.15
X587 VGND single_9b_cdac_1.SW[7] a_30012_17740# VGND sky130_fd_pr__nfet_01v8 ad=0.145 pd=1.58 as=0.145 ps=1.58 w=0.5 l=0.5
X588 VDPWR sar9b_0.net15 a_8431_22682# VDPWR sky130_fd_pr__pfet_01v8_hvt ad=0.0819 pd=0.81 as=0.0567 ps=0.69 w=0.42 l=0.15
X589 VGND single_9b_cdac_1.cdac_sw_9b_0.cdac_sw_3_6.nooverlap_clk_0.x1.A single_9b_cdac_1.cdac_sw_9b_0.cdac_sw_3_6.nooverlap_clk_0.sky130_fd_sc_hs__inv_8_0.A VGND sky130_fd_pr__nfet_01v8_lvt ad=0.2109 pd=2.05 as=0.1036 ps=1.02 w=0.74 l=0.15
X590 a_9000_27438# a_7919_27066# a_8653_27034# VDPWR sky130_fd_pr__pfet_01v8_hvt ad=0.0588 pd=0.7 as=0.12915 ps=1.185 w=0.42 l=0.15
X591 a_11733_24162# a_11689_23770# a_11567_24174# VGND sky130_fd_pr__nfet_01v8 ad=0.0441 pd=0.63 as=0.1401 ps=1.1 w=0.42 l=0.15
X592 VDPWR a_12211_24100# a_12198_23796# VDPWR sky130_fd_pr__pfet_01v8_hvt ad=0.0819 pd=0.81 as=0.0567 ps=0.69 w=0.42 l=0.15
X593 th_dif_sw_0.VCP single_9b_cdac_1.cdac_sw_9b_0.S[1] sky130_fd_pr__cap_mim_m3_1 l=2 w=2
X594 a_16159_13315# tdc_0.phase_detector_0.pd_out_0.A VGND VGND sky130_fd_pr__nfet_01v8_lvt ad=0.17738 pd=1.195 as=0.33275 ps=2.31 w=0.55 l=0.15
X595 single_9b_cdac_0.cdac_sw_9b_0.cdac_sw_3_2.nooverlap_clk_0.CLKB0 single_9b_cdac_0.cdac_sw_9b_0.cdac_sw_3_2.nooverlap_clk_0.sky130_fd_sc_hs__inv_8_0.A VGND VGND sky130_fd_pr__nfet_01v8_lvt ad=0.1036 pd=1.02 as=0.2146 ps=2.06 w=0.74 l=0.15
X596 VDPWR VGND VDPWR VDPWR sky130_fd_pr__pfet_01v8_hvt ad=0.2262 pd=2.26 as=0 ps=0 w=0.87 l=0.59
X597 single_9b_cdac_1.CF[6] a_13899_23252# VDPWR VDPWR sky130_fd_pr__pfet_01v8_hvt ad=0.2054 pd=2.1 as=0.11455 ps=1.08 w=0.79 l=0.15
X598 a_8909_23074# a_8431_22682# VGND VGND sky130_fd_pr__nfet_01v8 ad=0.0669 pd=0.75 as=0.12495 ps=1.015 w=0.42 l=0.15
X599 sar9b_0.clknet_0_CLK a_7345_21594# VDPWR VDPWR sky130_fd_pr__pfet_01v8_hvt ad=0.14 pd=1.28 as=0.14 ps=1.28 w=1 l=0.15
X600 single_9b_cdac_0.cdac_sw_9b_0.S[3] single_9b_cdac_0.cdac_sw_9b_0.cdac_sw_3_4.tg_sw_3_3.SWP ua[0] VGND sky130_fd_pr__nfet_01v8 ad=0.145 pd=1.58 as=0.145 ps=1.58 w=0.5 l=0.5
X601 th_dif_sw_0.VCP single_9b_cdac_1.cdac_sw_9b_0.S[0] sky130_fd_pr__cap_mim_m3_1 l=2 w=2
X602 VDPWR single_9b_cdac_0.cdac_sw_9b_0.cdac_sw_3_7.nooverlap_clk_0.sky130_fd_sc_hs__inv_1_1.A single_9b_cdac_0.cdac_sw_9b_0.cdac_sw_3_7.nooverlap_clk_0.x1.A VDPWR sky130_fd_pr__pfet_01v8 ad=0.3864 pd=2.93 as=0.3304 ps=2.83 w=1.12 l=0.15
X603 VDPWR VGND VDPWR VDPWR sky130_fd_pr__pfet_01v8_hvt ad=0.2262 pd=2.26 as=0 ps=0 w=0.87 l=0.59
X604 VGND a_9843_19137# a_9774_19266# VGND sky130_fd_pr__nfet_01v8 ad=0.1346 pd=1.15 as=0.0999 ps=0.985 w=0.64 l=0.15
X605 VGND single_9b_cdac_1.cdac_sw_9b_0.cdac_sw_3_6.nooverlap_clk_0.sky130_fd_sc_hs__inv_8_0.A single_9b_cdac_1.cdac_sw_9b_0.cdac_sw_3_6.nooverlap_clk_0.CLKB0 VGND sky130_fd_pr__nfet_01v8_lvt ad=0.1554 pd=1.16 as=0.1036 ps=1.02 w=0.74 l=0.15
X606 VDPWR a_14143_25188# a_14130_24884# VDPWR sky130_fd_pr__pfet_01v8_hvt ad=0.0819 pd=0.81 as=0.0567 ps=0.69 w=0.42 l=0.15
X607 sar9b_0.clknet_1_1__leaf_CLK a_6149_23770# VGND VGND sky130_fd_pr__nfet_01v8 ad=0.0588 pd=0.7 as=0.0588 ps=0.7 w=0.42 l=0.15
X608 th_dif_sw_0.VCP single_9b_cdac_1.cdac_sw_9b_0.S[1] sky130_fd_pr__cap_mim_m3_1 l=2 w=2
X609 th_dif_sw_0.VCN single_9b_cdac_0.cdac_sw_9b_0.S[0] sky130_fd_pr__cap_mim_m3_1 l=2 w=2
X610 th_dif_sw_0.VCN single_9b_cdac_0.cdac_sw_9b_0.S[1] sky130_fd_pr__cap_mim_m3_1 l=2 w=2
X611 a_13665_25250# a_13621_24858# a_13499_25262# VGND sky130_fd_pr__nfet_01v8 ad=0.0441 pd=0.63 as=0.1401 ps=1.1 w=0.42 l=0.15
X612 VDPWR VGND VDPWR VDPWR sky130_fd_pr__pfet_01v8_hvt ad=0.2262 pd=2.26 as=0 ps=0 w=0.87 l=0.59
X613 single_9b_cdac_1.cdac_sw_9b_0.S[5] single_9b_cdac_1.cdac_sw_9b_0.cdac_sw_3_5.tg_sw_3_3.SWN single_9b_cdac_1.cdac_sw_9b_0.S[5] VGND sky130_fd_pr__nfet_01v8 ad=0.145 pd=1.58 as=0 ps=0 w=0.5 l=0.5
X614 single_9b_cdac_1.cdac_sw_9b_0.cdac_sw_3_3.nooverlap_clk_0.x4.A single_9b_cdac_1.cdac_sw_9b_0.cdac_sw_3_3.nooverlap_clk_0.x1.A a_45123_15495# VGND sky130_fd_pr__nfet_01v8_lvt ad=0.2109 pd=2.05 as=0.0888 ps=0.98 w=0.74 l=0.15
X615 VGND VDPWR VGND VGND sky130_fd_pr__nfet_01v8 ad=0.143 pd=1.62 as=0 ps=0 w=0.55 l=0.59
X616 ua[0] single_9b_cdac_0.cdac_sw_9b_0.cdac_sw_3_4.tg_sw_3_3.SWP ua[0] VDPWR sky130_fd_pr__pfet_01v8 ad=0.435 pd=3.58 as=0 ps=0 w=1.5 l=0.5
X617 a_11652_20898# sar9b_0.net7 VGND VGND sky130_fd_pr__nfet_01v8 ad=0.066 pd=0.745 as=0.2205 ps=1.89 w=0.42 l=0.15
X618 a_10055_20130# sar9b_0.net8 VGND VGND sky130_fd_pr__nfet_01v8 ad=0.1092 pd=1.36 as=0.0567 ps=0.69 w=0.42 l=0.15
X619 th_dif_sw_0.VCP single_9b_cdac_1.cdac_sw_9b_0.S[1] sky130_fd_pr__cap_mim_m3_1 l=2 w=2
X620 single_9b_cdac_1.cdac_sw_9b_0.cdac_sw_3_7.nooverlap_clk_0.x3.Y single_9b_cdac_1.CF[7] VDPWR VDPWR sky130_fd_pr__pfet_01v8 ad=0.3304 pd=2.83 as=0.3864 ps=2.93 w=1.12 l=0.15
X621 th_dif_sw_0.VCN single_9b_cdac_0.cdac_sw_9b_0.S[0] sky130_fd_pr__cap_mim_m3_1 l=2 w=2
X622 single_9b_cdac_0.cdac_sw_9b_0.cdac_sw_3_4.nooverlap_clk_0.sky130_fd_sc_hs__inv_8_0.A single_9b_cdac_0.cdac_sw_9b_0.cdac_sw_3_4.nooverlap_clk_0.x1.A VGND VGND sky130_fd_pr__nfet_01v8_lvt ad=0.1036 pd=1.02 as=0.2109 ps=2.05 w=0.74 l=0.15
X623 single_9b_cdac_1.cdac_sw_9b_0.cdac_sw_3_5.nooverlap_clk_0.CLKB0 single_9b_cdac_1.cdac_sw_9b_0.cdac_sw_3_5.nooverlap_clk_0.sky130_fd_sc_hs__inv_8_0.A VGND VGND sky130_fd_pr__nfet_01v8_lvt ad=0.1036 pd=1.02 as=0.2109 ps=2.05 w=0.74 l=0.15
X624 ua[0] single_9b_cdac_1.cdac_sw_9b_0.cdac_sw_3_4.tg_sw_3_3.SWN ua[0] VGND sky130_fd_pr__nfet_01v8 ad=0.145 pd=1.58 as=0 ps=0 w=0.5 l=0.5
X625 VDPWR single_9b_cdac_1.cdac_sw_9b_0.cdac_sw_3_7.nooverlap_clk_0.x10.A single_9b_cdac_1.cdac_sw_9b_0.cdac_sw_3_7.tg_sw_3_3.SWN VDPWR sky130_fd_pr__pfet_01v8 ad=0.3864 pd=2.93 as=0.168 ps=1.42 w=1.12 l=0.15
X626 VDPWR single_9b_cdac_1.cdac_sw_9b_0.cdac_sw_3_0.tg_sw_3_3.SWN single_9b_cdac_1.cdac_sw_9b_0.cdac_sw_3_0.tg_sw_3_3.SWP VDPWR sky130_fd_pr__pfet_01v8 ad=0.196 pd=1.47 as=0.168 ps=1.42 w=1.12 l=0.15
X627 VGND a_6691_26490# a_6625_26516# VGND sky130_fd_pr__nfet_01v8 ad=0.12495 pd=1.015 as=0.0669 ps=0.75 w=0.42 l=0.15
X628 single_9b_cdac_0.cdac_sw_9b_0.S[5] single_9b_cdac_0.cdac_sw_9b_0.cdac_sw_3_5.tg_sw_3_3.SWP ua[0] VGND sky130_fd_pr__nfet_01v8 ad=0.145 pd=1.58 as=0.145 ps=1.58 w=0.5 l=0.5
X629 VDPWR single_9b_cdac_0.cdac_sw_9b_0.cdac_sw_3_3.nooverlap_clk_0.x8.A single_9b_cdac_0.cdac_sw_9b_0.cdac_sw_3_3.nooverlap_clk_0.x10.A VDPWR sky130_fd_pr__pfet_01v8 ad=0.3304 pd=2.83 as=0.168 ps=1.42 w=1.12 l=0.15
X630 single_9b_cdac_0.cdac_sw_9b_0.cdac_sw_3_0.nooverlap_clk_0.x10.A single_9b_cdac_0.cdac_sw_9b_0.cdac_sw_3_0.nooverlap_clk_0.x8.A VGND VGND sky130_fd_pr__nfet_01v8_lvt ad=0.1184 pd=1.06 as=0.1221 ps=1.07 w=0.74 l=0.15
X631 ua[0] single_9b_cdac_0.cdac_sw_9b_0.cdac_sw_3_4.tg_sw_3_3.SWN ua[0] VGND sky130_fd_pr__nfet_01v8 ad=0.145 pd=1.58 as=0 ps=0 w=0.5 l=0.5
X632 VGND single_9b_cdac_0.cdac_sw_9b_0.cdac_sw_3_1.nooverlap_clk_0.x10.A single_9b_cdac_0.cdac_sw_9b_0.cdac_sw_3_1.tg_sw_3_3.SWN VGND sky130_fd_pr__nfet_01v8_lvt ad=0.1036 pd=1.02 as=0.1036 ps=1.02 w=0.74 l=0.15
X633 sar9b_0.net40 a_10187_22138# VDPWR VDPWR sky130_fd_pr__pfet_01v8_hvt ad=0.26 pd=2.52 as=0.3012 ps=2.66 w=1 l=0.15
X634 th_dif_sw_0.VCP single_9b_cdac_1.cdac_sw_9b_0.S[0] sky130_fd_pr__cap_mim_m3_1 l=2 w=2
X635 th_dif_sw_0.VCN single_9b_cdac_0.cdac_sw_9b_0.S[0] sky130_fd_pr__cap_mim_m3_1 l=2 w=2
X636 a_7809_23028# sar9b_0.clk_div_0.COUNT\[1\] a_7725_23028# VGND sky130_fd_pr__nfet_01v8 ad=0.10725 pd=0.98 as=0.08775 ps=0.92 w=0.65 l=0.15
X637 a_12211_18874# a_12036_18900# a_12390_18900# VGND sky130_fd_pr__nfet_01v8 ad=0.1092 pd=1.36 as=0.06405 ps=0.725 w=0.42 l=0.15
X638 single_9b_cdac_1.cdac_sw_9b_0.cdac_sw_3_7.tg_sw_3_3.SWN single_9b_cdac_1.cdac_sw_9b_0.cdac_sw_3_7.nooverlap_clk_0.x10.A VDPWR VDPWR sky130_fd_pr__pfet_01v8 ad=0.168 pd=1.42 as=0.196 ps=1.47 w=1.12 l=0.15
X639 single_9b_cdac_1.cdac_sw_9b_0.cdac_sw_3_0.tg_sw_3_3.SWP single_9b_cdac_1.cdac_sw_9b_0.cdac_sw_3_0.tg_sw_3_3.SWN VDPWR VDPWR sky130_fd_pr__pfet_01v8 ad=0.168 pd=1.42 as=0.168 ps=1.42 w=1.12 l=0.15
X640 VDPWR single_9b_cdac_1.cdac_sw_9b_0.cdac_sw_3_1.nooverlap_clk_0.x1.A single_9b_cdac_1.cdac_sw_9b_0.cdac_sw_3_1.nooverlap_clk_0.sky130_fd_sc_hs__inv_8_0.A VDPWR sky130_fd_pr__pfet_01v8 ad=0.3304 pd=2.83 as=0.168 ps=1.42 w=1.12 l=0.15
X641 VDPWR a_9849_26758# a_9739_26882# VDPWR sky130_fd_pr__pfet_01v8_hvt ad=0.07035 pd=0.755 as=0.1155 ps=0.97 w=0.42 l=0.15
X642 VDPWR single_9b_cdac_0.cdac_sw_9b_0.cdac_sw_3_1.nooverlap_clk_0.CLKB0 single_9b_cdac_0.cdac_sw_9b_0.cdac_sw_3_1.nooverlap_clk_0.CLK0 VDPWR sky130_fd_pr__pfet_01v8 ad=0.196 pd=1.47 as=0.168 ps=1.42 w=1.12 l=0.15
X643 a_6759_20354# a_5895_19988# a_6502_20124# VDPWR sky130_fd_pr__pfet_01v8_hvt ad=0.0567 pd=0.69 as=0.1095 ps=1.075 w=0.42 l=0.15
X644 VDPWR VGND VDPWR VDPWR sky130_fd_pr__pfet_01v8_hvt ad=0.2262 pd=2.26 as=0 ps=0 w=0.87 l=0.59
X645 VDPWR a_10371_21050# a_10358_21442# VDPWR sky130_fd_pr__pfet_01v8_hvt ad=0.0819 pd=0.81 as=0.0567 ps=0.69 w=0.42 l=0.15
X646 VDPWR a_11689_21318# a_11579_21442# VDPWR sky130_fd_pr__pfet_01v8_hvt ad=0.07035 pd=0.755 as=0.1155 ps=0.97 w=0.42 l=0.15
X647 sar9b_0.clknet_1_0__leaf_CLK a_6701_20506# VGND VGND sky130_fd_pr__nfet_01v8 ad=0.0588 pd=0.7 as=0.0588 ps=0.7 w=0.42 l=0.15
X648 th_dif_sw_0.VCP single_9b_cdac_1.cdac_sw_9b_0.S[1] sky130_fd_pr__cap_mim_m3_1 l=2 w=2
X649 VGND VDPWR VGND VGND sky130_fd_pr__nfet_01v8 ad=0.143 pd=1.62 as=0 ps=0 w=0.55 l=0.59
X650 single_9b_cdac_1.cdac_sw_9b_0.S[5] single_9b_cdac_1.cdac_sw_9b_0.cdac_sw_3_5.nooverlap_clk_0.CLKB0 a_38738_16877# VDPWR sky130_fd_pr__pfet_01v8 ad=0.435 pd=3.58 as=0.435 ps=3.58 w=1.5 l=0.5
X651 VDPWR single_9b_cdac_1.cdac_sw_9b_0.cdac_sw_3_0.tg_sw_3_3.SWN single_9b_cdac_1.cdac_sw_9b_0.cdac_sw_3_0.tg_sw_3_3.SWP VDPWR sky130_fd_pr__pfet_01v8 ad=0.168 pd=1.42 as=0.168 ps=1.42 w=1.12 l=0.15
X652 th_dif_sw_0.VCP single_9b_cdac_1.cdac_sw_9b_0.S[4] sky130_fd_pr__cap_mim_m3_1 l=2 w=2
X653 th_dif_sw_0.VCN single_9b_cdac_0.cdac_sw_9b_0.S[1] sky130_fd_pr__cap_mim_m3_1 l=2 w=2
X654 single_9b_cdac_1.cdac_sw_9b_0.cdac_sw_3_1.nooverlap_clk_0.sky130_fd_sc_hs__inv_8_0.A single_9b_cdac_1.cdac_sw_9b_0.cdac_sw_3_1.nooverlap_clk_0.x1.A VDPWR VDPWR sky130_fd_pr__pfet_01v8 ad=0.168 pd=1.42 as=0.168 ps=1.42 w=1.12 l=0.15
X655 a_9003_25972# sar9b_0.net3 VDPWR VDPWR sky130_fd_pr__pfet_01v8_hvt ad=0.1092 pd=1.36 as=0.07035 ps=0.755 w=0.42 l=0.15
X656 a_10935_24884# a_10311_24890# a_10827_25262# VDPWR sky130_fd_pr__pfet_01v8_hvt ad=0.1155 pd=0.97 as=0.07245 ps=0.765 w=0.42 l=0.15
X657 a_6701_20506# sar9b_0.clknet_0_CLK VGND VGND sky130_fd_pr__nfet_01v8 ad=0.0588 pd=0.7 as=0.0588 ps=0.7 w=0.42 l=0.15
X658 single_9b_cdac_1.cdac_sw_9b_0.cdac_sw_3_6.nooverlap_clk_0.sky130_fd_sc_hs__inv_1_1.A single_9b_cdac_1.cdac_sw_9b_0.cdac_sw_3_6.nooverlap_clk_0.sky130_fd_sc_hs__nand2_1_0.Y VDPWR VDPWR sky130_fd_pr__pfet_01v8 ad=0.3304 pd=2.83 as=0.3864 ps=2.93 w=1.12 l=0.15
X659 a_6184_23252# a_5785_23252# a_6058_23618# VGND sky130_fd_pr__special_nfet_01v8 ad=0.0696 pd=0.765 as=0.0621 ps=0.705 w=0.36 l=0.15
X660 VDPWR a_9000_27438# a_9175_27364# VDPWR sky130_fd_pr__pfet_01v8_hvt ad=0.1134 pd=1.38 as=0.0567 ps=0.69 w=0.42 l=0.15
X661 VDPWR VGND VDPWR VDPWR sky130_fd_pr__pfet_01v8_hvt ad=0.2262 pd=2.26 as=0 ps=0 w=0.87 l=0.59
X662 a_8951_22950# sar9b_0.net4 VDPWR VDPWR sky130_fd_pr__pfet_01v8_hvt ad=0.1664 pd=1.8 as=0.0864 ps=0.91 w=0.64 l=0.15
X663 VDPWR a_7345_21594# sar9b_0.clknet_0_CLK VDPWR sky130_fd_pr__pfet_01v8_hvt ad=0.14 pd=1.28 as=0.14 ps=1.28 w=1 l=0.15
X664 single_9b_cdac_1.cdac_sw_9b_0.cdac_sw_3_0.tg_sw_3_3.SWP single_9b_cdac_1.cdac_sw_9b_0.cdac_sw_3_0.tg_sw_3_3.SWN VDPWR VDPWR sky130_fd_pr__pfet_01v8 ad=0.168 pd=1.42 as=0.196 ps=1.47 w=1.12 l=0.15
X665 th_dif_sw_0.VCP single_9b_cdac_1.cdac_sw_9b_0.S[1] sky130_fd_pr__cap_mim_m3_1 l=2 w=2
X666 VDPWR a_7345_21594# sar9b_0.clknet_0_CLK VDPWR sky130_fd_pr__pfet_01v8_hvt ad=0.14 pd=1.28 as=0.14 ps=1.28 w=1 l=0.15
X667 th_dif_sw_0.VCN single_9b_cdac_0.cdac_sw_9b_0.S[1] sky130_fd_pr__cap_mim_m3_1 l=2 w=2
X668 VDPWR single_9b_cdac_1.cdac_sw_9b_0.cdac_sw_3_1.nooverlap_clk_0.x1.A single_9b_cdac_1.cdac_sw_9b_0.cdac_sw_3_1.nooverlap_clk_0.sky130_fd_sc_hs__inv_8_0.A VDPWR sky130_fd_pr__pfet_01v8 ad=0.168 pd=1.42 as=0.168 ps=1.42 w=1.12 l=0.15
X669 VGND VDPWR VGND VGND sky130_fd_pr__nfet_01v8 ad=0.143 pd=1.62 as=0 ps=0 w=0.55 l=0.59
X670 a_6610_22708# a_6337_22714# a_6525_22708# VDPWR sky130_fd_pr__pfet_01v8_hvt ad=0.06825 pd=0.745 as=0.05775 ps=0.695 w=0.42 l=0.15
X671 a_6345_21940# sar9b_0.net3 sar9b_0._10_ VGND sky130_fd_pr__nfet_01v8 ad=0.08775 pd=0.92 as=0.169 ps=1.82 w=0.65 l=0.15
X672 VGND sar9b_0.net43 a_13071_21620# VGND sky130_fd_pr__nfet_01v8 ad=0.0754 pd=0.81 as=0.1352 ps=1.56 w=0.52 l=0.15
X673 VDPWR single_9b_cdac_1.cdac_sw_9b_0.cdac_sw_3_3.nooverlap_clk_0.sky130_fd_sc_hs__inv_8_0.A single_9b_cdac_1.cdac_sw_9b_0.cdac_sw_3_3.nooverlap_clk_0.CLKB0 VDPWR sky130_fd_pr__pfet_01v8 ad=0.196 pd=1.47 as=0.168 ps=1.42 w=1.12 l=0.15
X674 th_dif_sw_0.VCP single_9b_cdac_1.cdac_sw_9b_0.S[0] sky130_fd_pr__cap_mim_m3_1 l=2 w=2
X675 VDPWR VGND VDPWR VDPWR sky130_fd_pr__pfet_01v8_hvt ad=0.2262 pd=2.26 as=0 ps=0 w=0.87 l=0.59
X676 single_9b_cdac_1.cdac_sw_9b_0.cdac_sw_3_1.nooverlap_clk_0.sky130_fd_sc_hs__inv_8_0.A single_9b_cdac_1.cdac_sw_9b_0.cdac_sw_3_1.nooverlap_clk_0.x1.A VDPWR VDPWR sky130_fd_pr__pfet_01v8 ad=0.168 pd=1.42 as=0.3304 ps=2.83 w=1.12 l=0.15
X677 th_dif_sw_0.VCP single_9b_cdac_1.cdac_sw_9b_0.S[1] sky130_fd_pr__cap_mim_m3_1 l=2 w=2
X678 a_13053_19988# a_12887_19988# VDPWR VDPWR sky130_fd_pr__pfet_01v8_hvt ad=0.1664 pd=1.8 as=0.0864 ps=0.91 w=0.64 l=0.15
X679 th_dif_sw_0.VCN single_9b_cdac_0.cdac_sw_9b_0.S[0] sky130_fd_pr__cap_mim_m3_1 l=2 w=2
X680 VDPWR a_9460_24340# a_9635_24314# VDPWR sky130_fd_pr__pfet_01v8_hvt ad=0.1134 pd=1.38 as=0.0567 ps=0.69 w=0.42 l=0.15
X681 VGND single_9b_cdac_1.cdac_sw_9b_0.cdac_sw_3_7.nooverlap_clk_0.x10.A single_9b_cdac_1.cdac_sw_9b_0.cdac_sw_3_7.tg_sw_3_3.SWN VGND sky130_fd_pr__nfet_01v8_lvt ad=0.1036 pd=1.02 as=0.1036 ps=1.02 w=0.74 l=0.15
X682 th_dif_sw_0.VCP single_9b_cdac_1.cdac_sw_9b_0.S[2] sky130_fd_pr__cap_mim_m3_1 l=2 w=2
X683 VGND single_9b_cdac_0.cdac_sw_9b_0.cdac_sw_3_4.nooverlap_clk_0.x8.A single_9b_cdac_0.cdac_sw_9b_0.cdac_sw_3_4.nooverlap_clk_0.x10.A VGND sky130_fd_pr__nfet_01v8_lvt ad=0.1221 pd=1.07 as=0.1036 ps=1.02 w=0.74 l=0.15
X684 VGND VDPWR VGND VGND sky130_fd_pr__nfet_01v8 ad=0.143 pd=1.62 as=0 ps=0 w=0.55 l=0.59
X685 VGND single_9b_cdac_1.cdac_sw_9b_0.cdac_sw_3_8.nooverlap_clk_0.sky130_fd_sc_hs__inv_8_0.A single_9b_cdac_1.cdac_sw_9b_0.cdac_sw_3_8.nooverlap_clk_0.CLKB0 VGND sky130_fd_pr__nfet_01v8_lvt ad=0.2146 pd=2.06 as=0.1036 ps=1.02 w=0.74 l=0.15
X686 single_9b_cdac_1.cdac_sw_9b_0.S[4] single_9b_cdac_1.cdac_sw_9b_0.cdac_sw_3_3.tg_sw_3_3.SWN single_9b_cdac_1.cdac_sw_9b_0.S[4] VGND sky130_fd_pr__nfet_01v8 ad=0.145 pd=1.58 as=0 ps=0 w=0.5 l=0.5
X687 a_14077_26516# a_12887_26516# a_13968_26516# VGND sky130_fd_pr__special_nfet_01v8 ad=0.0669 pd=0.75 as=0.0711 ps=0.755 w=0.36 l=0.15
X688 th_dif_sw_0.VCN ua[0] sky130_fd_pr__cap_mim_m3_1 l=2 w=2
X689 VGND single_9b_cdac_0.cdac_sw_9b_0.cdac_sw_3_5.nooverlap_clk_0.sky130_fd_sc_hs__inv_8_0.A single_9b_cdac_0.cdac_sw_9b_0.cdac_sw_3_5.nooverlap_clk_0.CLKB0 VGND sky130_fd_pr__nfet_01v8_lvt ad=0.2109 pd=2.05 as=0.1036 ps=1.02 w=0.74 l=0.15
X690 a_39616_26990# single_9b_cdac_0.cdac_sw_9b_0.cdac_sw_3_5.nooverlap_clk_0.CLK0 single_9b_cdac_0.cdac_sw_9b_0.S[5] VGND sky130_fd_pr__nfet_01v8 ad=0.145 pd=1.58 as=0.145 ps=1.58 w=0.5 l=0.5
X691 VDPWR single_9b_cdac_0.cdac_sw_9b_0.cdac_sw_3_5.tg_sw_3_3.SWN single_9b_cdac_0.cdac_sw_9b_0.cdac_sw_3_5.tg_sw_3_3.SWP VDPWR sky130_fd_pr__pfet_01v8 ad=0.196 pd=1.47 as=0.168 ps=1.42 w=1.12 l=0.15
X692 single_9b_cdac_1.cdac_sw_9b_0.S[5] single_9b_cdac_1.cdac_sw_9b_0.cdac_sw_3_5.tg_sw_3_3.SWP ua[0] VGND sky130_fd_pr__nfet_01v8 ad=0.145 pd=1.58 as=0.145 ps=1.58 w=0.5 l=0.5
X693 VGND VDPWR VGND VGND sky130_fd_pr__nfet_01v8 ad=0.143 pd=1.62 as=0 ps=0 w=0.55 l=0.59
X694 VGND VDPWR VGND VGND sky130_fd_pr__nfet_01v8 ad=0.143 pd=1.62 as=0 ps=0 w=0.55 l=0.59
X695 VDPWR VGND VDPWR VDPWR sky130_fd_pr__pfet_01v8_hvt ad=0.2262 pd=2.26 as=0 ps=0 w=0.87 l=0.59
X696 th_dif_sw_0.VCN single_9b_cdac_0.cdac_sw_9b_0.S[0] sky130_fd_pr__cap_mim_m3_1 l=2 w=2
X697 VGND single_9b_cdac_0.cdac_sw_9b_0.cdac_sw_3_3.nooverlap_clk_0.x10.A single_9b_cdac_0.cdac_sw_9b_0.cdac_sw_3_3.tg_sw_3_3.SWN VGND sky130_fd_pr__nfet_01v8_lvt ad=0.1295 pd=1.09 as=0.1036 ps=1.02 w=0.74 l=0.15
X698 a_48343_26999# single_9b_cdac_0.SW[3] VDPWR VDPWR sky130_fd_pr__pfet_01v8 ad=0.435 pd=3.58 as=0.435 ps=3.58 w=1.5 l=0.5
X699 single_9b_cdac_0.cdac_sw_9b_0.cdac_sw_3_5.tg_sw_3_3.SWP single_9b_cdac_0.cdac_sw_9b_0.cdac_sw_3_5.tg_sw_3_3.SWN VDPWR VDPWR sky130_fd_pr__pfet_01v8 ad=0.168 pd=1.42 as=0.168 ps=1.42 w=1.12 l=0.15
X700 VGND single_9b_cdac_1.cdac_sw_9b_0.cdac_sw_3_0.tg_sw_3_3.SWN single_9b_cdac_1.cdac_sw_9b_0.cdac_sw_3_0.tg_sw_3_3.SWP VGND sky130_fd_pr__nfet_01v8_lvt ad=0.1554 pd=1.16 as=0.1036 ps=1.02 w=0.74 l=0.15
X701 a_54032_26990# single_9b_cdac_0.cdac_sw_9b_0.cdac_sw_3_0.nooverlap_clk_0.CLK0 single_9b_cdac_0.cdac_sw_9b_0.S[2] VGND sky130_fd_pr__nfet_01v8 ad=0.145 pd=1.58 as=0.145 ps=1.58 w=0.5 l=0.5
X702 VDPWR sar9b_0.net13 a_10955_23802# VDPWR sky130_fd_pr__pfet_01v8_hvt ad=0.0864 pd=0.91 as=0.1664 ps=1.8 w=0.64 l=0.15
X703 VDPWR VGND VDPWR VDPWR sky130_fd_pr__pfet_01v8_hvt ad=0.2262 pd=2.26 as=0 ps=0 w=0.87 l=0.59
X704 VDPWR a_8783_23796# a_8951_23770# VDPWR sky130_fd_pr__pfet_01v8_hvt ad=0.135 pd=1.27 as=0.27 ps=2.54 w=1 l=0.15
X705 sar9b_0.clknet_0_CLK a_7345_21594# VGND VGND sky130_fd_pr__nfet_01v8 ad=0.0588 pd=0.7 as=0.0588 ps=0.7 w=0.42 l=0.15
X706 a_13403_18900# a_12887_18900# a_13308_18900# VGND sky130_fd_pr__special_nfet_01v8 ad=0.0594 pd=0.69 as=0.066 ps=0.745 w=0.36 l=0.15
X707 VDPWR single_9b_cdac_1.cdac_sw_9b_0.cdac_sw_3_3.nooverlap_clk_0.x1.A single_9b_cdac_1.cdac_sw_9b_0.cdac_sw_3_3.nooverlap_clk_0.x4.A VDPWR sky130_fd_pr__pfet_01v8 ad=0.3192 pd=2.81 as=0.168 ps=1.42 w=1.12 l=0.15
X708 single_9b_cdac_1.cdac_sw_9b_0.cdac_sw_3_4.nooverlap_clk_0.CLK0 single_9b_cdac_1.cdac_sw_9b_0.cdac_sw_3_4.nooverlap_clk_0.CLKB0 VGND VGND sky130_fd_pr__nfet_01v8_lvt ad=0.1036 pd=1.02 as=0.1036 ps=1.02 w=0.74 l=0.15
X709 th_dif_sw_0.VCP single_9b_cdac_1.cdac_sw_9b_0.S[0] sky130_fd_pr__cap_mim_m3_1 l=2 w=2
X710 th_dif_sw_0.VCN single_9b_cdac_0.cdac_sw_9b_0.S[1] sky130_fd_pr__cap_mim_m3_1 l=2 w=2
X711 single_9b_cdac_0.cdac_sw_9b_0.S[5] single_9b_cdac_0.cdac_sw_9b_0.cdac_sw_3_5.tg_sw_3_3.SWN ua[0] VDPWR sky130_fd_pr__pfet_01v8 ad=0.435 pd=3.58 as=0.435 ps=3.58 w=1.5 l=0.5
X712 VDPWR single_9b_cdac_0.cdac_sw_9b_0.cdac_sw_3_5.tg_sw_3_3.SWN single_9b_cdac_0.cdac_sw_9b_0.cdac_sw_3_5.tg_sw_3_3.SWP VDPWR sky130_fd_pr__pfet_01v8 ad=0.168 pd=1.42 as=0.168 ps=1.42 w=1.12 l=0.15
X713 single_9b_cdac_1.CF[2] a_13899_21620# VDPWR VDPWR sky130_fd_pr__pfet_01v8_hvt ad=0.2054 pd=2.1 as=0.11455 ps=1.08 w=0.79 l=0.15
X714 th_dif_sw_0.VCP single_9b_cdac_1.cdac_sw_9b_0.S[1] sky130_fd_pr__cap_mim_m3_1 l=2 w=2
X715 sar9b_0.clknet_0_CLK a_7345_21594# VGND VGND sky130_fd_pr__nfet_01v8 ad=0.0588 pd=0.7 as=0.0588 ps=0.7 w=0.42 l=0.15
X716 VGND VDPWR VGND VGND sky130_fd_pr__nfet_01v8 ad=0.143 pd=1.62 as=0 ps=0 w=0.55 l=0.59
X717 single_9b_cdac_1.cdac_sw_9b_0.cdac_sw_3_3.nooverlap_clk_0.x4.A single_9b_cdac_1.cdac_sw_9b_0.cdac_sw_3_3.nooverlap_clk_0.x3.Y VDPWR VDPWR sky130_fd_pr__pfet_01v8 ad=0.168 pd=1.42 as=0.3192 ps=2.81 w=1.12 l=0.15
X718 single_9b_cdac_1.cdac_sw_9b_0.cdac_sw_3_1.nooverlap_clk_0.CLK0 single_9b_cdac_1.cdac_sw_9b_0.cdac_sw_3_1.nooverlap_clk_0.CLKB0 VGND VGND sky130_fd_pr__nfet_01v8_lvt ad=0.1036 pd=1.02 as=0.1295 ps=1.09 w=0.74 l=0.15
X719 VGND a_13857_27279# uo_out[1] VGND sky130_fd_pr__nfet_01v8 ad=0.0754 pd=0.81 as=0.1352 ps=1.56 w=0.52 l=0.15
X720 a_5863_19662# sar9b_0.clknet_1_0__leaf_CLK VDPWR VDPWR sky130_fd_pr__pfet_01v8_hvt ad=0.1664 pd=1.8 as=0.0864 ps=0.91 w=0.64 l=0.15
X721 single_9b_cdac_1.cdac_sw_9b_0.S[4] single_9b_cdac_1.cdac_sw_9b_0.cdac_sw_3_3.nooverlap_clk_0.CLKB0 a_43540_16877# VDPWR sky130_fd_pr__pfet_01v8 ad=0.435 pd=3.58 as=0.435 ps=3.58 w=1.5 l=0.5
X722 a_6061_19988# a_5895_19988# VGND VGND sky130_fd_pr__nfet_01v8 ad=0.1092 pd=1.36 as=0.0567 ps=0.69 w=0.42 l=0.15
X723 single_9b_cdac_1.cdac_sw_9b_0.cdac_sw_3_5.nooverlap_clk_0.sky130_fd_sc_hs__inv_1_1.A single_9b_cdac_1.cdac_sw_9b_0.cdac_sw_3_5.nooverlap_clk_0.sky130_fd_sc_hs__nand2_1_0.Y VDPWR VDPWR sky130_fd_pr__pfet_01v8 ad=0.3304 pd=2.83 as=0.3864 ps=2.93 w=1.12 l=0.15
X724 VGND sar9b_0.net8 a_12887_22164# VGND sky130_fd_pr__nfet_01v8 ad=0.0567 pd=0.69 as=0.1092 ps=1.36 w=0.42 l=0.15
X725 VDPWR single_9b_cdac_1.cdac_sw_9b_0.cdac_sw_3_6.tg_sw_3_3.SWN single_9b_cdac_1.cdac_sw_9b_0.cdac_sw_3_6.tg_sw_3_3.SWP VDPWR sky130_fd_pr__pfet_01v8 ad=0.196 pd=1.47 as=0.168 ps=1.42 w=1.12 l=0.15
X726 VGND single_9b_cdac_1.cdac_sw_9b_0.cdac_sw_3_5.nooverlap_clk_0.x8.A a_41357_15501# VGND sky130_fd_pr__nfet_01v8_lvt ad=0.2109 pd=2.05 as=0.0888 ps=0.98 w=0.74 l=0.15
X727 a_13665_25428# a_13621_25670# a_13499_25428# VGND sky130_fd_pr__nfet_01v8 ad=0.0441 pd=0.63 as=0.1401 ps=1.1 w=0.42 l=0.15
X728 VGND sar9b_0.net28 a_14175_24340# VGND sky130_fd_pr__nfet_01v8 ad=0.0754 pd=0.81 as=0.1352 ps=1.56 w=0.52 l=0.15
X729 ua[0] single_9b_cdac_1.cdac_sw_9b_0.cdac_sw_3_5.tg_sw_3_3.SWN ua[0] VGND sky130_fd_pr__nfet_01v8 ad=0.145 pd=1.58 as=0 ps=0 w=0.5 l=0.5
X730 single_9b_cdac_1.cdac_sw_9b_0.cdac_sw_3_3.tg_sw_3_3.SWN single_9b_cdac_1.cdac_sw_9b_0.cdac_sw_3_3.nooverlap_clk_0.x10.A VGND VGND sky130_fd_pr__nfet_01v8_lvt ad=0.1036 pd=1.02 as=0.2109 ps=2.05 w=0.74 l=0.15
X731 th_dif_sw_0.VCN single_9b_cdac_0.cdac_sw_9b_0.S[2] sky130_fd_pr__cap_mim_m3_1 l=2 w=2
X732 VDPWR single_9b_cdac_1.CF[5] single_9b_cdac_0.cdac_sw_9b_0.cdac_sw_3_5.nooverlap_clk_0.x3.Y VDPWR sky130_fd_pr__pfet_01v8 ad=0.3864 pd=2.93 as=0.3304 ps=2.83 w=1.12 l=0.15
X733 a_12315_25972# sar9b_0.net3 VDPWR VDPWR sky130_fd_pr__pfet_01v8_hvt ad=0.1092 pd=1.36 as=0.07035 ps=0.755 w=0.42 l=0.15
X734 VGND VDPWR VGND VGND sky130_fd_pr__nfet_01v8 ad=0.143 pd=1.62 as=0 ps=0 w=0.55 l=0.59
X735 single_9b_cdac_1.cdac_sw_9b_0.cdac_sw_3_6.tg_sw_3_3.SWP single_9b_cdac_1.cdac_sw_9b_0.cdac_sw_3_6.tg_sw_3_3.SWN VDPWR VDPWR sky130_fd_pr__pfet_01v8 ad=0.168 pd=1.42 as=0.3304 ps=2.83 w=1.12 l=0.15
X736 th_dif_sw_0.VCN single_9b_cdac_0.cdac_sw_9b_0.S[0] sky130_fd_pr__cap_mim_m3_1 l=2 w=2
X737 VDPWR single_9b_cdac_1.CF[7] single_9b_cdac_0.cdac_sw_9b_0.cdac_sw_3_7.nooverlap_clk_0.sky130_fd_sc_hs__nand2_1_0.Y VDPWR sky130_fd_pr__pfet_01v8 ad=0.3192 pd=2.81 as=0.168 ps=1.42 w=1.12 l=0.15
X738 VGND VDPWR VGND VGND sky130_fd_pr__nfet_01v8 ad=0.143 pd=1.62 as=0 ps=0 w=0.55 l=0.59
X739 a_6674_21050# sar9b_0._08_ VDPWR VDPWR sky130_fd_pr__pfet_01v8_hvt ad=0.1092 pd=1.36 as=0.1092 ps=1.36 w=0.42 l=0.15
X740 VGND single_9b_cdac_0.SW[7] a_30012_26990# VGND sky130_fd_pr__nfet_01v8 ad=0.145 pd=1.58 as=0.145 ps=1.58 w=0.5 l=0.5
X741 th_dif_sw_0.VCP single_9b_cdac_1.cdac_sw_9b_0.S[3] sky130_fd_pr__cap_mim_m3_1 l=2 w=2
X742 single_9b_cdac_0.cdac_sw_9b_0.cdac_sw_3_8.nooverlap_clk_0.CLK0 single_9b_cdac_0.cdac_sw_9b_0.cdac_sw_3_8.nooverlap_clk_0.CLKB0 VGND VGND sky130_fd_pr__nfet_01v8_lvt ad=0.1036 pd=1.02 as=0.1295 ps=1.09 w=0.74 l=0.15
X743 th_dif_sw_0.th_sw_1.CKB a_21177_7457# VGND VGND sky130_fd_pr__nfet_01v8_lvt ad=0.1036 pd=1.02 as=0.1554 ps=1.16 w=0.74 l=0.15
X744 VDPWR VGND VDPWR VDPWR sky130_fd_pr__pfet_01v8_hvt ad=0.2262 pd=2.26 as=0 ps=0 w=0.87 l=0.59
X745 th_dif_sw_0.VCP single_9b_cdac_1.cdac_sw_9b_0.S[0] sky130_fd_pr__cap_mim_m3_1 l=2 w=2
X746 single_9b_cdac_0.cdac_sw_9b_0.cdac_sw_3_7.nooverlap_clk_0.sky130_fd_sc_hs__nand2_1_0.Y single_9b_cdac_0.cdac_sw_9b_0.cdac_sw_3_7.nooverlap_clk_0.x8.A VDPWR VDPWR sky130_fd_pr__pfet_01v8 ad=0.168 pd=1.42 as=0.3192 ps=2.81 w=1.12 l=0.15
X747 th_dif_sw_0.VCN single_9b_cdac_0.cdac_sw_9b_0.S[4] sky130_fd_pr__cap_mim_m3_1 l=2 w=2
X748 a_24332_26999# single_9b_cdac_0.SW[8] VDPWR VDPWR sky130_fd_pr__pfet_01v8 ad=0.435 pd=3.58 as=0.435 ps=3.58 w=1.5 l=0.5
X749 dw_12589_1395# a_10166_3438# sky130_fd_pr__cap_mim_m3_1 l=2 w=2
X750 single_9b_cdac_1.cdac_sw_9b_0.cdac_sw_3_1.tg_sw_3_3.SWP single_9b_cdac_1.cdac_sw_9b_0.cdac_sw_3_1.tg_sw_3_3.SWN VGND VGND sky130_fd_pr__nfet_01v8_lvt ad=0.1036 pd=1.02 as=0.2109 ps=2.05 w=0.74 l=0.15
X751 single_9b_cdac_0.cdac_sw_9b_0.cdac_sw_3_3.nooverlap_clk_0.CLKB0 single_9b_cdac_0.cdac_sw_9b_0.cdac_sw_3_3.nooverlap_clk_0.sky130_fd_sc_hs__inv_8_0.A VDPWR VDPWR sky130_fd_pr__pfet_01v8 ad=0.168 pd=1.42 as=0.196 ps=1.47 w=1.12 l=0.15
X752 single_9b_cdac_1.cdac_sw_9b_0.S[3] single_9b_cdac_1.cdac_sw_9b_0.cdac_sw_3_4.nooverlap_clk_0.CLKB0 a_48343_16877# VDPWR sky130_fd_pr__pfet_01v8 ad=0.435 pd=3.58 as=0.435 ps=3.58 w=1.5 l=0.5
X753 single_9b_cdac_1.cdac_sw_9b_0.cdac_sw_3_0.nooverlap_clk_0.x8.A single_9b_cdac_1.cdac_sw_9b_0.cdac_sw_3_0.nooverlap_clk_0.x6.A VDPWR VDPWR sky130_fd_pr__pfet_01v8 ad=0.3304 pd=2.83 as=0.3864 ps=2.93 w=1.12 l=0.15
X754 th_dif_sw_0.VCP single_9b_cdac_1.cdac_sw_9b_0.S[0] sky130_fd_pr__cap_mim_m3_1 l=2 w=2
X755 VGND sar9b_0.FINAL a_10955_26516# VGND sky130_fd_pr__nfet_01v8 ad=0.0567 pd=0.69 as=0.1092 ps=1.36 w=0.42 l=0.15
X756 single_9b_cdac_0.cdac_sw_9b_0.cdac_sw_3_6.nooverlap_clk_0.CLKB0 single_9b_cdac_0.cdac_sw_9b_0.cdac_sw_3_6.nooverlap_clk_0.sky130_fd_sc_hs__inv_8_0.A VGND VGND sky130_fd_pr__nfet_01v8_lvt ad=0.1036 pd=1.02 as=0.2146 ps=2.06 w=0.74 l=0.15
X757 VGND single_9b_cdac_0.cdac_sw_9b_0.cdac_sw_3_0.nooverlap_clk_0.sky130_fd_sc_hs__inv_8_0.A single_9b_cdac_0.cdac_sw_9b_0.cdac_sw_3_0.nooverlap_clk_0.CLKB0 VGND sky130_fd_pr__nfet_01v8_lvt ad=0.1554 pd=1.16 as=0.1036 ps=1.02 w=0.74 l=0.15
X758 VDPWR sar9b_0.net38 a_13347_20532# VDPWR sky130_fd_pr__pfet_01v8_hvt ad=0.11455 pd=1.08 as=0.2054 ps=2.1 w=0.79 l=0.15
X759 a_14077_19988# a_12887_19988# a_13968_19988# VGND sky130_fd_pr__special_nfet_01v8 ad=0.0669 pd=0.75 as=0.0711 ps=0.755 w=0.36 l=0.15
X760 th_dif_sw_0.VCN single_9b_cdac_0.cdac_sw_9b_0.S[0] sky130_fd_pr__cap_mim_m3_1 l=2 w=2
X761 sar9b_0.clk_div_0.COUNT\[1\] a_8951_23770# VGND VGND sky130_fd_pr__nfet_01v8 ad=0.169 pd=1.82 as=0.08775 ps=0.92 w=0.65 l=0.15
X762 dw_12589_1395# a_10166_3438# sky130_fd_pr__cap_mim_m3_1 l=2 w=2
X763 VGND a_9132_7271# th_dif_sw_0.th_sw_1.CK VGND sky130_fd_pr__nfet_01v8_lvt ad=0.1554 pd=1.16 as=0.1036 ps=1.02 w=0.74 l=0.15
X764 a_7782_25972# a_6705_25978# a_7620_26350# VDPWR sky130_fd_pr__pfet_01v8_hvt ad=0.0567 pd=0.69 as=0.0588 ps=0.7 w=0.42 l=0.15
X765 VGND single_9b_cdac_1.cdac_sw_9b_0.cdac_sw_3_4.tg_sw_3_3.SWN single_9b_cdac_1.cdac_sw_9b_0.cdac_sw_3_4.tg_sw_3_3.SWP VGND sky130_fd_pr__nfet_01v8_lvt ad=0.1295 pd=1.09 as=0.1036 ps=1.02 w=0.74 l=0.15
X766 a_44418_26990# single_9b_cdac_0.cdac_sw_9b_0.cdac_sw_3_3.nooverlap_clk_0.CLK0 single_9b_cdac_0.cdac_sw_9b_0.S[4] VGND sky130_fd_pr__nfet_01v8 ad=0.145 pd=1.58 as=0.145 ps=1.58 w=0.5 l=0.5
X767 single_9b_cdac_0.cdac_sw_9b_0.cdac_sw_3_4.nooverlap_clk_0.CLK0 single_9b_cdac_0.cdac_sw_9b_0.cdac_sw_3_4.nooverlap_clk_0.CLKB0 VDPWR VDPWR sky130_fd_pr__pfet_01v8 ad=0.168 pd=1.42 as=0.196 ps=1.47 w=1.12 l=0.15
X768 th_dif_sw_0.VCP single_9b_cdac_1.cdac_sw_9b_0.S[0] sky130_fd_pr__cap_mim_m3_1 l=2 w=2
X769 a_9157_24340# a_9113_24582# a_8991_24340# VGND sky130_fd_pr__nfet_01v8 ad=0.0441 pd=0.63 as=0.1401 ps=1.1 w=0.42 l=0.15
X770 single_9b_cdac_1.cdac_sw_9b_0.cdac_sw_3_0.nooverlap_clk_0.sky130_fd_sc_hs__inv_8_0.A single_9b_cdac_1.cdac_sw_9b_0.cdac_sw_3_0.nooverlap_clk_0.x1.A VGND VGND sky130_fd_pr__nfet_01v8_lvt ad=0.1184 pd=1.06 as=0.2331 ps=2.11 w=0.74 l=0.15
X771 th_dif_sw_0.VCN single_9b_cdac_0.cdac_sw_9b_0.S[5] sky130_fd_pr__cap_mim_m3_1 l=2 w=2
X772 VGND single_9b_cdac_0.cdac_sw_9b_0.cdac_sw_3_7.tg_sw_3_3.SWN single_9b_cdac_0.cdac_sw_9b_0.cdac_sw_3_7.tg_sw_3_3.SWP VGND sky130_fd_pr__nfet_01v8_lvt ad=0.1295 pd=1.09 as=0.1036 ps=1.02 w=0.74 l=0.15
X773 a_8484_24174# a_8085_23802# a_8358_23796# VGND sky130_fd_pr__special_nfet_01v8 ad=0.0696 pd=0.765 as=0.0621 ps=0.705 w=0.36 l=0.15
X774 VDPWR single_9b_cdac_1.cdac_sw_9b_0.cdac_sw_3_1.nooverlap_clk_0.sky130_fd_sc_hs__inv_8_0.A single_9b_cdac_1.cdac_sw_9b_0.cdac_sw_3_1.nooverlap_clk_0.CLKB0 VDPWR sky130_fd_pr__pfet_01v8 ad=0.196 pd=1.47 as=0.168 ps=1.42 w=1.12 l=0.15
X775 VDPWR sar9b_0.net4 a_10311_24890# VDPWR sky130_fd_pr__pfet_01v8_hvt ad=0.0864 pd=0.91 as=0.1664 ps=1.8 w=0.64 l=0.15
X776 VDPWR VGND VDPWR VDPWR sky130_fd_pr__pfet_01v8_hvt ad=0.2262 pd=2.26 as=0 ps=0 w=0.87 l=0.59
X777 a_5579_19676# a_5870_19566# a_5821_19444# VDPWR sky130_fd_pr__pfet_01v8_hvt ad=0.0567 pd=0.69 as=0.0882 ps=0.84 w=0.42 l=0.15
X778 VGND single_9b_cdac_1.cdac_sw_9b_0.cdac_sw_3_0.nooverlap_clk_0.sky130_fd_sc_hs__inv_8_0.A single_9b_cdac_1.cdac_sw_9b_0.cdac_sw_3_0.nooverlap_clk_0.CLKB0 VGND sky130_fd_pr__nfet_01v8_lvt ad=0.1295 pd=1.09 as=0.1036 ps=1.02 w=0.74 l=0.15
X779 VDPWR sar9b_0.FINAL a_7919_27066# VDPWR sky130_fd_pr__pfet_01v8_hvt ad=0.0864 pd=0.91 as=0.1664 ps=1.8 w=0.64 l=0.15
X780 VDPWR a_6149_23770# sar9b_0.clknet_1_1__leaf_CLK VDPWR sky130_fd_pr__pfet_01v8_hvt ad=0.14 pd=1.28 as=0.14 ps=1.28 w=1 l=0.15
X781 a_11045_23494# a_10827_23252# VGND VGND sky130_fd_pr__nfet_01v8 ad=0.0999 pd=0.985 as=0.1346 ps=1.15 w=0.64 l=0.15
X782 VGND sar9b_0.clk_div_0.COUNT\[0\] sar9b_0._02_ VGND sky130_fd_pr__nfet_01v8 ad=0.169 pd=1.82 as=0.08775 ps=0.92 w=0.65 l=0.15
X783 VDPWR a_13621_19418# a_13511_19444# VDPWR sky130_fd_pr__pfet_01v8_hvt ad=0.07035 pd=0.755 as=0.1155 ps=0.97 w=0.42 l=0.15
X784 th_dif_sw_0.VCN single_9b_cdac_0.cdac_sw_9b_0.S[3] sky130_fd_pr__cap_mim_m3_1 l=2 w=2
X785 th_dif_sw_0.VCN single_9b_cdac_0.cdac_sw_9b_0.S[4] sky130_fd_pr__cap_mim_m3_1 l=2 w=2
X786 VGND VDPWR VGND VGND sky130_fd_pr__nfet_01v8 ad=0.143 pd=1.62 as=0 ps=0 w=0.55 l=0.59
X787 a_54032_17740# single_9b_cdac_1.cdac_sw_9b_0.cdac_sw_3_0.nooverlap_clk_0.CLK0 single_9b_cdac_1.cdac_sw_9b_0.S[2] VGND sky130_fd_pr__nfet_01v8 ad=0.145 pd=1.58 as=0.145 ps=1.58 w=0.5 l=0.5
X788 th_dif_sw_0.VCN single_9b_cdac_0.cdac_sw_9b_0.S[0] sky130_fd_pr__cap_mim_m3_1 l=2 w=2
X789 VGND th_dif_sw_0.CKB a_21177_7457# VGND sky130_fd_pr__nfet_01v8_lvt ad=0.1036 pd=1.02 as=0.1036 ps=1.02 w=0.74 l=0.15
X790 a_6059_26882# sar9b_0.net3 VDPWR VDPWR sky130_fd_pr__pfet_01v8_hvt ad=0.1092 pd=1.36 as=0.07035 ps=0.755 w=0.42 l=0.15
X791 a_7363_23502# sar9b_0.clk_div_0.COUNT\[2\] a_7145_23226# VDPWR sky130_fd_pr__pfet_01v8_hvt ad=0.1375 pd=1.275 as=0.26 ps=2.52 w=1 l=0.15
X792 VDPWR a_9552_23252# a_9727_23226# VDPWR sky130_fd_pr__pfet_01v8_hvt ad=0.1134 pd=1.38 as=0.0567 ps=0.69 w=0.42 l=0.15
X793 a_14130_21442# a_13053_21076# a_13968_21076# VDPWR sky130_fd_pr__pfet_01v8_hvt ad=0.0567 pd=0.69 as=0.0588 ps=0.7 w=0.42 l=0.15
X794 a_15265_9613# th_dif_sw_0.VCP VDPWR VDPWR sky130_fd_pr__pfet_01v8 ad=0.435 pd=3.29 as=0.435 ps=3.29 w=3 l=1
X795 sar9b_0.net12 a_9635_24314# VGND VGND sky130_fd_pr__nfet_01v8 ad=0.169 pd=1.82 as=0.2087 ps=2.02 w=0.65 l=0.15
X796 a_9631_21076# a_9115_21076# a_9536_21076# VGND sky130_fd_pr__special_nfet_01v8 ad=0.0594 pd=0.69 as=0.066 ps=0.745 w=0.36 l=0.15
X797 VGND VDPWR VGND VGND sky130_fd_pr__nfet_01v8 ad=0.143 pd=1.62 as=0 ps=0 w=0.55 l=0.59
X798 VGND single_9b_cdac_0.cdac_sw_9b_0.cdac_sw_3_5.nooverlap_clk_0.sky130_fd_sc_hs__inv_8_0.A single_9b_cdac_0.cdac_sw_9b_0.cdac_sw_3_5.nooverlap_clk_0.CLKB0 VGND sky130_fd_pr__nfet_01v8_lvt ad=0.1036 pd=1.02 as=0.1036 ps=1.02 w=0.74 l=0.15
X799 VDPWR single_9b_cdac_1.cdac_sw_9b_0.cdac_sw_3_7.nooverlap_clk_0.x1.A single_9b_cdac_1.cdac_sw_9b_0.cdac_sw_3_7.nooverlap_clk_0.sky130_fd_sc_hs__inv_8_0.A VDPWR sky130_fd_pr__pfet_01v8 ad=0.3304 pd=2.83 as=0.168 ps=1.42 w=1.12 l=0.15
X800 th_dif_sw_0.VCN single_9b_cdac_0.cdac_sw_9b_0.S[0] sky130_fd_pr__cap_mim_m3_1 l=2 w=2
X801 tdc_0.phase_detector_0.INN a_16527_10454# VGND VGND sky130_fd_pr__nfet_01v8_lvt ad=0.2109 pd=2.05 as=0.15535 ps=1.17 w=0.74 l=0.15
X802 VDPWR single_9b_cdac_0.cdac_sw_9b_0.cdac_sw_3_7.nooverlap_clk_0.CLKB0 single_9b_cdac_0.cdac_sw_9b_0.cdac_sw_3_7.nooverlap_clk_0.CLK0 VDPWR sky130_fd_pr__pfet_01v8 ad=0.196 pd=1.47 as=0.168 ps=1.42 w=1.12 l=0.15
X803 VGND single_9b_cdac_0.cdac_sw_9b_0.cdac_sw_3_3.nooverlap_clk_0.x10.A single_9b_cdac_0.cdac_sw_9b_0.cdac_sw_3_3.tg_sw_3_3.SWN VGND sky130_fd_pr__nfet_01v8_lvt ad=0.2109 pd=2.05 as=0.1036 ps=1.02 w=0.74 l=0.15
X804 VGND VDPWR VGND VGND sky130_fd_pr__nfet_01v8 ad=0.143 pd=1.62 as=0 ps=0 w=0.55 l=0.59
X805 th_dif_sw_0.th_sw_1.CK a_9132_7271# VDPWR VDPWR sky130_fd_pr__pfet_01v8 ad=0.168 pd=1.42 as=0.196 ps=1.47 w=1.12 l=0.15
X806 sar9b_0.clknet_1_1__leaf_CLK a_6149_23770# VGND VGND sky130_fd_pr__nfet_01v8 ad=0.0588 pd=0.7 as=0.0588 ps=0.7 w=0.42 l=0.15
X807 ua[0] single_9b_cdac_1.cdac_sw_9b_0.cdac_sw_3_3.tg_sw_3_3.SWN ua[0] VGND sky130_fd_pr__nfet_01v8 ad=0.145 pd=1.58 as=0 ps=0 w=0.5 l=0.5
X808 VDPWR single_9b_cdac_0.cdac_sw_9b_0.cdac_sw_3_5.nooverlap_clk_0.x4.A single_9b_cdac_0.cdac_sw_9b_0.cdac_sw_3_5.nooverlap_clk_0.x6.A VDPWR sky130_fd_pr__pfet_01v8 ad=0.3864 pd=2.93 as=0.3304 ps=2.83 w=1.12 l=0.15
X809 VDPWR VGND VDPWR VDPWR sky130_fd_pr__pfet_01v8_hvt ad=0.2262 pd=2.26 as=0 ps=0 w=0.87 l=0.59
X810 VGND VDPWR VGND VGND sky130_fd_pr__nfet_01v8 ad=0.143 pd=1.62 as=0 ps=0 w=0.55 l=0.59
X811 single_9b_cdac_1.cdac_sw_9b_0.cdac_sw_3_7.nooverlap_clk_0.sky130_fd_sc_hs__inv_8_0.A single_9b_cdac_1.cdac_sw_9b_0.cdac_sw_3_7.nooverlap_clk_0.x1.A VDPWR VDPWR sky130_fd_pr__pfet_01v8 ad=0.168 pd=1.42 as=0.168 ps=1.42 w=1.12 l=0.15
X812 VDPWR single_9b_cdac_1.cdac_sw_9b_0.cdac_sw_3_0.nooverlap_clk_0.CLKB0 single_9b_cdac_1.cdac_sw_9b_0.cdac_sw_3_0.nooverlap_clk_0.CLK0 VDPWR sky130_fd_pr__pfet_01v8 ad=0.196 pd=1.47 as=0.168 ps=1.42 w=1.12 l=0.15
X813 th_dif_sw_0.VCP single_9b_cdac_1.cdac_sw_9b_0.S[0] sky130_fd_pr__cap_mim_m3_1 l=2 w=2
X814 th_dif_sw_0.VCN single_9b_cdac_0.cdac_sw_9b_0.S[0] sky130_fd_pr__cap_mim_m3_1 l=2 w=2
X815 VDPWR single_9b_cdac_0.cdac_sw_9b_0.cdac_sw_3_2.nooverlap_clk_0.x1.A single_9b_cdac_0.cdac_sw_9b_0.cdac_sw_3_2.nooverlap_clk_0.sky130_fd_sc_hs__inv_8_0.A VDPWR sky130_fd_pr__pfet_01v8 ad=0.3304 pd=2.83 as=0.168 ps=1.42 w=1.12 l=0.15
X816 ua[0] single_9b_cdac_1.cdac_sw_9b_0.cdac_sw_3_0.tg_sw_3_3.SWN ua[0] VGND sky130_fd_pr__nfet_01v8 ad=0.145 pd=1.58 as=0 ps=0 w=0.5 l=0.5
X817 VGND a_9107_22682# a_9038_22708# VGND sky130_fd_pr__nfet_01v8 ad=0.1346 pd=1.15 as=0.0999 ps=0.985 w=0.64 l=0.15
X818 single_9b_cdac_1.cdac_sw_9b_0.cdac_sw_3_1.nooverlap_clk_0.x6.A single_9b_cdac_1.cdac_sw_9b_0.cdac_sw_3_1.nooverlap_clk_0.x4.A VGND VGND sky130_fd_pr__nfet_01v8_lvt ad=0.2109 pd=2.05 as=0.2627 ps=2.19 w=0.74 l=0.15
X819 VDPWR single_9b_cdac_1.cdac_sw_9b_0.cdac_sw_3_7.nooverlap_clk_0.x1.A single_9b_cdac_1.cdac_sw_9b_0.cdac_sw_3_7.nooverlap_clk_0.sky130_fd_sc_hs__inv_8_0.A VDPWR sky130_fd_pr__pfet_01v8 ad=0.168 pd=1.42 as=0.168 ps=1.42 w=1.12 l=0.15
X820 ua[0] single_9b_cdac_0.cdac_sw_9b_0.cdac_sw_3_0.tg_sw_3_3.SWN ua[0] VGND sky130_fd_pr__nfet_01v8 ad=0.145 pd=1.58 as=0 ps=0 w=0.5 l=0.5
X821 VDPWR single_9b_cdac_0.cdac_sw_9b_0.cdac_sw_3_1.nooverlap_clk_0.x10.A single_9b_cdac_0.cdac_sw_9b_0.cdac_sw_3_1.tg_sw_3_3.SWN VDPWR sky130_fd_pr__pfet_01v8 ad=0.3304 pd=2.83 as=0.168 ps=1.42 w=1.12 l=0.15
X822 a_53154_16877# single_9b_cdac_1.SW[2] VDPWR VDPWR sky130_fd_pr__pfet_01v8 ad=0.435 pd=3.58 as=0.435 ps=3.58 w=1.5 l=0.5
X823 single_9b_cdac_1.cdac_sw_9b_0.cdac_sw_3_0.nooverlap_clk_0.CLK0 single_9b_cdac_1.cdac_sw_9b_0.cdac_sw_3_0.nooverlap_clk_0.CLKB0 VDPWR VDPWR sky130_fd_pr__pfet_01v8 ad=0.168 pd=1.42 as=0.3304 ps=2.83 w=1.12 l=0.15
X824 VGND single_9b_cdac_0.cdac_sw_9b_0.cdac_sw_3_3.nooverlap_clk_0.sky130_fd_sc_hs__inv_8_0.A single_9b_cdac_0.cdac_sw_9b_0.cdac_sw_3_3.nooverlap_clk_0.CLKB0 VGND sky130_fd_pr__nfet_01v8_lvt ad=0.1554 pd=1.16 as=0.1036 ps=1.02 w=0.74 l=0.15
X825 single_9b_cdac_1.cdac_sw_9b_0.cdac_sw_3_2.tg_sw_3_3.SWP single_9b_cdac_1.cdac_sw_9b_0.cdac_sw_3_2.tg_sw_3_3.SWN VGND VGND sky130_fd_pr__nfet_01v8_lvt ad=0.1036 pd=1.02 as=0.1295 ps=1.09 w=0.74 l=0.15
X826 single_9b_cdac_0.cdac_sw_9b_0.cdac_sw_3_1.tg_sw_3_3.SWN single_9b_cdac_0.cdac_sw_9b_0.cdac_sw_3_1.nooverlap_clk_0.x10.A VDPWR VDPWR sky130_fd_pr__pfet_01v8 ad=0.168 pd=1.42 as=0.196 ps=1.47 w=1.12 l=0.15
X827 single_9b_cdac_1.cdac_sw_9b_0.cdac_sw_3_7.nooverlap_clk_0.sky130_fd_sc_hs__inv_8_0.A single_9b_cdac_1.cdac_sw_9b_0.cdac_sw_3_7.nooverlap_clk_0.x1.A VDPWR VDPWR sky130_fd_pr__pfet_01v8 ad=0.168 pd=1.42 as=0.3304 ps=2.83 w=1.12 l=0.15
X828 a_9003_25972# a_8379_25978# a_8895_26350# VDPWR sky130_fd_pr__pfet_01v8_hvt ad=0.1155 pd=0.97 as=0.07245 ps=0.765 w=0.42 l=0.15
X829 a_11287_22164# a_10937_22164# a_11192_22164# VDPWR sky130_fd_pr__pfet_01v8_hvt ad=0.07245 pd=0.765 as=0.0651 ps=0.73 w=0.42 l=0.15
X830 single_9b_cdac_0.cdac_sw_9b_0.cdac_sw_3_8.nooverlap_clk_0.CLKB0 single_9b_cdac_0.cdac_sw_9b_0.cdac_sw_3_8.nooverlap_clk_0.sky130_fd_sc_hs__inv_8_0.A VGND VGND sky130_fd_pr__nfet_01v8_lvt ad=0.1036 pd=1.02 as=0.1554 ps=1.16 w=0.74 l=0.15
X831 VGND sar9b_0.net32 a_13899_25972# VGND sky130_fd_pr__nfet_01v8 ad=0.0754 pd=0.81 as=0.1352 ps=1.56 w=0.52 l=0.15
X832 a_12793_18330# a_12575_18734# VDPWR VDPWR sky130_fd_pr__pfet_01v8_hvt ad=0.12915 pd=1.185 as=0.2184 ps=2.2 w=0.84 l=0.15
X833 th_dif_sw_0.VCN single_9b_cdac_0.cdac_sw_9b_0.S[1] sky130_fd_pr__cap_mim_m3_1 l=2 w=2
X834 single_9b_cdac_1.cdac_sw_9b_0.cdac_sw_3_3.nooverlap_clk_0.sky130_fd_sc_hs__inv_8_0.A single_9b_cdac_1.cdac_sw_9b_0.cdac_sw_3_3.nooverlap_clk_0.x1.A VGND VGND sky130_fd_pr__nfet_01v8_lvt ad=0.1184 pd=1.06 as=0.2331 ps=2.11 w=0.74 l=0.15
X835 VDPWR single_9b_cdac_0.cdac_sw_9b_0.cdac_sw_3_8.nooverlap_clk_0.x10.A single_9b_cdac_0.cdac_sw_9b_0.cdac_sw_3_8.tg_sw_3_3.SWN VDPWR sky130_fd_pr__pfet_01v8 ad=0.196 pd=1.47 as=0.168 ps=1.42 w=1.12 l=0.15
X836 VGND a_6651_23520# a_6609_23252# VGND sky130_fd_pr__nfet_01v8 ad=0.1092 pd=1.36 as=0.066 ps=0.745 w=0.42 l=0.15
X837 VGND single_9b_cdac_1.cdac_sw_9b_0.cdac_sw_3_6.tg_sw_3_3.SWN single_9b_cdac_1.cdac_sw_9b_0.cdac_sw_3_6.tg_sw_3_3.SWP VGND sky130_fd_pr__nfet_01v8_lvt ad=0.2146 pd=2.06 as=0.1036 ps=1.02 w=0.74 l=0.15
X838 VGND single_9b_cdac_1.cdac_sw_9b_0.cdac_sw_3_3.nooverlap_clk_0.sky130_fd_sc_hs__inv_8_0.A single_9b_cdac_1.cdac_sw_9b_0.cdac_sw_3_3.nooverlap_clk_0.CLKB0 VGND sky130_fd_pr__nfet_01v8_lvt ad=0.1295 pd=1.09 as=0.1036 ps=1.02 w=0.74 l=0.15
X839 single_9b_cdac_0.cdac_sw_9b_0.cdac_sw_3_5.tg_sw_3_3.SWP single_9b_cdac_0.cdac_sw_9b_0.cdac_sw_3_5.tg_sw_3_3.SWN VDPWR VDPWR sky130_fd_pr__pfet_01v8 ad=0.168 pd=1.42 as=0.3864 ps=2.93 w=1.12 l=0.15
X840 th_dif_sw_0.VCN single_9b_cdac_0.cdac_sw_9b_0.S[4] sky130_fd_pr__cap_mim_m3_1 l=2 w=2
X841 th_dif_sw_0.VCN single_9b_cdac_0.cdac_sw_9b_0.S[3] sky130_fd_pr__cap_mim_m3_1 l=2 w=2
X842 VGND a_21177_7457# th_dif_sw_0.th_sw_1.CKB VGND sky130_fd_pr__nfet_01v8_lvt ad=0.1036 pd=1.02 as=0.1036 ps=1.02 w=0.74 l=0.15
X843 VDPWR tdc_0.OUTP tdc_0.OUTN VDPWR sky130_fd_pr__pfet_01v8 ad=0.3192 pd=2.81 as=0.168 ps=1.42 w=1.12 l=0.15
X844 single_9b_cdac_1.CF[2] a_13899_21620# VGND VGND sky130_fd_pr__nfet_01v8 ad=0.1352 pd=1.56 as=0.0754 ps=0.81 w=0.52 l=0.15
X845 th_dif_sw_0.VCP single_9b_cdac_1.cdac_sw_9b_0.S[0] sky130_fd_pr__cap_mim_m3_1 l=2 w=2
X846 single_9b_cdac_0.cdac_sw_9b_0.cdac_sw_3_8.tg_sw_3_3.SWN single_9b_cdac_0.cdac_sw_9b_0.cdac_sw_3_8.nooverlap_clk_0.x10.A VDPWR VDPWR sky130_fd_pr__pfet_01v8 ad=0.168 pd=1.42 as=0.168 ps=1.42 w=1.12 l=0.15
X847 VGND sar9b_0.net15 a_13665_25250# VGND sky130_fd_pr__nfet_01v8 ad=0.1346 pd=1.15 as=0.0441 ps=0.63 w=0.42 l=0.15
X848 a_44418_17740# single_9b_cdac_1.cdac_sw_9b_0.cdac_sw_3_3.nooverlap_clk_0.CLK0 single_9b_cdac_1.cdac_sw_9b_0.S[4] VGND sky130_fd_pr__nfet_01v8 ad=0.145 pd=1.58 as=0.145 ps=1.58 w=0.5 l=0.5
X849 VGND single_9b_cdac_1.SW[4] a_44418_17740# VGND sky130_fd_pr__nfet_01v8 ad=0.145 pd=1.58 as=0.145 ps=1.58 w=0.5 l=0.5
X850 single_9b_cdac_1.cdac_sw_9b_0.S[1] single_9b_cdac_1.cdac_sw_9b_0.cdac_sw_3_1.tg_sw_3_3.SWN ua[0] VDPWR sky130_fd_pr__pfet_01v8 ad=0.435 pd=3.58 as=0.435 ps=3.58 w=1.5 l=0.5
X851 a_13968_21076# a_13053_21076# a_13621_21318# VGND sky130_fd_pr__special_nfet_01v8 ad=0.0711 pd=0.755 as=0.0999 ps=0.985 w=0.36 l=0.15
X852 VGND VDPWR VGND VGND sky130_fd_pr__nfet_01v8 ad=0.143 pd=1.62 as=0 ps=0 w=0.55 l=0.59
X853 tdc_0.OUTN tdc_0.phase_detector_0.pd_out_0.A VDPWR VDPWR sky130_fd_pr__pfet_01v8 ad=0.168 pd=1.42 as=0.3192 ps=2.81 w=1.12 l=0.15
X854 VGND a_6149_23770# sar9b_0.clknet_1_1__leaf_CLK VGND sky130_fd_pr__nfet_01v8 ad=0.0588 pd=0.7 as=0.0588 ps=0.7 w=0.42 l=0.15
X855 single_9b_cdac_1.SW[0] a_14175_18356# VDPWR VDPWR sky130_fd_pr__pfet_01v8_hvt ad=0.2054 pd=2.1 as=0.11455 ps=1.08 w=0.79 l=0.15
X856 dw_12589_1395# a_10166_3438# sky130_fd_pr__cap_mim_m3_1 l=2 w=2
X857 th_dif_sw_0.VCN single_9b_cdac_0.cdac_sw_9b_0.S[0] sky130_fd_pr__cap_mim_m3_1 l=2 w=2
X858 th_dif_sw_0.VCN single_9b_cdac_0.cdac_sw_9b_0.S[0] sky130_fd_pr__cap_mim_m3_1 l=2 w=2
X859 th_dif_sw_0.VCN single_9b_cdac_0.cdac_sw_9b_0.S[1] sky130_fd_pr__cap_mim_m3_1 l=2 w=2
X860 a_13968_26516# a_12887_26516# a_13621_26758# VDPWR sky130_fd_pr__pfet_01v8_hvt ad=0.0588 pd=0.7 as=0.12915 ps=1.185 w=0.42 l=0.15
X861 VDPWR single_9b_cdac_0.cdac_sw_9b_0.cdac_sw_3_8.nooverlap_clk_0.x10.A single_9b_cdac_0.cdac_sw_9b_0.cdac_sw_3_8.tg_sw_3_3.SWN VDPWR sky130_fd_pr__pfet_01v8 ad=0.168 pd=1.42 as=0.168 ps=1.42 w=1.12 l=0.15
X862 ua[0] single_9b_cdac_0.cdac_sw_9b_0.cdac_sw_3_4.tg_sw_3_3.SWN ua[0] VGND sky130_fd_pr__nfet_01v8 ad=0.145 pd=1.58 as=0 ps=0 w=0.5 l=0.5
X863 single_9b_cdac_0.cdac_sw_9b_0.cdac_sw_3_1.nooverlap_clk_0.x10.A single_9b_cdac_0.cdac_sw_9b_0.cdac_sw_3_1.nooverlap_clk_0.x8.A VGND VGND sky130_fd_pr__nfet_01v8_lvt ad=0.1036 pd=1.02 as=0.2109 ps=2.05 w=0.74 l=0.15
X864 VGND a_6149_23770# sar9b_0.clknet_1_1__leaf_CLK VGND sky130_fd_pr__nfet_01v8 ad=0.0588 pd=0.7 as=0.0588 ps=0.7 w=0.42 l=0.15
X865 a_12575_18734# a_12059_18362# a_12480_18722# VGND sky130_fd_pr__special_nfet_01v8 ad=0.0594 pd=0.69 as=0.066 ps=0.745 w=0.36 l=0.15
X866 dw_12589_1395# a_10166_3438# sky130_fd_pr__cap_mim_m3_1 l=2 w=2
X867 a_21368_4076# th_dif_sw_0.th_sw_0.th_sw_main_0.VGS a_18214_3039# VGND sky130_fd_pr__nfet_01v8 ad=1.16 pd=8.58 as=1.16 ps=8.58 w=4 l=0.15
X868 single_9b_cdac_0.cdac_sw_9b_0.cdac_sw_3_8.tg_sw_3_3.SWP single_9b_cdac_0.cdac_sw_9b_0.cdac_sw_3_8.tg_sw_3_3.SWN VGND VGND sky130_fd_pr__nfet_01v8_lvt ad=0.1036 pd=1.02 as=0.1036 ps=1.02 w=0.74 l=0.15
X869 VGND single_9b_cdac_0.cdac_sw_9b_0.cdac_sw_3_6.nooverlap_clk_0.x4.A single_9b_cdac_0.cdac_sw_9b_0.cdac_sw_3_6.nooverlap_clk_0.x6.A VGND sky130_fd_pr__nfet_01v8_lvt ad=0.2627 pd=2.19 as=0.2109 ps=2.05 w=0.74 l=0.15
X870 single_9b_cdac_0.cdac_sw_9b_0.cdac_sw_3_1.nooverlap_clk_0.CLKB0 single_9b_cdac_0.cdac_sw_9b_0.cdac_sw_3_1.nooverlap_clk_0.sky130_fd_sc_hs__inv_8_0.A VDPWR VDPWR sky130_fd_pr__pfet_01v8 ad=0.168 pd=1.42 as=0.196 ps=1.47 w=1.12 l=0.15
X871 VGND VDPWR VGND VGND sky130_fd_pr__nfet_01v8 ad=0.143 pd=1.62 as=0 ps=0 w=0.55 l=0.59
X872 VGND VDPWR VGND VGND sky130_fd_pr__nfet_01v8 ad=0.143 pd=1.62 as=0 ps=0 w=0.55 l=0.59
X873 th_dif_sw_0.VCP single_9b_cdac_1.cdac_sw_9b_0.S[1] sky130_fd_pr__cap_mim_m3_1 l=2 w=2
X874 a_7417_27279# sar9b_0.net19 VGND VGND sky130_fd_pr__nfet_01v8 ad=0.1352 pd=1.56 as=0.0754 ps=0.81 w=0.52 l=0.15
X875 single_9b_cdac_0.cdac_sw_9b_0.S[2] single_9b_cdac_0.cdac_sw_9b_0.cdac_sw_3_0.tg_sw_3_3.SWN ua[0] VDPWR sky130_fd_pr__pfet_01v8 ad=0.435 pd=3.58 as=0.435 ps=3.58 w=1.5 l=0.5
X876 a_38738_16877# single_9b_cdac_1.SW[5] VDPWR VDPWR sky130_fd_pr__pfet_01v8 ad=0.435 pd=3.58 as=0.435 ps=3.58 w=1.5 l=0.5
X877 th_dif_sw_0.VCN single_9b_cdac_0.cdac_sw_9b_0.S[3] sky130_fd_pr__cap_mim_m3_1 l=2 w=2
X878 a_9727_23226# a_9552_23252# a_9906_23252# VGND sky130_fd_pr__nfet_01v8 ad=0.1092 pd=1.36 as=0.06405 ps=0.725 w=0.42 l=0.15
X879 VDPWR sar9b_0.clknet_1_0__leaf_CLK a_6907_19444# VDPWR sky130_fd_pr__pfet_01v8_hvt ad=0.165 pd=1.33 as=0.265 ps=2.53 w=1 l=0.15
X880 th_dif_sw_0.VCN single_9b_cdac_0.cdac_sw_9b_0.S[2] sky130_fd_pr__cap_mim_m3_1 l=2 w=2
X881 single_9b_cdac_0.cdac_sw_9b_0.S[8] single_9b_cdac_0.cdac_sw_9b_0.cdac_sw_3_8.tg_sw_3_3.SWP single_9b_cdac_0.cdac_sw_9b_0.S[8] VDPWR sky130_fd_pr__pfet_01v8 ad=0.435 pd=3.58 as=0 ps=0 w=1.5 l=0.5
X882 single_9b_cdac_1.cdac_sw_9b_0.cdac_sw_3_7.nooverlap_clk_0.CLK0 single_9b_cdac_1.cdac_sw_9b_0.cdac_sw_3_7.nooverlap_clk_0.CLKB0 VGND VGND sky130_fd_pr__nfet_01v8_lvt ad=0.1036 pd=1.02 as=0.1295 ps=1.09 w=0.74 l=0.15
X883 VDPWR single_9b_cdac_1.cdac_sw_9b_0.cdac_sw_3_4.nooverlap_clk_0.sky130_fd_sc_hs__inv_8_0.A single_9b_cdac_1.cdac_sw_9b_0.cdac_sw_3_4.nooverlap_clk_0.CLKB0 VDPWR sky130_fd_pr__pfet_01v8 ad=0.196 pd=1.47 as=0.168 ps=1.42 w=1.12 l=0.15
X884 dw_12589_1395# a_10166_3438# sky130_fd_pr__cap_mim_m3_1 l=2 w=2
X885 a_13403_19988# a_13053_19988# a_13308_19988# VDPWR sky130_fd_pr__pfet_01v8_hvt ad=0.07245 pd=0.765 as=0.0651 ps=0.73 w=0.42 l=0.15
X886 single_9b_cdac_1.cdac_sw_9b_0.cdac_sw_3_6.nooverlap_clk_0.x8.A single_9b_cdac_1.cdac_sw_9b_0.cdac_sw_3_6.nooverlap_clk_0.x6.A VGND VGND sky130_fd_pr__nfet_01v8_lvt ad=0.2109 pd=2.05 as=0.2627 ps=2.19 w=0.74 l=0.15
X887 VGND single_9b_cdac_1.cdac_sw_9b_0.cdac_sw_3_0.nooverlap_clk_0.sky130_fd_sc_hs__inv_8_0.A single_9b_cdac_1.cdac_sw_9b_0.cdac_sw_3_0.nooverlap_clk_0.CLKB0 VGND sky130_fd_pr__nfet_01v8_lvt ad=0.1036 pd=1.02 as=0.1036 ps=1.02 w=0.74 l=0.15
X888 th_dif_sw_0.VCN single_9b_cdac_0.cdac_sw_9b_0.S[0] sky130_fd_pr__cap_mim_m3_1 l=2 w=2
X889 th_dif_sw_0.VCN single_9b_cdac_0.cdac_sw_9b_0.S[0] sky130_fd_pr__cap_mim_m3_1 l=2 w=2
X890 a_11121_23802# a_10955_23802# VGND VGND sky130_fd_pr__nfet_01v8 ad=0.1092 pd=1.36 as=0.0567 ps=0.69 w=0.42 l=0.15
X891 VGND sar9b_0._15_ a_7889_21076# VGND sky130_fd_pr__nfet_01v8 ad=0.13165 pd=1.14 as=0.0441 ps=0.63 w=0.42 l=0.15
X892 single_9b_cdac_0.cdac_sw_9b_0.S[2] single_9b_cdac_0.cdac_sw_9b_0.cdac_sw_3_0.nooverlap_clk_0.CLKB0 a_53154_26999# VDPWR sky130_fd_pr__pfet_01v8 ad=0.435 pd=3.58 as=0.435 ps=3.58 w=1.5 l=0.5
X893 single_9b_cdac_1.cdac_sw_9b_0.cdac_sw_3_4.nooverlap_clk_0.CLKB0 single_9b_cdac_1.cdac_sw_9b_0.cdac_sw_3_4.nooverlap_clk_0.sky130_fd_sc_hs__inv_8_0.A VDPWR VDPWR sky130_fd_pr__pfet_01v8 ad=0.168 pd=1.42 as=0.168 ps=1.42 w=1.12 l=0.15
X894 th_dif_sw_0.VCP single_9b_cdac_1.cdac_sw_9b_0.S[1] sky130_fd_pr__cap_mim_m3_1 l=2 w=2
X895 a_9132_7271# th_dif_sw_0.CK VGND VGND sky130_fd_pr__nfet_01v8_lvt ad=0.1036 pd=1.02 as=0.1036 ps=1.02 w=0.74 l=0.15
X896 VGND single_9b_cdac_0.SW[8] a_25210_26990# VGND sky130_fd_pr__nfet_01v8 ad=0.145 pd=1.58 as=0.145 ps=1.58 w=0.5 l=0.5
X897 single_9b_cdac_1.cdac_sw_9b_0.S[2] single_9b_cdac_1.cdac_sw_9b_0.cdac_sw_3_0.tg_sw_3_3.SWN ua[0] VDPWR sky130_fd_pr__pfet_01v8 ad=0.435 pd=3.58 as=0.435 ps=3.58 w=1.5 l=0.5
X898 VDPWR single_9b_cdac_1.cdac_sw_9b_0.cdac_sw_3_2.nooverlap_clk_0.x8.A single_9b_cdac_1.cdac_sw_9b_0.cdac_sw_3_2.nooverlap_clk_0.sky130_fd_sc_hs__nand2_1_0.Y VDPWR sky130_fd_pr__pfet_01v8 ad=0.3192 pd=2.81 as=0.168 ps=1.42 w=1.12 l=0.15
X899 single_9b_cdac_1.cdac_sw_9b_0.cdac_sw_3_1.tg_sw_3_3.SWN single_9b_cdac_1.cdac_sw_9b_0.cdac_sw_3_1.nooverlap_clk_0.x10.A VDPWR VDPWR sky130_fd_pr__pfet_01v8 ad=0.168 pd=1.42 as=0.3304 ps=2.83 w=1.12 l=0.15
X900 VDPWR VGND VDPWR VDPWR sky130_fd_pr__pfet_01v8_hvt ad=0.2262 pd=2.26 as=0 ps=0 w=0.87 l=0.59
X901 a_8910_20532# a_8471_20538# a_8825_20532# VGND sky130_fd_pr__special_nfet_01v8 ad=0.0621 pd=0.705 as=0.0813 ps=0.83 w=0.36 l=0.15
X902 th_dif_sw_0.VCP single_9b_cdac_1.cdac_sw_9b_0.S[0] sky130_fd_pr__cap_mim_m3_1 l=2 w=2
X903 a_21368_4076# th_dif_sw_0.th_sw_0.th_sw_main_0.VGS ua[1] VGND sky130_fd_pr__nfet_01v8 ad=1.16 pd=8.58 as=1.16 ps=8.58 w=4 l=0.15
X904 single_9b_cdac_0.cdac_sw_9b_0.cdac_sw_3_4.nooverlap_clk_0.x10.A single_9b_cdac_0.cdac_sw_9b_0.cdac_sw_3_4.nooverlap_clk_0.x8.A VGND VGND sky130_fd_pr__nfet_01v8_lvt ad=0.1184 pd=1.06 as=0.1221 ps=1.07 w=0.74 l=0.15
X905 VGND sar9b_0.net38 a_13347_20532# VGND sky130_fd_pr__nfet_01v8 ad=0.0754 pd=0.81 as=0.1352 ps=1.56 w=0.52 l=0.15
X906 VGND sar9b_0.net4 a_8287_19450# VGND sky130_fd_pr__nfet_01v8 ad=0.0567 pd=0.69 as=0.1092 ps=1.36 w=0.42 l=0.15
X907 VDPWR single_9b_cdac_1.cdac_sw_9b_0.cdac_sw_3_4.nooverlap_clk_0.sky130_fd_sc_hs__inv_8_0.A single_9b_cdac_1.cdac_sw_9b_0.cdac_sw_3_4.nooverlap_clk_0.CLKB0 VDPWR sky130_fd_pr__pfet_01v8 ad=0.168 pd=1.42 as=0.168 ps=1.42 w=1.12 l=0.15
X908 th_dif_sw_0.VCN single_9b_cdac_0.cdac_sw_9b_0.S[2] sky130_fd_pr__cap_mim_m3_1 l=2 w=2
X909 VDPWR single_9b_cdac_0.cdac_sw_9b_0.cdac_sw_3_7.nooverlap_clk_0.x8.A single_9b_cdac_0.cdac_sw_9b_0.cdac_sw_3_7.nooverlap_clk_0.x10.A VDPWR sky130_fd_pr__pfet_01v8 ad=0.3304 pd=2.83 as=0.168 ps=1.42 w=1.12 l=0.15
X910 a_9727_21076# a_9281_21076# a_9631_21076# VGND sky130_fd_pr__special_nfet_01v8 ad=0.1401 pd=1.1 as=0.0594 ps=0.69 w=0.36 l=0.15
X911 single_9b_cdac_1.cdac_sw_9b_0.S[3] single_9b_cdac_1.cdac_sw_9b_0.cdac_sw_3_4.nooverlap_clk_0.CLKB0 a_48343_16877# VDPWR sky130_fd_pr__pfet_01v8 ad=0.435 pd=3.58 as=0.435 ps=3.58 w=1.5 l=0.5
X912 a_5856_26516# sar9b_0.net36 VGND VGND sky130_fd_pr__nfet_01v8 ad=0.066 pd=0.745 as=0.2205 ps=1.89 w=0.42 l=0.15
X913 VGND single_9b_cdac_0.cdac_sw_9b_0.cdac_sw_3_3.nooverlap_clk_0.x10.A single_9b_cdac_0.cdac_sw_9b_0.cdac_sw_3_3.tg_sw_3_3.SWN VGND sky130_fd_pr__nfet_01v8_lvt ad=0.1036 pd=1.02 as=0.1036 ps=1.02 w=0.74 l=0.15
X914 a_11567_19748# a_11392_19822# a_11746_19810# VGND sky130_fd_pr__nfet_01v8 ad=0.1092 pd=1.36 as=0.06405 ps=0.725 w=0.42 l=0.15
X915 single_9b_cdac_1.cdac_sw_9b_0.cdac_sw_3_2.nooverlap_clk_0.sky130_fd_sc_hs__nand2_1_0.Y single_9b_cdac_1.CF[0] VDPWR VDPWR sky130_fd_pr__pfet_01v8 ad=0.168 pd=1.42 as=0.3192 ps=2.81 w=1.12 l=0.15
X916 th_dif_sw_0.VCP single_9b_cdac_1.cdac_sw_9b_0.S[1] sky130_fd_pr__cap_mim_m3_1 l=2 w=2
X917 VGND VDPWR VGND VGND sky130_fd_pr__nfet_01v8 ad=0.143 pd=1.62 as=0 ps=0 w=0.55 l=0.59
X918 sar9b_0.clknet_0_CLK a_7345_21594# VDPWR VDPWR sky130_fd_pr__pfet_01v8_hvt ad=0.14 pd=1.28 as=0.1375 ps=1.275 w=1 l=0.15
X919 single_9b_cdac_1.cdac_sw_9b_0.cdac_sw_3_4.nooverlap_clk_0.CLKB0 single_9b_cdac_1.cdac_sw_9b_0.cdac_sw_3_4.nooverlap_clk_0.sky130_fd_sc_hs__inv_8_0.A VDPWR VDPWR sky130_fd_pr__pfet_01v8 ad=0.168 pd=1.42 as=0.196 ps=1.47 w=1.12 l=0.15
X920 VDPWR a_9132_7271# th_dif_sw_0.th_sw_1.CK VDPWR sky130_fd_pr__pfet_01v8 ad=0.168 pd=1.42 as=0.168 ps=1.42 w=1.12 l=0.15
X921 a_8431_22682# a_8634_22840# VDPWR VDPWR sky130_fd_pr__pfet_01v8_hvt ad=0.0567 pd=0.69 as=0.1134 ps=1.38 w=0.42 l=0.15
X922 th_dif_sw_0.VCN single_9b_cdac_0.cdac_sw_9b_0.S[1] sky130_fd_pr__cap_mim_m3_1 l=2 w=2
X923 th_dif_sw_0.th_sw_1.CKB a_21177_7457# VGND VGND sky130_fd_pr__nfet_01v8_lvt ad=0.1036 pd=1.02 as=0.1554 ps=1.16 w=0.74 l=0.15
X924 a_12198_23796# a_11121_23802# a_12036_24174# VDPWR sky130_fd_pr__pfet_01v8_hvt ad=0.0567 pd=0.69 as=0.0588 ps=0.7 w=0.42 l=0.15
X925 single_9b_cdac_1.cdac_sw_9b_0.cdac_sw_3_5.nooverlap_clk_0.CLK0 single_9b_cdac_1.cdac_sw_9b_0.cdac_sw_3_5.nooverlap_clk_0.CLKB0 VGND VGND sky130_fd_pr__nfet_01v8_lvt ad=0.1036 pd=1.02 as=0.2109 ps=2.05 w=0.74 l=0.15
X926 single_9b_cdac_0.cdac_sw_9b_0.S[5] single_9b_cdac_0.cdac_sw_9b_0.cdac_sw_3_5.tg_sw_3_3.SWN ua[0] VDPWR sky130_fd_pr__pfet_01v8 ad=0.435 pd=3.58 as=0.435 ps=3.58 w=1.5 l=0.5
X927 VDPWR single_9b_cdac_0.cdac_sw_9b_0.cdac_sw_3_0.tg_sw_3_3.SWN single_9b_cdac_0.cdac_sw_9b_0.cdac_sw_3_0.tg_sw_3_3.SWP VDPWR sky130_fd_pr__pfet_01v8 ad=0.3304 pd=2.83 as=0.168 ps=1.42 w=1.12 l=0.15
X928 VDPWR tdc_0.OUTP a_12427_17812# VDPWR sky130_fd_pr__pfet_01v8_hvt ad=0.1625 pd=1.325 as=0.265 ps=2.53 w=1 l=0.15
X929 VGND single_9b_cdac_0.cdac_sw_9b_0.cdac_sw_3_1.nooverlap_clk_0.x1.A single_9b_cdac_0.cdac_sw_9b_0.cdac_sw_3_1.nooverlap_clk_0.sky130_fd_sc_hs__inv_8_0.A VGND sky130_fd_pr__nfet_01v8_lvt ad=0.2331 pd=2.11 as=0.1184 ps=1.06 w=0.74 l=0.15
X930 sar9b_0.net20 a_7795_26276# VGND VGND sky130_fd_pr__nfet_01v8 ad=0.169 pd=1.82 as=0.2087 ps=2.02 w=0.65 l=0.15
X931 VGND a_5487_27034# sar9b_0.net17 VGND sky130_fd_pr__nfet_01v8 ad=0.2087 pd=2.02 as=0.169 ps=1.82 w=0.65 l=0.15
X932 a_14143_18874# sar9b_0.net15 VDPWR VDPWR sky130_fd_pr__pfet_01v8_hvt ad=0.0567 pd=0.69 as=0.0819 ps=0.81 w=0.42 l=0.15
X933 th_dif_sw_0.VCN single_9b_cdac_0.cdac_sw_9b_0.S[0] sky130_fd_pr__cap_mim_m3_1 l=2 w=2
X934 single_9b_cdac_0.cdac_sw_9b_0.cdac_sw_3_0.tg_sw_3_3.SWP single_9b_cdac_0.cdac_sw_9b_0.cdac_sw_3_0.tg_sw_3_3.SWN VDPWR VDPWR sky130_fd_pr__pfet_01v8 ad=0.168 pd=1.42 as=0.196 ps=1.47 w=1.12 l=0.15
X935 a_10371_26490# a_10196_26516# a_10550_26516# VGND sky130_fd_pr__nfet_01v8 ad=0.1092 pd=1.36 as=0.06405 ps=0.725 w=0.42 l=0.15
X936 VGND single_9b_cdac_0.cdac_sw_9b_0.cdac_sw_3_6.tg_sw_3_3.SWN single_9b_cdac_0.cdac_sw_9b_0.cdac_sw_3_6.tg_sw_3_3.SWP VGND sky130_fd_pr__nfet_01v8_lvt ad=0.2109 pd=2.05 as=0.1036 ps=1.02 w=0.74 l=0.15
X937 th_dif_sw_0.VCN single_9b_cdac_0.cdac_sw_9b_0.S[0] sky130_fd_pr__cap_mim_m3_1 l=2 w=2
X938 VDPWR tdc_0.phase_detector_0.pd_out_0.A a_16185_13034# VDPWR sky130_fd_pr__pfet_01v8 ad=0.2352 pd=1.54 as=0.3752 ps=2.91 w=1.12 l=0.15
X939 a_54032_26990# single_9b_cdac_0.cdac_sw_9b_0.cdac_sw_3_0.nooverlap_clk_0.CLK0 single_9b_cdac_0.cdac_sw_9b_0.S[2] VGND sky130_fd_pr__nfet_01v8 ad=0.145 pd=1.58 as=0.145 ps=1.58 w=0.5 l=0.5
X940 VGND VDPWR VGND VGND sky130_fd_pr__nfet_01v8 ad=0.143 pd=1.62 as=0 ps=0 w=0.55 l=0.59
X941 th_dif_sw_0.VCN single_9b_cdac_0.cdac_sw_9b_0.S[0] sky130_fd_pr__cap_mim_m3_1 l=2 w=2
X942 VDPWR single_9b_cdac_1.cdac_sw_9b_0.cdac_sw_3_7.nooverlap_clk_0.sky130_fd_sc_hs__inv_8_0.A single_9b_cdac_1.cdac_sw_9b_0.cdac_sw_3_7.nooverlap_clk_0.CLKB0 VDPWR sky130_fd_pr__pfet_01v8 ad=0.196 pd=1.47 as=0.168 ps=1.42 w=1.12 l=0.15
X943 th_dif_sw_0.VCN single_9b_cdac_0.cdac_sw_9b_0.S[2] sky130_fd_pr__cap_mim_m3_1 l=2 w=2
X944 VDPWR single_9b_cdac_0.cdac_sw_9b_0.cdac_sw_3_5.nooverlap_clk_0.x6.A single_9b_cdac_0.cdac_sw_9b_0.cdac_sw_3_5.nooverlap_clk_0.x8.A VDPWR sky130_fd_pr__pfet_01v8 ad=0.3864 pd=2.93 as=0.3304 ps=2.83 w=1.12 l=0.15
X945 th_dif_sw_0.VCP single_9b_cdac_1.cdac_sw_9b_0.S[0] sky130_fd_pr__cap_mim_m3_1 l=2 w=2
X946 VGND VDPWR VGND VGND sky130_fd_pr__nfet_01v8 ad=0.143 pd=1.62 as=0 ps=0 w=0.55 l=0.59
X947 a_13665_19810# a_13621_19418# a_13499_19822# VGND sky130_fd_pr__nfet_01v8 ad=0.0441 pd=0.63 as=0.1401 ps=1.1 w=0.42 l=0.15
X948 th_dif_sw_0.th_sw_1.CKB a_21177_7457# VDPWR VDPWR sky130_fd_pr__pfet_01v8 ad=0.168 pd=1.42 as=0.168 ps=1.42 w=1.12 l=0.15
X949 VGND single_9b_cdac_1.cdac_sw_9b_0.cdac_sw_3_3.nooverlap_clk_0.sky130_fd_sc_hs__inv_8_0.A single_9b_cdac_1.cdac_sw_9b_0.cdac_sw_3_3.nooverlap_clk_0.CLKB0 VGND sky130_fd_pr__nfet_01v8_lvt ad=0.1036 pd=1.02 as=0.1036 ps=1.02 w=0.74 l=0.15
X950 single_9b_cdac_1.cdac_sw_9b_0.cdac_sw_3_0.tg_sw_3_3.SWP single_9b_cdac_1.cdac_sw_9b_0.cdac_sw_3_0.tg_sw_3_3.SWN VGND VGND sky130_fd_pr__nfet_01v8_lvt ad=0.1036 pd=1.02 as=0.1554 ps=1.16 w=0.74 l=0.15
X951 single_9b_cdac_1.cdac_sw_9b_0.cdac_sw_3_1.tg_sw_3_3.SWP single_9b_cdac_1.cdac_sw_9b_0.cdac_sw_3_1.tg_sw_3_3.SWN VGND VGND sky130_fd_pr__nfet_01v8_lvt ad=0.1036 pd=1.02 as=0.1036 ps=1.02 w=0.74 l=0.15
X952 th_dif_sw_0.VCP single_9b_cdac_1.cdac_sw_9b_0.S[1] sky130_fd_pr__cap_mim_m3_1 l=2 w=2
X953 th_dif_sw_0.VCN single_9b_cdac_0.cdac_sw_9b_0.S[1] sky130_fd_pr__cap_mim_m3_1 l=2 w=2
X954 sar9b_0.clknet_1_0__leaf_CLK a_6701_20506# VGND VGND sky130_fd_pr__nfet_01v8 ad=0.0588 pd=0.7 as=0.0588 ps=0.7 w=0.42 l=0.15
X955 a_13315_18660# sar9b_0.net15 VDPWR VDPWR sky130_fd_pr__pfet_01v8_hvt ad=0.0567 pd=0.69 as=0.0819 ps=0.81 w=0.42 l=0.15
X956 th_dif_sw_0.VCN single_9b_cdac_0.cdac_sw_9b_0.S[0] sky130_fd_pr__cap_mim_m3_1 l=2 w=2
X957 th_dif_sw_0.VCP single_9b_cdac_1.cdac_sw_9b_0.S[1] sky130_fd_pr__cap_mim_m3_1 l=2 w=2
X958 a_25210_26990# single_9b_cdac_0.cdac_sw_9b_0.cdac_sw_3_8.nooverlap_clk_0.CLK0 single_9b_cdac_0.cdac_sw_9b_0.S[8] VGND sky130_fd_pr__nfet_01v8 ad=0.145 pd=1.58 as=0.145 ps=1.58 w=0.5 l=0.5
X959 VDPWR VGND VDPWR VDPWR sky130_fd_pr__pfet_01v8_hvt ad=0.2262 pd=2.26 as=0 ps=0 w=0.87 l=0.59
X960 a_13308_22164# sar9b_0.net1 VDPWR VDPWR sky130_fd_pr__pfet_01v8_hvt ad=0.0651 pd=0.73 as=0.1092 ps=1.36 w=0.42 l=0.15
X961 a_10358_21442# a_9281_21076# a_10196_21076# VDPWR sky130_fd_pr__pfet_01v8_hvt ad=0.0567 pd=0.69 as=0.0588 ps=0.7 w=0.42 l=0.15
X962 VDPWR single_9b_cdac_0.cdac_sw_9b_0.cdac_sw_3_8.nooverlap_clk_0.CLKB0 single_9b_cdac_0.cdac_sw_9b_0.cdac_sw_3_8.nooverlap_clk_0.CLK0 VDPWR sky130_fd_pr__pfet_01v8 ad=0.196 pd=1.47 as=0.168 ps=1.42 w=1.12 l=0.15
X963 VGND a_7345_21594# sar9b_0.clknet_0_CLK VGND sky130_fd_pr__nfet_01v8 ad=0.0588 pd=0.7 as=0.0588 ps=0.7 w=0.42 l=0.15
X964 single_9b_cdac_1.CF[0] a_13347_21620# VDPWR VDPWR sky130_fd_pr__pfet_01v8_hvt ad=0.2054 pd=2.1 as=0.11455 ps=1.08 w=0.79 l=0.15
X965 th_dif_sw_0.VCP single_9b_cdac_1.cdac_sw_9b_0.S[0] sky130_fd_pr__cap_mim_m3_1 l=2 w=2
X966 th_dif_sw_0.VCN single_9b_cdac_0.cdac_sw_9b_0.S[0] sky130_fd_pr__cap_mim_m3_1 l=2 w=2
X967 dw_17224_1400# a_18214_3039# th_dif_sw_0.th_sw_0.th_sw_main_0.VGS dw_17224_1400# sky130_fd_pr__pfet_01v8 ad=0.58 pd=4.58 as=0.58 ps=4.58 w=2 l=0.15
X968 VGND sar9b_0.net15 a_13665_25428# VGND sky130_fd_pr__nfet_01v8 ad=0.1346 pd=1.15 as=0.0441 ps=0.63 w=0.42 l=0.15
X969 a_6219_19810# a_5999_19822# VGND VGND sky130_fd_pr__nfet_01v8 ad=0.0696 pd=0.765 as=0.12095 ps=1.085 w=0.42 l=0.15
X970 VGND single_9b_cdac_0.SW[7] a_30012_26990# VGND sky130_fd_pr__nfet_01v8 ad=0.145 pd=1.58 as=0.145 ps=1.58 w=0.5 l=0.5
X971 VGND sar9b_0.net2 a_10774_20354# VGND sky130_fd_pr__nfet_01v8 ad=0.2205 pd=1.89 as=0.066 ps=0.745 w=0.42 l=0.15
X972 single_9b_cdac_0.cdac_sw_9b_0.cdac_sw_3_8.nooverlap_clk_0.CLK0 single_9b_cdac_0.cdac_sw_9b_0.cdac_sw_3_8.nooverlap_clk_0.CLKB0 VDPWR VDPWR sky130_fd_pr__pfet_01v8 ad=0.168 pd=1.42 as=0.168 ps=1.42 w=1.12 l=0.15
X973 a_7976_22414# sar9b_0._06_ VDPWR VDPWR sky130_fd_pr__pfet_01v8_hvt ad=0.0441 pd=0.63 as=0.14575 ps=1.335 w=0.42 l=0.15
X974 VGND single_9b_cdac_1.cdac_sw_9b_0.cdac_sw_3_4.tg_sw_3_3.SWN single_9b_cdac_1.cdac_sw_9b_0.cdac_sw_3_4.tg_sw_3_3.SWP VGND sky130_fd_pr__nfet_01v8_lvt ad=0.1554 pd=1.16 as=0.1036 ps=1.02 w=0.74 l=0.15
X975 dw_12589_1395# a_10166_3438# sky130_fd_pr__cap_mim_m3_1 l=2 w=2
X976 a_13419_23796# a_12795_23802# a_13311_24174# VDPWR sky130_fd_pr__pfet_01v8_hvt ad=0.1155 pd=0.97 as=0.07245 ps=0.765 w=0.42 l=0.15
X977 single_9b_cdac_1.cdac_sw_9b_0.cdac_sw_3_5.nooverlap_clk_0.sky130_fd_sc_hs__inv_1_1.A single_9b_cdac_1.cdac_sw_9b_0.cdac_sw_3_5.nooverlap_clk_0.sky130_fd_sc_hs__nand2_1_0.Y VGND VGND sky130_fd_pr__nfet_01v8_lvt ad=0.2109 pd=2.05 as=0.2627 ps=2.19 w=0.74 l=0.15
X978 single_9b_cdac_0.cdac_sw_9b_0.cdac_sw_3_5.tg_sw_3_3.SWP single_9b_cdac_0.cdac_sw_9b_0.cdac_sw_3_5.tg_sw_3_3.SWN VGND VGND sky130_fd_pr__nfet_01v8_lvt ad=0.1036 pd=1.02 as=0.1036 ps=1.02 w=0.74 l=0.15
X979 VGND single_9b_cdac_0.cdac_sw_9b_0.cdac_sw_3_0.nooverlap_clk_0.CLKB0 single_9b_cdac_0.cdac_sw_9b_0.cdac_sw_3_0.nooverlap_clk_0.CLK0 VGND sky130_fd_pr__nfet_01v8_lvt ad=0.1295 pd=1.09 as=0.1036 ps=1.02 w=0.74 l=0.15
X980 VDPWR single_9b_cdac_1.cdac_sw_9b_0.cdac_sw_3_7.nooverlap_clk_0.x1.A single_9b_cdac_1.cdac_sw_9b_0.cdac_sw_3_7.nooverlap_clk_0.x4.A VDPWR sky130_fd_pr__pfet_01v8 ad=0.3192 pd=2.81 as=0.168 ps=1.42 w=1.12 l=0.15
X981 VGND sar9b_0.net26 a_13623_24340# VGND sky130_fd_pr__nfet_01v8 ad=0.0754 pd=0.81 as=0.1352 ps=1.56 w=0.52 l=0.15
X982 VDPWR single_9b_cdac_0.cdac_sw_9b_0.cdac_sw_3_8.nooverlap_clk_0.CLKB0 single_9b_cdac_0.cdac_sw_9b_0.cdac_sw_3_8.nooverlap_clk_0.CLK0 VDPWR sky130_fd_pr__pfet_01v8 ad=0.168 pd=1.42 as=0.168 ps=1.42 w=1.12 l=0.15
X983 single_9b_cdac_1.cdac_sw_9b_0.cdac_sw_3_3.nooverlap_clk_0.x6.A single_9b_cdac_1.cdac_sw_9b_0.cdac_sw_3_3.nooverlap_clk_0.x4.A VDPWR VDPWR sky130_fd_pr__pfet_01v8 ad=0.3304 pd=2.83 as=0.3864 ps=2.93 w=1.12 l=0.15
X984 th_dif_sw_0.VCN single_9b_cdac_0.cdac_sw_9b_0.S[0] sky130_fd_pr__cap_mim_m3_1 l=2 w=2
X985 single_9b_cdac_1.cdac_sw_9b_0.cdac_sw_3_7.nooverlap_clk_0.x4.A single_9b_cdac_1.cdac_sw_9b_0.cdac_sw_3_7.nooverlap_clk_0.x3.Y VDPWR VDPWR sky130_fd_pr__pfet_01v8 ad=0.168 pd=1.42 as=0.3192 ps=2.81 w=1.12 l=0.15
X986 VGND single_9b_cdac_0.SW[4] a_44418_26990# VGND sky130_fd_pr__nfet_01v8 ad=0.145 pd=1.58 as=0.145 ps=1.58 w=0.5 l=0.5
X987 th_dif_sw_0.VCP single_9b_cdac_1.cdac_sw_9b_0.S[1] sky130_fd_pr__cap_mim_m3_1 l=2 w=2
X988 a_44418_26990# single_9b_cdac_0.cdac_sw_9b_0.cdac_sw_3_3.nooverlap_clk_0.CLK0 single_9b_cdac_0.cdac_sw_9b_0.S[4] VGND sky130_fd_pr__nfet_01v8 ad=0.145 pd=1.58 as=0.145 ps=1.58 w=0.5 l=0.5
X989 a_39616_17740# single_9b_cdac_1.cdac_sw_9b_0.cdac_sw_3_5.nooverlap_clk_0.CLK0 single_9b_cdac_1.cdac_sw_9b_0.S[5] VGND sky130_fd_pr__nfet_01v8 ad=0.145 pd=1.58 as=0.145 ps=1.58 w=0.5 l=0.5
X990 th_dif_sw_0.VCP single_9b_cdac_1.cdac_sw_9b_0.S[0] sky130_fd_pr__cap_mim_m3_1 l=2 w=2
X991 VGND a_9687_19042# a_9648_19168# VGND sky130_fd_pr__nfet_01v8 ad=0.0567 pd=0.69 as=0.1092 ps=1.36 w=0.42 l=0.15
X992 th_dif_sw_0.VCP single_9b_cdac_1.cdac_sw_9b_0.S[1] sky130_fd_pr__cap_mim_m3_1 l=2 w=2
X993 th_dif_sw_0.VCN single_9b_cdac_0.cdac_sw_9b_0.S[0] sky130_fd_pr__cap_mim_m3_1 l=2 w=2
X994 VDPWR VGND VDPWR VDPWR sky130_fd_pr__pfet_01v8_hvt ad=0.2262 pd=2.26 as=0 ps=0 w=0.87 l=0.59
X995 a_6415_25428# a_5969_25428# a_6319_25428# VGND sky130_fd_pr__special_nfet_01v8 ad=0.1401 pd=1.1 as=0.0594 ps=0.69 w=0.36 l=0.15
X996 a_14143_23012# a_13968_23086# a_14322_23074# VGND sky130_fd_pr__nfet_01v8 ad=0.1092 pd=1.36 as=0.06405 ps=0.725 w=0.42 l=0.15
X997 a_8895_24340# a_8379_24340# a_8800_24340# VGND sky130_fd_pr__special_nfet_01v8 ad=0.0594 pd=0.69 as=0.066 ps=0.745 w=0.36 l=0.15
X998 single_9b_cdac_1.cdac_sw_9b_0.S[2] single_9b_cdac_1.cdac_sw_9b_0.cdac_sw_3_0.tg_sw_3_3.SWP ua[0] VGND sky130_fd_pr__nfet_01v8 ad=0.145 pd=1.58 as=0.145 ps=1.58 w=0.5 l=0.5
X999 a_13876_24174# a_12795_23802# a_13529_23770# VDPWR sky130_fd_pr__pfet_01v8_hvt ad=0.0588 pd=0.7 as=0.12915 ps=1.185 w=0.42 l=0.15
X1000 sar9b_0.clknet_0_CLK a_7345_21594# VGND VGND sky130_fd_pr__nfet_01v8 ad=0.0588 pd=0.7 as=0.1113 ps=1.37 w=0.42 l=0.15
X1001 a_9739_26882# a_9115_26516# a_9631_26516# VDPWR sky130_fd_pr__pfet_01v8_hvt ad=0.1155 pd=0.97 as=0.07245 ps=0.765 w=0.42 l=0.15
X1002 VDPWR a_7059_25402# a_7046_25794# VDPWR sky130_fd_pr__pfet_01v8_hvt ad=0.0819 pd=0.81 as=0.0567 ps=0.69 w=0.42 l=0.15
X1003 VGND VDPWR VGND VGND sky130_fd_pr__nfet_01v8 ad=0.143 pd=1.62 as=0 ps=0 w=0.55 l=0.59
X1004 VDPWR sar9b_0.net13 a_14451_23252# VDPWR sky130_fd_pr__pfet_01v8_hvt ad=0.11455 pd=1.08 as=0.2054 ps=2.1 w=0.79 l=0.15
X1005 VDPWR a_13968_19988# a_14143_19962# VDPWR sky130_fd_pr__pfet_01v8_hvt ad=0.1134 pd=1.38 as=0.0567 ps=0.69 w=0.42 l=0.15
X1006 th_dif_sw_0.VCP single_9b_cdac_1.cdac_sw_9b_0.S[1] sky130_fd_pr__cap_mim_m3_1 l=2 w=2
X1007 a_11579_21442# a_10955_21076# a_11471_21076# VDPWR sky130_fd_pr__pfet_01v8_hvt ad=0.1155 pd=0.97 as=0.07245 ps=0.765 w=0.42 l=0.15
X1008 single_9b_cdac_1.cdac_sw_9b_0.cdac_sw_3_7.tg_sw_3_3.SWN single_9b_cdac_1.cdac_sw_9b_0.cdac_sw_3_7.nooverlap_clk_0.x10.A VGND VGND sky130_fd_pr__nfet_01v8_lvt ad=0.1036 pd=1.02 as=0.1554 ps=1.16 w=0.74 l=0.15
X1009 single_9b_cdac_1.cdac_sw_9b_0.cdac_sw_3_3.tg_sw_3_3.SWP single_9b_cdac_1.cdac_sw_9b_0.cdac_sw_3_3.tg_sw_3_3.SWN VGND VGND sky130_fd_pr__nfet_01v8_lvt ad=0.1036 pd=1.02 as=0.2109 ps=2.05 w=0.74 l=0.15
X1010 single_9b_cdac_0.cdac_sw_9b_0.cdac_sw_3_5.nooverlap_clk_0.sky130_fd_sc_hs__inv_8_0.A single_9b_cdac_0.cdac_sw_9b_0.cdac_sw_3_5.nooverlap_clk_0.x1.A VGND VGND sky130_fd_pr__nfet_01v8_lvt ad=0.1036 pd=1.02 as=0.2109 ps=2.05 w=0.74 l=0.15
X1011 VDPWR single_9b_cdac_0.cdac_sw_9b_0.cdac_sw_3_3.nooverlap_clk_0.sky130_fd_sc_hs__inv_8_0.A single_9b_cdac_0.cdac_sw_9b_0.cdac_sw_3_3.nooverlap_clk_0.CLKB0 VDPWR sky130_fd_pr__pfet_01v8 ad=0.196 pd=1.47 as=0.168 ps=1.42 w=1.12 l=0.15
X1012 VDPWR a_12211_18874# a_12198_19266# VDPWR sky130_fd_pr__pfet_01v8_hvt ad=0.0819 pd=0.81 as=0.0567 ps=0.69 w=0.42 l=0.15
X1013 dw_17224_1400# a_21368_4076# sky130_fd_pr__cap_mim_m3_1 l=2 w=2
X1014 th_dif_sw_0.VCN single_9b_cdac_0.cdac_sw_9b_0.S[0] sky130_fd_pr__cap_mim_m3_1 l=2 w=2
X1015 single_9b_cdac_0.cdac_sw_9b_0.cdac_sw_3_7.nooverlap_clk_0.CLKB0 single_9b_cdac_0.cdac_sw_9b_0.cdac_sw_3_7.nooverlap_clk_0.sky130_fd_sc_hs__inv_8_0.A VDPWR VDPWR sky130_fd_pr__pfet_01v8 ad=0.168 pd=1.42 as=0.196 ps=1.47 w=1.12 l=0.15
X1016 VGND single_9b_cdac_0.cdac_sw_9b_0.cdac_sw_3_2.nooverlap_clk_0.x8.A single_9b_cdac_0.cdac_sw_9b_0.cdac_sw_3_2.nooverlap_clk_0.x10.A VGND sky130_fd_pr__nfet_01v8_lvt ad=0.2331 pd=2.11 as=0.1184 ps=1.06 w=0.74 l=0.15
X1017 VGND VDPWR VGND VGND sky130_fd_pr__nfet_01v8 ad=0.143 pd=1.62 as=0 ps=0 w=0.55 l=0.59
X1018 VDPWR VGND VDPWR VDPWR sky130_fd_pr__pfet_01v8_hvt ad=0.2262 pd=2.26 as=0 ps=0 w=0.87 l=0.59
X1019 th_dif_sw_0.VCN single_9b_cdac_0.cdac_sw_9b_0.S[2] sky130_fd_pr__cap_mim_m3_1 l=2 w=2
X1020 VGND single_9b_cdac_0.cdac_sw_9b_0.cdac_sw_3_6.tg_sw_3_3.SWN single_9b_cdac_0.cdac_sw_9b_0.cdac_sw_3_6.tg_sw_3_3.SWP VGND sky130_fd_pr__nfet_01v8_lvt ad=0.1036 pd=1.02 as=0.1036 ps=1.02 w=0.74 l=0.15
X1021 single_9b_cdac_0.cdac_sw_9b_0.cdac_sw_3_3.nooverlap_clk_0.CLKB0 single_9b_cdac_0.cdac_sw_9b_0.cdac_sw_3_3.nooverlap_clk_0.sky130_fd_sc_hs__inv_8_0.A VDPWR VDPWR sky130_fd_pr__pfet_01v8 ad=0.168 pd=1.42 as=0.168 ps=1.42 w=1.12 l=0.15
X1022 VDPWR single_9b_cdac_1.cdac_sw_9b_0.cdac_sw_3_6.nooverlap_clk_0.CLKB0 single_9b_cdac_1.cdac_sw_9b_0.cdac_sw_3_6.nooverlap_clk_0.CLK0 VDPWR sky130_fd_pr__pfet_01v8 ad=0.196 pd=1.47 as=0.168 ps=1.42 w=1.12 l=0.15
X1023 single_9b_cdac_1.cdac_sw_9b_0.S[2] single_9b_cdac_1.cdac_sw_9b_0.cdac_sw_3_0.tg_sw_3_3.SWN ua[0] VDPWR sky130_fd_pr__pfet_01v8 ad=0.435 pd=3.58 as=0.435 ps=3.58 w=1.5 l=0.5
X1024 th_dif_sw_0.VCN single_9b_cdac_0.cdac_sw_9b_0.S[0] sky130_fd_pr__cap_mim_m3_1 l=2 w=2
X1025 VGND single_9b_cdac_0.cdac_sw_9b_0.cdac_sw_3_2.nooverlap_clk_0.sky130_fd_sc_hs__inv_8_0.A single_9b_cdac_0.cdac_sw_9b_0.cdac_sw_3_2.nooverlap_clk_0.CLKB0 VGND sky130_fd_pr__nfet_01v8_lvt ad=0.1295 pd=1.09 as=0.1036 ps=1.02 w=0.74 l=0.15
X1026 VGND VDPWR VGND VGND sky130_fd_pr__nfet_01v8 ad=0.143 pd=1.62 as=0 ps=0 w=0.55 l=0.59
X1027 VDPWR a_5863_19662# a_5870_19566# VDPWR sky130_fd_pr__pfet_01v8_hvt ad=0.0864 pd=0.91 as=0.1664 ps=1.8 w=0.64 l=0.15
X1028 VDPWR VGND VDPWR VDPWR sky130_fd_pr__pfet_01v8_hvt ad=0.2262 pd=2.26 as=0 ps=0 w=0.87 l=0.59
X1029 VGND sar9b_0.net15 a_11733_18900# VGND sky130_fd_pr__nfet_01v8 ad=0.1346 pd=1.15 as=0.0441 ps=0.63 w=0.42 l=0.15
X1030 VDPWR VGND VDPWR VDPWR sky130_fd_pr__pfet_01v8_hvt ad=0.2262 pd=2.26 as=0 ps=0 w=0.87 l=0.59
X1031 VGND single_9b_cdac_0.cdac_sw_9b_0.cdac_sw_3_3.nooverlap_clk_0.CLKB0 single_9b_cdac_0.cdac_sw_9b_0.cdac_sw_3_3.nooverlap_clk_0.CLK0 VGND sky130_fd_pr__nfet_01v8_lvt ad=0.1295 pd=1.09 as=0.1036 ps=1.02 w=0.74 l=0.15
X1032 single_9b_cdac_1.cdac_sw_9b_0.cdac_sw_3_6.nooverlap_clk_0.CLK0 single_9b_cdac_1.cdac_sw_9b_0.cdac_sw_3_6.nooverlap_clk_0.CLKB0 VDPWR VDPWR sky130_fd_pr__pfet_01v8 ad=0.168 pd=1.42 as=0.168 ps=1.42 w=1.12 l=0.15
X1033 th_dif_sw_0.VCP single_9b_cdac_1.cdac_sw_9b_0.S[2] sky130_fd_pr__cap_mim_m3_1 l=2 w=2
X1034 th_dif_sw_0.VCP single_9b_cdac_1.cdac_sw_9b_0.S[4] sky130_fd_pr__cap_mim_m3_1 l=2 w=2
X1035 VDPWR single_9b_cdac_0.cdac_sw_9b_0.cdac_sw_3_3.nooverlap_clk_0.sky130_fd_sc_hs__inv_8_0.A single_9b_cdac_0.cdac_sw_9b_0.cdac_sw_3_3.nooverlap_clk_0.CLKB0 VDPWR sky130_fd_pr__pfet_01v8 ad=0.168 pd=1.42 as=0.168 ps=1.42 w=1.12 l=0.15
X1036 VGND single_9b_cdac_1.SW[7] a_30012_17740# VGND sky130_fd_pr__nfet_01v8 ad=0.145 pd=1.58 as=0.145 ps=1.58 w=0.5 l=0.5
X1037 VGND single_9b_cdac_1.cdac_sw_9b_0.cdac_sw_3_4.nooverlap_clk_0.CLKB0 single_9b_cdac_1.cdac_sw_9b_0.cdac_sw_3_4.nooverlap_clk_0.CLK0 VGND sky130_fd_pr__nfet_01v8_lvt ad=0.2146 pd=2.06 as=0.1036 ps=1.02 w=0.74 l=0.15
X1038 a_12937_27279# sar9b_0.net24 VGND VGND sky130_fd_pr__nfet_01v8 ad=0.1352 pd=1.56 as=0.0754 ps=0.81 w=0.52 l=0.15
X1039 VDPWR single_9b_cdac_1.cdac_sw_9b_0.cdac_sw_3_6.nooverlap_clk_0.CLKB0 single_9b_cdac_1.cdac_sw_9b_0.cdac_sw_3_6.nooverlap_clk_0.CLK0 VDPWR sky130_fd_pr__pfet_01v8 ad=0.168 pd=1.42 as=0.168 ps=1.42 w=1.12 l=0.15
X1040 th_dif_sw_0.VCN single_9b_cdac_0.cdac_sw_9b_0.S[0] sky130_fd_pr__cap_mim_m3_1 l=2 w=2
X1041 single_9b_cdac_0.cdac_sw_9b_0.S[3] single_9b_cdac_0.cdac_sw_9b_0.cdac_sw_3_4.tg_sw_3_3.SWP ua[0] VGND sky130_fd_pr__nfet_01v8 ad=0.145 pd=1.58 as=0.145 ps=1.58 w=0.5 l=0.5
X1042 single_9b_cdac_1.cdac_sw_9b_0.cdac_sw_3_6.nooverlap_clk_0.CLK0 single_9b_cdac_1.cdac_sw_9b_0.cdac_sw_3_6.nooverlap_clk_0.CLKB0 VDPWR VDPWR sky130_fd_pr__pfet_01v8 ad=0.168 pd=1.42 as=0.196 ps=1.47 w=1.12 l=0.15
X1043 th_dif_sw_0.VCP single_9b_cdac_1.cdac_sw_9b_0.S[0] sky130_fd_pr__cap_mim_m3_1 l=2 w=2
X1044 th_dif_sw_0.VCP single_9b_cdac_1.cdac_sw_9b_0.S[0] sky130_fd_pr__cap_mim_m3_1 l=2 w=2
X1045 th_dif_sw_0.VCN single_9b_cdac_0.cdac_sw_9b_0.S[0] sky130_fd_pr__cap_mim_m3_1 l=2 w=2
X1046 th_dif_sw_0.VCP single_9b_cdac_1.cdac_sw_9b_0.S[0] sky130_fd_pr__cap_mim_m3_1 l=2 w=2
X1047 single_9b_cdac_1.cdac_sw_9b_0.cdac_sw_3_2.nooverlap_clk_0.CLKB0 single_9b_cdac_1.cdac_sw_9b_0.cdac_sw_3_2.nooverlap_clk_0.sky130_fd_sc_hs__inv_8_0.A VGND VGND sky130_fd_pr__nfet_01v8_lvt ad=0.1036 pd=1.02 as=0.2109 ps=2.05 w=0.74 l=0.15
X1048 VDPWR single_9b_cdac_0.cdac_sw_9b_0.cdac_sw_3_5.nooverlap_clk_0.x3.Y single_9b_cdac_0.cdac_sw_9b_0.cdac_sw_3_5.nooverlap_clk_0.x4.A VDPWR sky130_fd_pr__pfet_01v8 ad=0.3192 pd=2.81 as=0.168 ps=1.42 w=1.12 l=0.15
X1049 VGND VDPWR VGND VGND sky130_fd_pr__nfet_01v8 ad=0.143 pd=1.62 as=0 ps=0 w=0.55 l=0.59
X1050 single_9b_cdac_1.CF[6] a_13899_23252# VGND VGND sky130_fd_pr__nfet_01v8 ad=0.1352 pd=1.56 as=0.0754 ps=0.81 w=0.52 l=0.15
X1051 VDPWR a_12312_20910# a_12487_20836# VDPWR sky130_fd_pr__pfet_01v8_hvt ad=0.1134 pd=1.38 as=0.0567 ps=0.69 w=0.42 l=0.15
X1052 VDPWR sar9b_0._00_ a_6417_19822# VDPWR sky130_fd_pr__pfet_01v8_hvt ad=0.1092 pd=1.36 as=0.05775 ps=0.695 w=0.42 l=0.15
X1053 th_dif_sw_0.VCP single_9b_cdac_1.cdac_sw_9b_0.S[0] sky130_fd_pr__cap_mim_m3_1 l=2 w=2
X1054 VGND single_9b_cdac_0.cdac_sw_9b_0.cdac_sw_3_4.nooverlap_clk_0.sky130_fd_sc_hs__nand2_1_0.Y single_9b_cdac_0.cdac_sw_9b_0.cdac_sw_3_4.nooverlap_clk_0.sky130_fd_sc_hs__inv_1_1.A VGND sky130_fd_pr__nfet_01v8_lvt ad=0.2627 pd=2.19 as=0.2109 ps=2.05 w=0.74 l=0.15
X1055 VDPWR single_9b_cdac_0.cdac_sw_9b_0.cdac_sw_3_8.nooverlap_clk_0.sky130_fd_sc_hs__nand2_1_0.Y single_9b_cdac_0.cdac_sw_9b_0.cdac_sw_3_8.nooverlap_clk_0.sky130_fd_sc_hs__inv_1_1.A VDPWR sky130_fd_pr__pfet_01v8 ad=0.3864 pd=2.93 as=0.3304 ps=2.83 w=1.12 l=0.15
X1056 a_13308_23074# sar9b_0.net1 VDPWR VDPWR sky130_fd_pr__pfet_01v8_hvt ad=0.0651 pd=0.73 as=0.1092 ps=1.36 w=0.42 l=0.15
X1057 a_9005_20532# a_8471_20538# a_8910_20532# VDPWR sky130_fd_pr__pfet_01v8_hvt ad=0.07665 pd=0.785 as=0.06825 ps=0.745 w=0.42 l=0.15
X1058 VGND single_9b_cdac_0.cdac_sw_9b_0.cdac_sw_3_7.nooverlap_clk_0.x1.A single_9b_cdac_0.cdac_sw_9b_0.cdac_sw_3_7.nooverlap_clk_0.sky130_fd_sc_hs__inv_8_0.A VGND sky130_fd_pr__nfet_01v8_lvt ad=0.2331 pd=2.11 as=0.1184 ps=1.06 w=0.74 l=0.15
X1059 ua[0] single_9b_cdac_1.cdac_sw_9b_0.cdac_sw_3_4.tg_sw_3_3.SWN ua[0] VGND sky130_fd_pr__nfet_01v8 ad=0.145 pd=1.58 as=0 ps=0 w=0.5 l=0.5
X1060 th_dif_sw_0.VCP single_9b_cdac_1.cdac_sw_9b_0.S[0] sky130_fd_pr__cap_mim_m3_1 l=2 w=2
X1061 th_dif_sw_0.VCN single_9b_cdac_0.cdac_sw_9b_0.S[1] sky130_fd_pr__cap_mim_m3_1 l=2 w=2
X1062 a_11376_26516# sar9b_0.net42 VGND VGND sky130_fd_pr__nfet_01v8 ad=0.066 pd=0.745 as=0.2205 ps=1.89 w=0.42 l=0.15
X1063 single_9b_cdac_0.cdac_sw_9b_0.cdac_sw_3_5.nooverlap_clk_0.x4.A single_9b_cdac_0.cdac_sw_9b_0.cdac_sw_3_5.nooverlap_clk_0.x1.A VDPWR VDPWR sky130_fd_pr__pfet_01v8 ad=0.168 pd=1.42 as=0.3192 ps=2.81 w=1.12 l=0.15
X1064 single_9b_cdac_1.cdac_sw_9b_0.cdac_sw_3_3.nooverlap_clk_0.x6.A single_9b_cdac_1.cdac_sw_9b_0.cdac_sw_3_3.nooverlap_clk_0.x4.A VGND VGND sky130_fd_pr__nfet_01v8_lvt ad=0.2109 pd=2.05 as=0.2627 ps=2.19 w=0.74 l=0.15
X1065 th_dif_sw_0.VCN single_9b_cdac_0.cdac_sw_9b_0.S[6] sky130_fd_pr__cap_mim_m3_1 l=2 w=2
X1066 single_9b_cdac_0.cdac_sw_9b_0.S[5] single_9b_cdac_0.cdac_sw_9b_0.cdac_sw_3_5.tg_sw_3_3.SWP ua[0] VGND sky130_fd_pr__nfet_01v8 ad=0.145 pd=1.58 as=0.145 ps=1.58 w=0.5 l=0.5
X1067 ua[0] single_9b_cdac_0.cdac_sw_9b_0.cdac_sw_3_4.tg_sw_3_3.SWN ua[0] VGND sky130_fd_pr__nfet_01v8 ad=0.145 pd=1.58 as=0 ps=0 w=0.5 l=0.5
X1068 a_6714_24340# sar9b_0.clk_div_0.COUNT\[1\] VGND VGND sky130_fd_pr__nfet_01v8 ad=0.09588 pd=0.945 as=0.17225 ps=1.83 w=0.65 l=0.15
X1069 VDPWR a_10311_17812# sar9b_0.net1 VDPWR sky130_fd_pr__pfet_01v8_hvt ad=0.26 pd=2.52 as=0.135 ps=1.27 w=1 l=0.15
X1070 single_9b_cdac_1.cdac_sw_9b_0.cdac_sw_3_4.nooverlap_clk_0.x1.A single_9b_cdac_1.cdac_sw_9b_0.cdac_sw_3_4.nooverlap_clk_0.sky130_fd_sc_hs__inv_1_1.A VGND VGND sky130_fd_pr__nfet_01v8_lvt ad=0.2109 pd=2.05 as=0.2627 ps=2.19 w=0.74 l=0.15
X1071 single_9b_cdac_0.cdac_sw_9b_0.S[0] single_9b_cdac_0.cdac_sw_9b_0.cdac_sw_3_2.tg_sw_3_3.SWP single_9b_cdac_0.cdac_sw_9b_0.S[0] VDPWR sky130_fd_pr__pfet_01v8 ad=0.435 pd=3.58 as=6.96 ps=57.28 w=1.5 l=0.5
X1072 a_12145_24174# a_10955_23802# a_12036_24174# VGND sky130_fd_pr__special_nfet_01v8 ad=0.0669 pd=0.75 as=0.0711 ps=0.755 w=0.36 l=0.15
X1073 a_12145_18900# a_10955_18900# a_12036_18900# VGND sky130_fd_pr__special_nfet_01v8 ad=0.0669 pd=0.75 as=0.0711 ps=0.755 w=0.36 l=0.15
X1074 ua[0] single_9b_cdac_1.cdac_sw_9b_0.cdac_sw_3_7.tg_sw_3_3.SWP ua[0] VDPWR sky130_fd_pr__pfet_01v8 ad=0.435 pd=3.58 as=0 ps=0 w=1.5 l=0.5
X1075 a_48343_16877# single_9b_cdac_1.SW[3] VDPWR VDPWR sky130_fd_pr__pfet_01v8 ad=0.435 pd=3.58 as=0.435 ps=3.58 w=1.5 l=0.5
X1076 th_dif_sw_0.VCN single_9b_cdac_0.cdac_sw_9b_0.S[0] sky130_fd_pr__cap_mim_m3_1 l=2 w=2
X1077 a_10550_21076# sar9b_0.net15 VGND VGND sky130_fd_pr__nfet_01v8 ad=0.06405 pd=0.725 as=0.12495 ps=1.015 w=0.42 l=0.15
X1078 th_dif_sw_0.VCN single_9b_cdac_0.cdac_sw_9b_0.S[2] sky130_fd_pr__cap_mim_m3_1 l=2 w=2
X1079 dw_17224_1400# a_21368_4076# sky130_fd_pr__cap_mim_m3_1 l=2 w=2
X1080 VDPWR a_7325_26681# uio_out[0] VDPWR sky130_fd_pr__pfet_01v8_hvt ad=0.11455 pd=1.08 as=0.2054 ps=2.1 w=0.79 l=0.15
X1081 single_9b_cdac_1.CF[0] a_13347_21620# VGND VGND sky130_fd_pr__nfet_01v8 ad=0.1352 pd=1.56 as=0.0754 ps=0.81 w=0.52 l=0.15
X1082 VGND VDPWR VGND VGND sky130_fd_pr__nfet_01v8 ad=0.143 pd=1.62 as=0 ps=0 w=0.55 l=0.59
X1083 dw_12589_1395# a_10166_3438# sky130_fd_pr__cap_mim_m3_1 l=2 w=2
X1084 th_dif_sw_0.VCP single_9b_cdac_1.cdac_sw_9b_0.S[0] sky130_fd_pr__cap_mim_m3_1 l=2 w=2
X1085 a_14077_25262# a_12887_24890# a_13968_25262# VGND sky130_fd_pr__special_nfet_01v8 ad=0.0669 pd=0.75 as=0.0711 ps=0.755 w=0.36 l=0.15
X1086 single_9b_cdac_1.cdac_sw_9b_0.S[8] single_9b_cdac_1.cdac_sw_9b_0.cdac_sw_3_8.tg_sw_3_3.SWN single_9b_cdac_1.cdac_sw_9b_0.S[8] VGND sky130_fd_pr__nfet_01v8 ad=0.145 pd=1.58 as=0 ps=0 w=0.5 l=0.5
X1087 VDPWR single_9b_cdac_1.cdac_sw_9b_0.cdac_sw_3_5.nooverlap_clk_0.CLKB0 single_9b_cdac_1.cdac_sw_9b_0.cdac_sw_3_5.nooverlap_clk_0.CLK0 VDPWR sky130_fd_pr__pfet_01v8 ad=0.196 pd=1.47 as=0.168 ps=1.42 w=1.12 l=0.15
X1088 th_dif_sw_0.VCP single_9b_cdac_1.cdac_sw_9b_0.S[1] sky130_fd_pr__cap_mim_m3_1 l=2 w=2
X1089 th_dif_sw_0.VCP single_9b_cdac_1.cdac_sw_9b_0.S[2] sky130_fd_pr__cap_mim_m3_1 l=2 w=2
X1090 VDPWR a_6149_23770# sar9b_0.clknet_1_1__leaf_CLK VDPWR sky130_fd_pr__pfet_01v8_hvt ad=0.14 pd=1.28 as=0.14 ps=1.28 w=1 l=0.15
X1091 a_9727_23226# sar9b_0.net15 VDPWR VDPWR sky130_fd_pr__pfet_01v8_hvt ad=0.0567 pd=0.69 as=0.0819 ps=0.81 w=0.42 l=0.15
X1092 th_dif_sw_0.VCN single_9b_cdac_0.cdac_sw_9b_0.S[0] sky130_fd_pr__cap_mim_m3_1 l=2 w=2
X1093 VDPWR VGND VDPWR VDPWR sky130_fd_pr__pfet_01v8_hvt ad=0.2262 pd=2.26 as=0 ps=0 w=0.87 l=0.59
X1094 sar9b_0.net36 a_13315_18660# VDPWR VDPWR sky130_fd_pr__pfet_01v8_hvt ad=0.26 pd=2.52 as=0.3012 ps=2.66 w=1 l=0.15
X1095 single_9b_cdac_1.cdac_sw_9b_0.cdac_sw_3_5.nooverlap_clk_0.CLK0 single_9b_cdac_1.cdac_sw_9b_0.cdac_sw_3_5.nooverlap_clk_0.CLKB0 VGND VGND sky130_fd_pr__nfet_01v8_lvt ad=0.1036 pd=1.02 as=0.1036 ps=1.02 w=0.74 l=0.15
X1096 th_dif_sw_0.VCP single_9b_cdac_1.cdac_sw_9b_0.S[0] sky130_fd_pr__cap_mim_m3_1 l=2 w=2
X1097 th_dif_sw_0.VCN single_9b_cdac_0.cdac_sw_9b_0.S[0] sky130_fd_pr__cap_mim_m3_1 l=2 w=2
X1098 single_9b_cdac_0.cdac_sw_9b_0.cdac_sw_3_0.tg_sw_3_3.SWP single_9b_cdac_0.cdac_sw_9b_0.cdac_sw_3_0.tg_sw_3_3.SWN VGND VGND sky130_fd_pr__nfet_01v8_lvt ad=0.1036 pd=1.02 as=0.2146 ps=2.06 w=0.74 l=0.15
X1099 VGND VDPWR VGND VGND sky130_fd_pr__nfet_01v8 ad=0.143 pd=1.62 as=0 ps=0 w=0.55 l=0.59
X1100 single_9b_cdac_0.cdac_sw_9b_0.cdac_sw_3_8.nooverlap_clk_0.CLK0 single_9b_cdac_0.cdac_sw_9b_0.cdac_sw_3_8.nooverlap_clk_0.CLKB0 VDPWR VDPWR sky130_fd_pr__pfet_01v8 ad=0.168 pd=1.42 as=0.3864 ps=2.93 w=1.12 l=0.15
X1101 a_14322_26516# sar9b_0.net15 VGND VGND sky130_fd_pr__nfet_01v8 ad=0.06405 pd=0.725 as=0.12495 ps=1.015 w=0.42 l=0.15
X1102 single_9b_cdac_1.cdac_sw_9b_0.cdac_sw_3_5.nooverlap_clk_0.CLK0 single_9b_cdac_1.cdac_sw_9b_0.cdac_sw_3_5.nooverlap_clk_0.CLKB0 VDPWR VDPWR sky130_fd_pr__pfet_01v8 ad=0.168 pd=1.42 as=0.168 ps=1.42 w=1.12 l=0.15
X1103 single_9b_cdac_1.cdac_sw_9b_0.S[3] single_9b_cdac_1.cdac_sw_9b_0.cdac_sw_3_4.tg_sw_3_3.SWP ua[0] VGND sky130_fd_pr__nfet_01v8 ad=0.145 pd=1.58 as=0.145 ps=1.58 w=0.5 l=0.5
X1104 th_dif_sw_0.VCP single_9b_cdac_1.cdac_sw_9b_0.S[0] sky130_fd_pr__cap_mim_m3_1 l=2 w=2
X1105 th_dif_sw_0.VCN single_9b_cdac_0.cdac_sw_9b_0.S[2] sky130_fd_pr__cap_mim_m3_1 l=2 w=2
X1106 a_9345_23074# sar9b_0.net15 VGND VGND sky130_fd_pr__nfet_01v8 ad=0.0441 pd=0.63 as=0.1346 ps=1.15 w=0.42 l=0.15
X1107 a_11689_21318# a_11471_21076# VGND VGND sky130_fd_pr__nfet_01v8 ad=0.0999 pd=0.985 as=0.1346 ps=1.15 w=0.64 l=0.15
X1108 VDPWR single_9b_cdac_1.cdac_sw_9b_0.cdac_sw_3_5.nooverlap_clk_0.CLKB0 single_9b_cdac_1.cdac_sw_9b_0.cdac_sw_3_5.nooverlap_clk_0.CLK0 VDPWR sky130_fd_pr__pfet_01v8 ad=0.168 pd=1.42 as=0.168 ps=1.42 w=1.12 l=0.15
X1109 th_dif_sw_0.VCP single_9b_cdac_1.cdac_sw_9b_0.S[0] sky130_fd_pr__cap_mim_m3_1 l=2 w=2
X1110 VDPWR sar9b_0.net9 a_14451_21620# VDPWR sky130_fd_pr__pfet_01v8_hvt ad=0.11455 pd=1.08 as=0.2054 ps=2.1 w=0.79 l=0.15
X1111 a_13511_19444# sar9b_0.net15 VDPWR VDPWR sky130_fd_pr__pfet_01v8_hvt ad=0.1092 pd=1.36 as=0.07035 ps=0.755 w=0.42 l=0.15
X1112 th_dif_sw_0.VCP single_9b_cdac_1.cdac_sw_9b_0.S[0] sky130_fd_pr__cap_mim_m3_1 l=2 w=2
X1113 VDPWR sar9b_0.net14 a_14175_27060# VDPWR sky130_fd_pr__pfet_01v8_hvt ad=0.11455 pd=1.08 as=0.2054 ps=2.1 w=0.79 l=0.15
X1114 VDPWR single_9b_cdac_1.cdac_sw_9b_0.cdac_sw_3_5.nooverlap_clk_0.x8.A single_9b_cdac_1.cdac_sw_9b_0.cdac_sw_3_5.nooverlap_clk_0.x10.A VDPWR sky130_fd_pr__pfet_01v8 ad=0.3304 pd=2.83 as=0.168 ps=1.42 w=1.12 l=0.15
X1115 th_dif_sw_0.VCN single_9b_cdac_0.cdac_sw_9b_0.S[0] sky130_fd_pr__cap_mim_m3_1 l=2 w=2
X1116 VDPWR single_9b_cdac_0.cdac_sw_9b_0.cdac_sw_3_5.tg_sw_3_3.SWN single_9b_cdac_0.cdac_sw_9b_0.cdac_sw_3_5.tg_sw_3_3.SWP VDPWR sky130_fd_pr__pfet_01v8 ad=0.196 pd=1.47 as=0.168 ps=1.42 w=1.12 l=0.15
X1117 single_9b_cdac_0.cdac_sw_9b_0.cdac_sw_3_3.nooverlap_clk_0.x10.A single_9b_cdac_0.cdac_sw_9b_0.cdac_sw_3_3.nooverlap_clk_0.x8.A VGND VGND sky130_fd_pr__nfet_01v8_lvt ad=0.1036 pd=1.02 as=0.2109 ps=2.05 w=0.74 l=0.15
X1118 VGND VDPWR VGND VGND sky130_fd_pr__nfet_01v8 ad=0.143 pd=1.62 as=0 ps=0 w=0.55 l=0.59
X1119 a_49221_17740# single_9b_cdac_1.cdac_sw_9b_0.cdac_sw_3_4.nooverlap_clk_0.CLK0 single_9b_cdac_1.cdac_sw_9b_0.S[3] VGND sky130_fd_pr__nfet_01v8 ad=0.145 pd=1.58 as=0.145 ps=1.58 w=0.5 l=0.5
X1120 VDPWR single_9b_cdac_0.cdac_sw_9b_0.cdac_sw_3_1.nooverlap_clk_0.sky130_fd_sc_hs__inv_8_0.A single_9b_cdac_0.cdac_sw_9b_0.cdac_sw_3_1.nooverlap_clk_0.CLKB0 VDPWR sky130_fd_pr__pfet_01v8 ad=0.196 pd=1.47 as=0.168 ps=1.42 w=1.12 l=0.15
X1121 VGND single_9b_cdac_0.cdac_sw_9b_0.cdac_sw_3_2.nooverlap_clk_0.sky130_fd_sc_hs__inv_8_0.A single_9b_cdac_0.cdac_sw_9b_0.cdac_sw_3_2.nooverlap_clk_0.CLKB0 VGND sky130_fd_pr__nfet_01v8_lvt ad=0.2109 pd=2.05 as=0.1036 ps=1.02 w=0.74 l=0.15
X1122 VDPWR single_9b_cdac_0.cdac_sw_9b_0.cdac_sw_3_2.tg_sw_3_3.SWN single_9b_cdac_0.cdac_sw_9b_0.cdac_sw_3_2.tg_sw_3_3.SWP VDPWR sky130_fd_pr__pfet_01v8 ad=0.196 pd=1.47 as=0.168 ps=1.42 w=1.12 l=0.15
X1123 single_9b_cdac_1.cdac_sw_9b_0.cdac_sw_3_5.nooverlap_clk_0.CLK0 single_9b_cdac_1.cdac_sw_9b_0.cdac_sw_3_5.nooverlap_clk_0.CLKB0 VDPWR VDPWR sky130_fd_pr__pfet_01v8 ad=0.168 pd=1.42 as=0.196 ps=1.47 w=1.12 l=0.15
X1124 VDPWR a_9132_7271# th_dif_sw_0.th_sw_1.CK VDPWR sky130_fd_pr__pfet_01v8 ad=0.168 pd=1.42 as=0.168 ps=1.42 w=1.12 l=0.15
X1125 single_9b_cdac_0.cdac_sw_9b_0.S[3] single_9b_cdac_0.cdac_sw_9b_0.cdac_sw_3_4.tg_sw_3_3.SWN ua[0] VDPWR sky130_fd_pr__pfet_01v8 ad=0.435 pd=3.58 as=0.435 ps=3.58 w=1.5 l=0.5
X1126 ua[0] single_9b_cdac_0.cdac_sw_9b_0.cdac_sw_3_0.tg_sw_3_3.SWP ua[0] VDPWR sky130_fd_pr__pfet_01v8 ad=0.435 pd=3.58 as=0 ps=0 w=1.5 l=0.5
X1127 VGND single_9b_cdac_0.cdac_sw_9b_0.cdac_sw_3_4.nooverlap_clk_0.CLKB0 single_9b_cdac_0.cdac_sw_9b_0.cdac_sw_3_4.nooverlap_clk_0.CLK0 VGND sky130_fd_pr__nfet_01v8_lvt ad=0.2109 pd=2.05 as=0.1036 ps=1.02 w=0.74 l=0.15
X1128 a_13621_22406# a_13403_22164# VGND VGND sky130_fd_pr__nfet_01v8 ad=0.0999 pd=0.985 as=0.1346 ps=1.15 w=0.64 l=0.15
X1129 a_7817_23252# sar9b_0.clk_div_0.COUNT\[0\] VGND VGND sky130_fd_pr__nfet_01v8 ad=0.169 pd=1.82 as=0.10725 ps=0.98 w=0.65 l=0.15
X1130 a_24332_16877# single_9b_cdac_1.SW[8] VDPWR VDPWR sky130_fd_pr__pfet_01v8 ad=0.435 pd=3.58 as=0.435 ps=3.58 w=1.5 l=0.5
X1131 single_9b_cdac_1.cdac_sw_9b_0.cdac_sw_3_5.nooverlap_clk_0.x10.A single_9b_cdac_1.cdac_sw_9b_0.cdac_sw_3_5.nooverlap_clk_0.x8.A VDPWR VDPWR sky130_fd_pr__pfet_01v8 ad=0.168 pd=1.42 as=0.168 ps=1.42 w=1.12 l=0.15
X1132 th_dif_sw_0.VCP single_9b_cdac_1.cdac_sw_9b_0.S[0] sky130_fd_pr__cap_mim_m3_1 l=2 w=2
X1133 a_39616_26990# single_9b_cdac_0.cdac_sw_9b_0.cdac_sw_3_5.nooverlap_clk_0.CLK0 single_9b_cdac_0.cdac_sw_9b_0.S[5] VGND sky130_fd_pr__nfet_01v8 ad=0.145 pd=1.58 as=0.145 ps=1.58 w=0.5 l=0.5
X1134 VGND single_9b_cdac_0.SW[5] a_39616_26990# VGND sky130_fd_pr__nfet_01v8 ad=0.145 pd=1.58 as=0.145 ps=1.58 w=0.5 l=0.5
X1135 a_13499_23086# a_13053_22714# a_13403_23086# VGND sky130_fd_pr__special_nfet_01v8 ad=0.1401 pd=1.1 as=0.0594 ps=0.69 w=0.36 l=0.15
X1136 a_13665_18900# a_13621_19142# a_13499_18900# VGND sky130_fd_pr__nfet_01v8 ad=0.0441 pd=0.63 as=0.1401 ps=1.1 w=0.42 l=0.15
X1137 VGND VDPWR VGND VGND sky130_fd_pr__nfet_01v8 ad=0.143 pd=1.62 as=0 ps=0 w=0.55 l=0.59
X1138 th_dif_sw_0.VCN single_9b_cdac_0.cdac_sw_9b_0.S[1] sky130_fd_pr__cap_mim_m3_1 l=2 w=2
X1139 th_dif_sw_0.VCN single_9b_cdac_0.cdac_sw_9b_0.S[2] sky130_fd_pr__cap_mim_m3_1 l=2 w=2
X1140 single_9b_cdac_0.cdac_sw_9b_0.cdac_sw_3_1.nooverlap_clk_0.CLKB0 single_9b_cdac_0.cdac_sw_9b_0.cdac_sw_3_1.nooverlap_clk_0.sky130_fd_sc_hs__inv_8_0.A VDPWR VDPWR sky130_fd_pr__pfet_01v8 ad=0.168 pd=1.42 as=0.168 ps=1.42 w=1.12 l=0.15
X1141 single_9b_cdac_0.cdac_sw_9b_0.cdac_sw_3_2.tg_sw_3_3.SWP single_9b_cdac_0.cdac_sw_9b_0.cdac_sw_3_2.tg_sw_3_3.SWN VDPWR VDPWR sky130_fd_pr__pfet_01v8 ad=0.168 pd=1.42 as=0.168 ps=1.42 w=1.12 l=0.15
X1142 a_6502_20124# a_6343_20354# VGND VGND sky130_fd_pr__nfet_01v8 ad=0.0989 pd=0.995 as=0.1493 ps=1.22 w=0.64 l=0.15
X1143 single_9b_cdac_1.cdac_sw_9b_0.S[5] single_9b_cdac_1.cdac_sw_9b_0.cdac_sw_3_5.tg_sw_3_3.SWP ua[0] VGND sky130_fd_pr__nfet_01v8 ad=0.145 pd=1.58 as=0.145 ps=1.58 w=0.5 l=0.5
X1144 VDPWR single_9b_cdac_1.cdac_sw_9b_0.cdac_sw_3_5.nooverlap_clk_0.x8.A single_9b_cdac_1.cdac_sw_9b_0.cdac_sw_3_5.nooverlap_clk_0.x10.A VDPWR sky130_fd_pr__pfet_01v8 ad=0.168 pd=1.42 as=0.168 ps=1.42 w=1.12 l=0.15
X1145 th_dif_sw_0.VCP single_9b_cdac_1.cdac_sw_9b_0.S[2] sky130_fd_pr__cap_mim_m3_1 l=2 w=2
X1146 VDPWR single_9b_cdac_0.cdac_sw_9b_0.cdac_sw_3_1.nooverlap_clk_0.sky130_fd_sc_hs__inv_8_0.A single_9b_cdac_0.cdac_sw_9b_0.cdac_sw_3_1.nooverlap_clk_0.CLKB0 VDPWR sky130_fd_pr__pfet_01v8 ad=0.168 pd=1.42 as=0.168 ps=1.42 w=1.12 l=0.15
X1147 VGND a_14143_26490# a_14077_26516# VGND sky130_fd_pr__nfet_01v8 ad=0.12495 pd=1.015 as=0.0669 ps=0.75 w=0.42 l=0.15
X1148 VDPWR single_9b_cdac_0.cdac_sw_9b_0.cdac_sw_3_2.tg_sw_3_3.SWN single_9b_cdac_0.cdac_sw_9b_0.cdac_sw_3_2.tg_sw_3_3.SWP VDPWR sky130_fd_pr__pfet_01v8 ad=0.168 pd=1.42 as=0.168 ps=1.42 w=1.12 l=0.15
X1149 single_9b_cdac_1.cdac_sw_9b_0.S[0] single_9b_cdac_1.cdac_sw_9b_0.cdac_sw_3_2.tg_sw_3_3.SWP single_9b_cdac_1.cdac_sw_9b_0.S[0] VDPWR sky130_fd_pr__pfet_01v8 ad=0.435 pd=3.58 as=6.96 ps=57.28 w=1.5 l=0.5
X1150 VGND single_9b_cdac_0.cdac_sw_9b_0.cdac_sw_3_8.nooverlap_clk_0.x10.A single_9b_cdac_0.cdac_sw_9b_0.cdac_sw_3_8.tg_sw_3_3.SWN VGND sky130_fd_pr__nfet_01v8_lvt ad=0.1554 pd=1.16 as=0.1036 ps=1.02 w=0.74 l=0.15
X1151 VDPWR VGND VDPWR VDPWR sky130_fd_pr__pfet_01v8_hvt ad=0.2262 pd=2.26 as=0 ps=0 w=0.87 l=0.59
X1152 single_9b_cdac_1.cdac_sw_9b_0.cdac_sw_3_6.nooverlap_clk_0.x1.A single_9b_cdac_1.cdac_sw_9b_0.cdac_sw_3_6.nooverlap_clk_0.sky130_fd_sc_hs__inv_1_1.A VDPWR VDPWR sky130_fd_pr__pfet_01v8 ad=0.3304 pd=2.83 as=0.3864 ps=2.93 w=1.12 l=0.15
X1153 single_9b_cdac_1.cdac_sw_9b_0.cdac_sw_3_5.nooverlap_clk_0.x10.A single_9b_cdac_1.cdac_sw_9b_0.cdac_sw_3_5.nooverlap_clk_0.x8.A VDPWR VDPWR sky130_fd_pr__pfet_01v8 ad=0.168 pd=1.42 as=0.3304 ps=2.83 w=1.12 l=0.15
X1154 th_dif_sw_0.VCP single_9b_cdac_1.cdac_sw_9b_0.S[8] sky130_fd_pr__cap_mim_m3_1 l=2 w=2
X1155 th_dif_sw_0.VCP single_9b_cdac_1.cdac_sw_9b_0.S[1] sky130_fd_pr__cap_mim_m3_1 l=2 w=2
X1156 single_9b_cdac_1.cdac_sw_9b_0.cdac_sw_3_2.nooverlap_clk_0.sky130_fd_sc_hs__inv_1_1.A single_9b_cdac_1.cdac_sw_9b_0.cdac_sw_3_2.nooverlap_clk_0.sky130_fd_sc_hs__nand2_1_0.Y VDPWR VDPWR sky130_fd_pr__pfet_01v8 ad=0.3304 pd=2.83 as=0.3864 ps=2.93 w=1.12 l=0.15
X1157 VGND single_9b_cdac_1.CF[2] single_9b_cdac_0.cdac_sw_9b_0.cdac_sw_3_0.nooverlap_clk_0.x3.Y VGND sky130_fd_pr__nfet_01v8_lvt ad=0.2627 pd=2.19 as=0.2109 ps=2.05 w=0.74 l=0.15
X1158 single_9b_cdac_0.SW[6] a_13899_25972# VDPWR VDPWR sky130_fd_pr__pfet_01v8_hvt ad=0.2054 pd=2.1 as=0.11455 ps=1.08 w=0.79 l=0.15
X1159 VDPWR VGND VDPWR VDPWR sky130_fd_pr__pfet_01v8_hvt ad=0.2262 pd=2.26 as=0 ps=0 w=0.87 l=0.59
X1160 a_5483_19676# a_5579_19676# VGND VGND sky130_fd_pr__nfet_01v8 ad=0.169 pd=1.82 as=0.08775 ps=0.92 w=0.65 l=0.15
X1161 th_dif_sw_0.VCP single_9b_cdac_1.cdac_sw_9b_0.S[3] sky130_fd_pr__cap_mim_m3_1 l=2 w=2
X1162 a_21177_7457# th_dif_sw_0.CKB VDPWR VDPWR sky130_fd_pr__pfet_01v8 ad=0.168 pd=1.42 as=0.196 ps=1.47 w=1.12 l=0.15
X1163 VGND single_9b_cdac_1.cdac_sw_9b_0.cdac_sw_3_2.nooverlap_clk_0.x8.A a_65367_15501# VGND sky130_fd_pr__nfet_01v8_lvt ad=0.2109 pd=2.05 as=0.0888 ps=0.98 w=0.74 l=0.15
X1164 VDPWR single_9b_cdac_1.cdac_sw_9b_0.cdac_sw_3_1.tg_sw_3_3.SWN single_9b_cdac_1.cdac_sw_9b_0.cdac_sw_3_1.tg_sw_3_3.SWP VDPWR sky130_fd_pr__pfet_01v8 ad=0.196 pd=1.47 as=0.168 ps=1.42 w=1.12 l=0.15
X1165 VGND sar9b_0.net15 a_12009_20898# VGND sky130_fd_pr__nfet_01v8 ad=0.1346 pd=1.15 as=0.0441 ps=0.63 w=0.42 l=0.15
X1166 single_9b_cdac_1.cdac_sw_9b_0.cdac_sw_3_8.nooverlap_clk_0.x10.A single_9b_cdac_1.cdac_sw_9b_0.cdac_sw_3_8.nooverlap_clk_0.x8.A VGND VGND sky130_fd_pr__nfet_01v8_lvt ad=0.1184 pd=1.06 as=0.2331 ps=2.11 w=0.74 l=0.15
X1167 th_dif_sw_0.VCP single_9b_cdac_1.cdac_sw_9b_0.S[1] sky130_fd_pr__cap_mim_m3_1 l=2 w=2
X1168 VGND sar9b_0.net15 a_13665_19810# VGND sky130_fd_pr__nfet_01v8 ad=0.1346 pd=1.15 as=0.0441 ps=0.63 w=0.42 l=0.15
X1169 VGND single_9b_cdac_1.cdac_sw_9b_0.cdac_sw_3_8.nooverlap_clk_0.x10.A single_9b_cdac_1.cdac_sw_9b_0.cdac_sw_3_8.tg_sw_3_3.SWN VGND sky130_fd_pr__nfet_01v8_lvt ad=0.1295 pd=1.09 as=0.1036 ps=1.02 w=0.74 l=0.15
X1170 VDPWR single_9b_cdac_1.CF[0] single_9b_cdac_0.cdac_sw_9b_0.cdac_sw_3_2.nooverlap_clk_0.x3.Y VDPWR sky130_fd_pr__pfet_01v8 ad=0.3864 pd=2.93 as=0.3304 ps=2.83 w=1.12 l=0.15
X1171 a_6502_20124# a_6343_20354# VDPWR VDPWR sky130_fd_pr__pfet_01v8_hvt ad=0.1095 pd=1.075 as=0.17887 ps=1.26 w=0.75 l=0.15
X1172 th_dif_sw_0.VCN single_9b_cdac_0.cdac_sw_9b_0.S[0] sky130_fd_pr__cap_mim_m3_1 l=2 w=2
X1173 single_9b_cdac_1.cdac_sw_9b_0.cdac_sw_3_1.tg_sw_3_3.SWP single_9b_cdac_1.cdac_sw_9b_0.cdac_sw_3_1.tg_sw_3_3.SWN VDPWR VDPWR sky130_fd_pr__pfet_01v8 ad=0.168 pd=1.42 as=0.3304 ps=2.83 w=1.12 l=0.15
X1174 a_6567_23618# a_5785_23252# a_6483_23618# VDPWR sky130_fd_pr__pfet_01v8_hvt ad=0.0882 pd=0.84 as=0.0567 ps=0.69 w=0.42 l=0.15
X1175 VDPWR a_13621_22406# a_13511_22530# VDPWR sky130_fd_pr__pfet_01v8_hvt ad=0.07035 pd=0.755 as=0.1155 ps=0.97 w=0.42 l=0.15
X1176 ua[0] single_9b_cdac_1.cdac_sw_9b_0.cdac_sw_3_5.tg_sw_3_3.SWN ua[0] VGND sky130_fd_pr__nfet_01v8 ad=0.145 pd=1.58 as=0 ps=0 w=0.5 l=0.5
X1177 a_6163_27034# a_6007_27302# a_6308_27060# VDPWR sky130_fd_pr__pfet_01v8_hvt ad=0.07245 pd=0.765 as=0.1155 ps=0.97 w=0.42 l=0.15
X1178 a_14322_19988# sar9b_0.net15 VGND VGND sky130_fd_pr__nfet_01v8 ad=0.06405 pd=0.725 as=0.12495 ps=1.015 w=0.42 l=0.15
X1179 a_8803_19822# a_8453_19450# a_8708_19810# VDPWR sky130_fd_pr__pfet_01v8_hvt ad=0.07245 pd=0.765 as=0.0651 ps=0.73 w=0.42 l=0.15
X1180 th_dif_sw_0.VCP single_9b_cdac_1.cdac_sw_9b_0.S[3] sky130_fd_pr__cap_mim_m3_1 l=2 w=2
X1181 dw_17224_1400# a_21368_4076# sky130_fd_pr__cap_mim_m3_1 l=2 w=2
X1182 th_dif_sw_0.VCN single_9b_cdac_0.cdac_sw_9b_0.S[0] sky130_fd_pr__cap_mim_m3_1 l=2 w=2
X1183 single_9b_cdac_0.cdac_sw_9b_0.cdac_sw_3_7.tg_sw_3_3.SWN single_9b_cdac_0.cdac_sw_9b_0.cdac_sw_3_7.nooverlap_clk_0.x10.A VGND VGND sky130_fd_pr__nfet_01v8_lvt ad=0.1036 pd=1.02 as=0.1036 ps=1.02 w=0.74 l=0.15
X1184 VGND single_9b_cdac_0.SW[7] a_30012_26990# VGND sky130_fd_pr__nfet_01v8 ad=0.145 pd=1.58 as=0.145 ps=1.58 w=0.5 l=0.5
X1185 VGND single_9b_cdac_0.cdac_sw_9b_0.cdac_sw_3_6.nooverlap_clk_0.sky130_fd_sc_hs__inv_8_0.A single_9b_cdac_0.cdac_sw_9b_0.cdac_sw_3_6.nooverlap_clk_0.CLKB0 VGND sky130_fd_pr__nfet_01v8_lvt ad=0.1295 pd=1.09 as=0.1036 ps=1.02 w=0.74 l=0.15
X1186 VGND single_9b_cdac_1.SW[8] a_25210_17740# VGND sky130_fd_pr__nfet_01v8 ad=0.145 pd=1.58 as=0.145 ps=1.58 w=0.5 l=0.5
X1187 th_dif_sw_0.VCN single_9b_cdac_0.cdac_sw_9b_0.S[2] sky130_fd_pr__cap_mim_m3_1 l=2 w=2
X1188 ua[0] single_9b_cdac_0.cdac_sw_9b_0.cdac_sw_3_0.tg_sw_3_3.SWP ua[0] VDPWR sky130_fd_pr__pfet_01v8 ad=0.435 pd=3.58 as=0 ps=0 w=1.5 l=0.5
X1189 a_12211_21050# a_12036_21076# a_12390_21076# VGND sky130_fd_pr__nfet_01v8 ad=0.1092 pd=1.36 as=0.06405 ps=0.725 w=0.42 l=0.15
X1190 th_dif_sw_0.VCP single_9b_cdac_1.cdac_sw_9b_0.S[0] sky130_fd_pr__cap_mim_m3_1 l=2 w=2
X1191 VDPWR sar9b_0.FINAL a_8379_25978# VDPWR sky130_fd_pr__pfet_01v8_hvt ad=0.0864 pd=0.91 as=0.1664 ps=1.8 w=0.64 l=0.15
X1192 VDPWR single_9b_cdac_0.cdac_sw_9b_0.cdac_sw_3_8.nooverlap_clk_0.sky130_fd_sc_hs__inv_1_1.A single_9b_cdac_0.cdac_sw_9b_0.cdac_sw_3_8.nooverlap_clk_0.x1.A VDPWR sky130_fd_pr__pfet_01v8 ad=0.3864 pd=2.93 as=0.3304 ps=2.83 w=1.12 l=0.15
X1193 a_11045_23494# a_10827_23252# VDPWR VDPWR sky130_fd_pr__pfet_01v8_hvt ad=0.12915 pd=1.185 as=0.2184 ps=2.2 w=0.84 l=0.15
X1194 VDPWR sar9b_0.net15 a_9535_19962# VDPWR sky130_fd_pr__pfet_01v8_hvt ad=0.0819 pd=0.81 as=0.0567 ps=0.69 w=0.42 l=0.15
X1195 th_dif_sw_0.VCN single_9b_cdac_0.cdac_sw_9b_0.S[0] sky130_fd_pr__cap_mim_m3_1 l=2 w=2
X1196 a_14143_22138# a_13968_22164# a_14322_22164# VGND sky130_fd_pr__nfet_01v8 ad=0.1092 pd=1.36 as=0.06405 ps=0.725 w=0.42 l=0.15
X1197 sar9b_0.clknet_1_0__leaf_CLK a_6701_20506# VDPWR VDPWR sky130_fd_pr__pfet_01v8_hvt ad=0.14 pd=1.28 as=0.14 ps=1.28 w=1 l=0.15
X1198 a_6246_19444# a_5999_19822# VDPWR VDPWR sky130_fd_pr__pfet_01v8_hvt ad=0.07665 pd=0.785 as=0.17887 ps=1.26 w=0.42 l=0.15
X1199 VGND VDPWR VGND VGND sky130_fd_pr__nfet_01v8 ad=0.143 pd=1.62 as=0 ps=0 w=0.55 l=0.59
X1200 th_dif_sw_0.VCN single_9b_cdac_0.cdac_sw_9b_0.S[0] sky130_fd_pr__cap_mim_m3_1 l=2 w=2
X1201 single_9b_cdac_1.cdac_sw_9b_0.cdac_sw_3_4.tg_sw_3_3.SWP single_9b_cdac_1.cdac_sw_9b_0.cdac_sw_3_4.tg_sw_3_3.SWN VGND VGND sky130_fd_pr__nfet_01v8_lvt ad=0.1036 pd=1.02 as=0.1554 ps=1.16 w=0.74 l=0.15
X1202 VDPWR sar9b_0.net3 a_6308_27060# VDPWR sky130_fd_pr__pfet_01v8_hvt ad=0.07035 pd=0.755 as=0.1092 ps=1.36 w=0.42 l=0.15
X1203 single_9b_cdac_1.cdac_sw_9b_0.cdac_sw_3_3.tg_sw_3_3.SWP single_9b_cdac_1.cdac_sw_9b_0.cdac_sw_3_3.tg_sw_3_3.SWN VGND VGND sky130_fd_pr__nfet_01v8_lvt ad=0.1036 pd=1.02 as=0.1036 ps=1.02 w=0.74 l=0.15
X1204 a_11935_25402# sar9b_0.net15 VDPWR VDPWR sky130_fd_pr__pfet_01v8_hvt ad=0.0567 pd=0.69 as=0.0819 ps=0.81 w=0.42 l=0.15
X1205 VDPWR VGND VDPWR VDPWR sky130_fd_pr__pfet_01v8_hvt ad=0.2262 pd=2.26 as=0 ps=0 w=0.87 l=0.59
X1206 a_8708_19810# sar9b_0.net15 VGND VGND sky130_fd_pr__nfet_01v8 ad=0.066 pd=0.745 as=0.2205 ps=1.89 w=0.42 l=0.15
X1207 th_dif_sw_0.VCP single_9b_cdac_1.cdac_sw_9b_0.S[0] sky130_fd_pr__cap_mim_m3_1 l=2 w=2
X1208 VGND a_21177_7457# th_dif_sw_0.th_sw_1.CKB VGND sky130_fd_pr__nfet_01v8_lvt ad=0.1554 pd=1.16 as=0.1036 ps=1.02 w=0.74 l=0.15
X1209 VGND single_9b_cdac_0.SW[4] a_44418_26990# VGND sky130_fd_pr__nfet_01v8 ad=0.145 pd=1.58 as=0.145 ps=1.58 w=0.5 l=0.5
X1210 single_9b_cdac_1.cdac_sw_9b_0.cdac_sw_3_0.nooverlap_clk_0.CLKB0 single_9b_cdac_1.cdac_sw_9b_0.cdac_sw_3_0.nooverlap_clk_0.sky130_fd_sc_hs__inv_8_0.A VGND VGND sky130_fd_pr__nfet_01v8_lvt ad=0.1036 pd=1.02 as=0.1554 ps=1.16 w=0.74 l=0.15
X1211 th_dif_sw_0.VCP single_9b_cdac_1.cdac_sw_9b_0.S[4] sky130_fd_pr__cap_mim_m3_1 l=2 w=2
X1212 th_dif_sw_0.VCN single_9b_cdac_0.cdac_sw_9b_0.S[1] sky130_fd_pr__cap_mim_m3_1 l=2 w=2
X1213 a_6213_26516# a_6169_26758# a_6047_26516# VGND sky130_fd_pr__nfet_01v8 ad=0.0441 pd=0.63 as=0.1401 ps=1.1 w=0.42 l=0.15
X1214 VDPWR a_6219_22316# sar9b_0._04_ VDPWR sky130_fd_pr__pfet_01v8_hvt ad=0.14222 pd=1.335 as=0.26 ps=2.52 w=1 l=0.15
X1215 VGND a_14143_19962# a_14077_19988# VGND sky130_fd_pr__nfet_01v8 ad=0.12495 pd=1.015 as=0.0669 ps=0.75 w=0.42 l=0.15
X1216 single_9b_cdac_1.cdac_sw_9b_0.cdac_sw_3_6.nooverlap_clk_0.CLKB0 single_9b_cdac_1.cdac_sw_9b_0.cdac_sw_3_6.nooverlap_clk_0.sky130_fd_sc_hs__inv_8_0.A VGND VGND sky130_fd_pr__nfet_01v8_lvt ad=0.1036 pd=1.02 as=0.2109 ps=2.05 w=0.74 l=0.15
X1217 VDPWR VGND VDPWR VDPWR sky130_fd_pr__pfet_01v8_hvt ad=0.2262 pd=2.26 as=0 ps=0 w=0.87 l=0.59
X1218 single_9b_cdac_1.cdac_sw_9b_0.cdac_sw_3_5.nooverlap_clk_0.x1.A single_9b_cdac_1.cdac_sw_9b_0.cdac_sw_3_5.nooverlap_clk_0.sky130_fd_sc_hs__inv_1_1.A VDPWR VDPWR sky130_fd_pr__pfet_01v8 ad=0.3304 pd=2.83 as=0.3864 ps=2.93 w=1.12 l=0.15
X1219 th_dif_sw_0.VCP single_9b_cdac_1.cdac_sw_9b_0.S[3] sky130_fd_pr__cap_mim_m3_1 l=2 w=2
X1220 th_dif_sw_0.VCP single_9b_cdac_1.cdac_sw_9b_0.S[1] sky130_fd_pr__cap_mim_m3_1 l=2 w=2
X1221 th_dif_sw_0.VCN single_9b_cdac_0.cdac_sw_9b_0.S[2] sky130_fd_pr__cap_mim_m3_1 l=2 w=2
X1222 VGND single_9b_cdac_0.cdac_sw_9b_0.cdac_sw_3_4.nooverlap_clk_0.CLKB0 single_9b_cdac_0.cdac_sw_9b_0.cdac_sw_3_4.nooverlap_clk_0.CLK0 VGND sky130_fd_pr__nfet_01v8_lvt ad=0.1036 pd=1.02 as=0.1036 ps=1.02 w=0.74 l=0.15
X1223 VGND single_9b_cdac_0.cdac_sw_9b_0.cdac_sw_3_2.nooverlap_clk_0.sky130_fd_sc_hs__inv_8_0.A single_9b_cdac_0.cdac_sw_9b_0.cdac_sw_3_2.nooverlap_clk_0.CLKB0 VGND sky130_fd_pr__nfet_01v8_lvt ad=0.1036 pd=1.02 as=0.1036 ps=1.02 w=0.74 l=0.15
X1224 VDPWR a_14143_19748# a_14130_19444# VDPWR sky130_fd_pr__pfet_01v8_hvt ad=0.0819 pd=0.81 as=0.0567 ps=0.69 w=0.42 l=0.15
X1225 single_9b_cdac_1.cdac_sw_9b_0.S[8] single_9b_cdac_1.cdac_sw_9b_0.cdac_sw_3_8.tg_sw_3_3.SWP single_9b_cdac_1.cdac_sw_9b_0.S[8] VDPWR sky130_fd_pr__pfet_01v8 ad=0.435 pd=3.58 as=0 ps=0 w=1.5 l=0.5
X1226 a_5945_26191# sar9b_0.net17 VGND VGND sky130_fd_pr__nfet_01v8 ad=0.1352 pd=1.56 as=0.0754 ps=0.81 w=0.52 l=0.15
X1227 th_dif_sw_0.VCP single_9b_cdac_1.cdac_sw_9b_0.S[0] sky130_fd_pr__cap_mim_m3_1 l=2 w=2
X1228 th_dif_sw_0.VCN single_9b_cdac_0.cdac_sw_9b_0.S[1] sky130_fd_pr__cap_mim_m3_1 l=2 w=2
X1229 th_dif_sw_0.th_sw_1.CK a_9132_7271# VDPWR VDPWR sky130_fd_pr__pfet_01v8 ad=0.168 pd=1.42 as=0.168 ps=1.42 w=1.12 l=0.15
X1230 single_9b_cdac_0.cdac_sw_9b_0.S[6] single_9b_cdac_0.cdac_sw_9b_0.cdac_sw_3_6.tg_sw_3_3.SWP single_9b_cdac_0.cdac_sw_9b_0.S[6] VDPWR sky130_fd_pr__pfet_01v8 ad=0.435 pd=3.58 as=6.96 ps=57.28 w=1.5 l=0.5
X1231 VDPWR single_9b_cdac_0.cdac_sw_9b_0.cdac_sw_3_2.nooverlap_clk_0.x4.A single_9b_cdac_0.cdac_sw_9b_0.cdac_sw_3_2.nooverlap_clk_0.x6.A VDPWR sky130_fd_pr__pfet_01v8 ad=0.3864 pd=2.93 as=0.3304 ps=2.83 w=1.12 l=0.15
X1232 a_14130_25794# a_13053_25428# a_13968_25428# VDPWR sky130_fd_pr__pfet_01v8_hvt ad=0.0567 pd=0.69 as=0.0588 ps=0.7 w=0.42 l=0.15
X1233 VGND VDPWR VGND VGND sky130_fd_pr__nfet_01v8 ad=0.143 pd=1.62 as=0 ps=0 w=0.55 l=0.59
X1234 th_dif_sw_0.VCP single_9b_cdac_1.cdac_sw_9b_0.S[3] sky130_fd_pr__cap_mim_m3_1 l=2 w=2
X1235 th_dif_sw_0.VCN single_9b_cdac_0.cdac_sw_9b_0.S[0] sky130_fd_pr__cap_mim_m3_1 l=2 w=2
X1236 VGND single_9b_cdac_0.cdac_sw_9b_0.cdac_sw_3_0.nooverlap_clk_0.x3.Y a_54737_29917# VGND sky130_fd_pr__nfet_01v8_lvt ad=0.2109 pd=2.05 as=0.0888 ps=0.98 w=0.74 l=0.15
X1237 VDPWR single_9b_cdac_0.cdac_sw_9b_0.cdac_sw_3_4.nooverlap_clk_0.sky130_fd_sc_hs__inv_8_0.A single_9b_cdac_0.cdac_sw_9b_0.cdac_sw_3_4.nooverlap_clk_0.CLKB0 VDPWR sky130_fd_pr__pfet_01v8 ad=0.3304 pd=2.83 as=0.168 ps=1.42 w=1.12 l=0.15
X1238 single_9b_cdac_1.cdac_sw_9b_0.cdac_sw_3_7.nooverlap_clk_0.x6.A single_9b_cdac_1.cdac_sw_9b_0.cdac_sw_3_7.nooverlap_clk_0.x4.A VDPWR VDPWR sky130_fd_pr__pfet_01v8 ad=0.3304 pd=2.83 as=0.3864 ps=2.93 w=1.12 l=0.15
X1239 ua[0] single_9b_cdac_1.cdac_sw_9b_0.cdac_sw_3_3.tg_sw_3_3.SWN ua[0] VGND sky130_fd_pr__nfet_01v8 ad=0.145 pd=1.58 as=0 ps=0 w=0.5 l=0.5
X1240 VGND sar9b_0.net9 a_14451_21620# VGND sky130_fd_pr__nfet_01v8 ad=0.0754 pd=0.81 as=0.1352 ps=1.56 w=0.52 l=0.15
X1241 th_dif_sw_0.VCP single_9b_cdac_1.cdac_sw_9b_0.S[0] sky130_fd_pr__cap_mim_m3_1 l=2 w=2
X1242 single_9b_cdac_0.cdac_sw_9b_0.cdac_sw_3_4.nooverlap_clk_0.CLKB0 single_9b_cdac_0.cdac_sw_9b_0.cdac_sw_3_4.nooverlap_clk_0.sky130_fd_sc_hs__inv_8_0.A VDPWR VDPWR sky130_fd_pr__pfet_01v8 ad=0.168 pd=1.42 as=0.196 ps=1.47 w=1.12 l=0.15
X1243 th_dif_sw_0.VCN single_9b_cdac_0.cdac_sw_9b_0.S[0] sky130_fd_pr__cap_mim_m3_1 l=2 w=2
X1244 a_21177_7457# th_dif_sw_0.CKB VGND VGND sky130_fd_pr__nfet_01v8_lvt ad=0.1036 pd=1.02 as=0.1036 ps=1.02 w=0.74 l=0.15
X1245 a_6960_26338# sar9b_0.net38 VDPWR VDPWR sky130_fd_pr__pfet_01v8_hvt ad=0.0651 pd=0.73 as=0.1092 ps=1.36 w=0.42 l=0.15
X1246 VDPWR sar9b_0.net11 a_13899_23252# VDPWR sky130_fd_pr__pfet_01v8_hvt ad=0.11455 pd=1.08 as=0.2054 ps=2.1 w=0.79 l=0.15
X1247 sar9b_0._12_ sar9b_0.clk_div_0.COUNT\[0\] a_7809_23028# VGND sky130_fd_pr__nfet_01v8 ad=0.169 pd=1.82 as=0.10725 ps=0.98 w=0.65 l=0.15
X1248 a_13403_21076# a_12887_21076# a_13308_21076# VGND sky130_fd_pr__special_nfet_01v8 ad=0.0594 pd=0.69 as=0.066 ps=0.745 w=0.36 l=0.15
X1249 VDPWR a_6701_20506# sar9b_0.clknet_1_0__leaf_CLK VDPWR sky130_fd_pr__pfet_01v8_hvt ad=0.14 pd=1.28 as=0.14 ps=1.28 w=1 l=0.15
X1250 a_11965_20506# a_11747_20910# VDPWR VDPWR sky130_fd_pr__pfet_01v8_hvt ad=0.12915 pd=1.185 as=0.2184 ps=2.2 w=0.84 l=0.15
X1251 VGND VDPWR VGND VGND sky130_fd_pr__nfet_01v8 ad=0.143 pd=1.62 as=0 ps=0 w=0.55 l=0.59
X1252 a_25210_17740# single_9b_cdac_1.cdac_sw_9b_0.cdac_sw_3_8.nooverlap_clk_0.CLK0 single_9b_cdac_1.cdac_sw_9b_0.S[8] VGND sky130_fd_pr__nfet_01v8 ad=0.145 pd=1.58 as=0.145 ps=1.58 w=0.5 l=0.5
X1253 VDPWR single_9b_cdac_1.cdac_sw_9b_0.cdac_sw_3_5.nooverlap_clk_0.x10.A single_9b_cdac_1.cdac_sw_9b_0.cdac_sw_3_5.tg_sw_3_3.SWN VDPWR sky130_fd_pr__pfet_01v8 ad=0.196 pd=1.47 as=0.168 ps=1.42 w=1.12 l=0.15
X1254 VGND single_9b_cdac_0.cdac_sw_9b_0.cdac_sw_3_5.nooverlap_clk_0.x10.A single_9b_cdac_0.cdac_sw_9b_0.cdac_sw_3_5.tg_sw_3_3.SWN VGND sky130_fd_pr__nfet_01v8_lvt ad=0.1554 pd=1.16 as=0.1036 ps=1.02 w=0.74 l=0.15
X1255 sar9b_0.net34 a_14143_26490# VGND VGND sky130_fd_pr__nfet_01v8 ad=0.169 pd=1.82 as=0.2087 ps=2.02 w=0.65 l=0.15
X1256 VGND a_9167_18874# sar9b_0.net35 VGND sky130_fd_pr__nfet_01v8 ad=0.2087 pd=2.02 as=0.169 ps=1.82 w=0.65 l=0.15
X1257 single_9b_cdac_1.cdac_sw_9b_0.S[2] single_9b_cdac_1.cdac_sw_9b_0.cdac_sw_3_0.nooverlap_clk_0.CLKB0 a_53154_16877# VDPWR sky130_fd_pr__pfet_01v8 ad=0.435 pd=3.58 as=0.435 ps=3.58 w=1.5 l=0.5
X1258 th_dif_sw_0.VCN single_9b_cdac_0.cdac_sw_9b_0.S[1] sky130_fd_pr__cap_mim_m3_1 l=2 w=2
X1259 VGND VDPWR VGND VGND sky130_fd_pr__nfet_01v8 ad=0.143 pd=1.62 as=0 ps=0 w=0.55 l=0.59
X1260 a_6070_19721# a_5863_19662# a_6246_19444# VDPWR sky130_fd_pr__pfet_01v8_hvt ad=0.06825 pd=0.745 as=0.07665 ps=0.785 w=0.42 l=0.15
X1261 VDPWR a_21177_7457# th_dif_sw_0.th_sw_1.CKB VDPWR sky130_fd_pr__pfet_01v8 ad=0.168 pd=1.42 as=0.168 ps=1.42 w=1.12 l=0.15
X1262 VDPWR VGND VDPWR VDPWR sky130_fd_pr__pfet_01v8_hvt ad=0.2262 pd=2.26 as=0 ps=0 w=0.87 l=0.59
X1263 a_10935_19444# a_10311_19450# a_10827_19822# VDPWR sky130_fd_pr__pfet_01v8_hvt ad=0.1155 pd=0.97 as=0.07245 ps=0.765 w=0.42 l=0.15
X1264 th_dif_sw_0.VCN single_9b_cdac_0.cdac_sw_9b_0.S[1] sky130_fd_pr__cap_mim_m3_1 l=2 w=2
X1265 single_9b_cdac_1.SW[1] a_14451_18356# VDPWR VDPWR sky130_fd_pr__pfet_01v8_hvt ad=0.2054 pd=2.1 as=0.11455 ps=1.08 w=0.79 l=0.15
X1266 VGND single_9b_cdac_1.cdac_sw_9b_0.cdac_sw_3_8.nooverlap_clk_0.x10.A single_9b_cdac_1.cdac_sw_9b_0.cdac_sw_3_8.tg_sw_3_3.SWN VGND sky130_fd_pr__nfet_01v8_lvt ad=0.1036 pd=1.02 as=0.1036 ps=1.02 w=0.74 l=0.15
X1267 VGND single_9b_cdac_1.cdac_sw_9b_0.cdac_sw_3_1.tg_sw_3_3.SWN single_9b_cdac_1.cdac_sw_9b_0.cdac_sw_3_1.tg_sw_3_3.SWP VGND sky130_fd_pr__nfet_01v8_lvt ad=0.2146 pd=2.06 as=0.1036 ps=1.02 w=0.74 l=0.15
X1268 single_9b_cdac_0.cdac_sw_9b_0.cdac_sw_3_2.tg_sw_3_3.SWP single_9b_cdac_0.cdac_sw_9b_0.cdac_sw_3_2.tg_sw_3_3.SWN VDPWR VDPWR sky130_fd_pr__pfet_01v8 ad=0.168 pd=1.42 as=0.3864 ps=2.93 w=1.12 l=0.15
X1269 single_9b_cdac_1.cdac_sw_9b_0.cdac_sw_3_5.nooverlap_clk_0.x10.A single_9b_cdac_1.cdac_sw_9b_0.cdac_sw_3_5.nooverlap_clk_0.x8.A VGND VGND sky130_fd_pr__nfet_01v8_lvt ad=0.1184 pd=1.06 as=0.2331 ps=2.11 w=0.74 l=0.15
X1270 single_9b_cdac_1.cdac_sw_9b_0.cdac_sw_3_3.nooverlap_clk_0.CLKB0 single_9b_cdac_1.cdac_sw_9b_0.cdac_sw_3_3.nooverlap_clk_0.sky130_fd_sc_hs__inv_8_0.A VGND VGND sky130_fd_pr__nfet_01v8_lvt ad=0.1036 pd=1.02 as=0.1554 ps=1.16 w=0.74 l=0.15
X1271 th_dif_sw_0.VCN single_9b_cdac_0.cdac_sw_9b_0.S[0] sky130_fd_pr__cap_mim_m3_1 l=2 w=2
X1272 single_9b_cdac_0.cdac_sw_9b_0.cdac_sw_3_4.nooverlap_clk_0.x10.A single_9b_cdac_0.cdac_sw_9b_0.cdac_sw_3_4.nooverlap_clk_0.x8.A VDPWR VDPWR sky130_fd_pr__pfet_01v8 ad=0.168 pd=1.42 as=0.168 ps=1.42 w=1.12 l=0.15
X1273 VDPWR sar9b_0.FINAL a_11691_25978# VDPWR sky130_fd_pr__pfet_01v8_hvt ad=0.0864 pd=0.91 as=0.1664 ps=1.8 w=0.64 l=0.15
X1274 sar9b_0.net31 a_14051_24100# VGND VGND sky130_fd_pr__nfet_01v8 ad=0.169 pd=1.82 as=0.2087 ps=2.02 w=0.65 l=0.15
X1275 VGND VDPWR VGND VGND sky130_fd_pr__nfet_01v8 ad=0.143 pd=1.62 as=0 ps=0 w=0.55 l=0.59
X1276 VGND single_9b_cdac_1.cdac_sw_9b_0.cdac_sw_3_5.nooverlap_clk_0.x10.A single_9b_cdac_1.cdac_sw_9b_0.cdac_sw_3_5.tg_sw_3_3.SWN VGND sky130_fd_pr__nfet_01v8_lvt ad=0.1295 pd=1.09 as=0.1036 ps=1.02 w=0.74 l=0.15
X1277 th_dif_sw_0.VCP single_9b_cdac_1.cdac_sw_9b_0.S[0] sky130_fd_pr__cap_mim_m3_1 l=2 w=2
X1278 a_8085_27066# a_7919_27066# VDPWR VDPWR sky130_fd_pr__pfet_01v8_hvt ad=0.1664 pd=1.8 as=0.0864 ps=0.91 w=0.64 l=0.15
X1279 VDPWR single_9b_cdac_0.cdac_sw_9b_0.cdac_sw_3_7.nooverlap_clk_0.sky130_fd_sc_hs__inv_8_0.A single_9b_cdac_0.cdac_sw_9b_0.cdac_sw_3_7.nooverlap_clk_0.CLKB0 VDPWR sky130_fd_pr__pfet_01v8 ad=0.196 pd=1.47 as=0.168 ps=1.42 w=1.12 l=0.15
X1280 VGND single_9b_cdac_0.cdac_sw_9b_0.cdac_sw_3_6.nooverlap_clk_0.sky130_fd_sc_hs__inv_8_0.A single_9b_cdac_0.cdac_sw_9b_0.cdac_sw_3_6.nooverlap_clk_0.CLKB0 VGND sky130_fd_pr__nfet_01v8_lvt ad=0.2109 pd=2.05 as=0.1036 ps=1.02 w=0.74 l=0.15
X1281 VDPWR single_9b_cdac_0.cdac_sw_9b_0.cdac_sw_3_6.tg_sw_3_3.SWN single_9b_cdac_0.cdac_sw_9b_0.cdac_sw_3_6.tg_sw_3_3.SWP VDPWR sky130_fd_pr__pfet_01v8 ad=0.196 pd=1.47 as=0.168 ps=1.42 w=1.12 l=0.15
X1282 a_12036_24174# a_11121_23802# a_11689_23770# VGND sky130_fd_pr__special_nfet_01v8 ad=0.0711 pd=0.755 as=0.0999 ps=0.985 w=0.36 l=0.15
X1283 a_11747_20910# a_11231_20538# a_11652_20898# VGND sky130_fd_pr__special_nfet_01v8 ad=0.0594 pd=0.69 as=0.066 ps=0.745 w=0.36 l=0.15
X1284 single_9b_cdac_1.cdac_sw_9b_0.S[4] single_9b_cdac_1.cdac_sw_9b_0.cdac_sw_3_3.tg_sw_3_3.SWP ua[0] VGND sky130_fd_pr__nfet_01v8 ad=0.145 pd=1.58 as=0.145 ps=1.58 w=0.5 l=0.5
X1285 VDPWR single_9b_cdac_0.cdac_sw_9b_0.cdac_sw_3_4.nooverlap_clk_0.x8.A single_9b_cdac_0.cdac_sw_9b_0.cdac_sw_3_4.nooverlap_clk_0.x10.A VDPWR sky130_fd_pr__pfet_01v8 ad=0.168 pd=1.42 as=0.168 ps=1.42 w=1.12 l=0.15
X1286 a_12036_18900# a_11121_18900# a_11689_19142# VGND sky130_fd_pr__special_nfet_01v8 ad=0.0711 pd=0.755 as=0.0999 ps=0.985 w=0.36 l=0.15
X1287 th_dif_sw_0.VCN single_9b_cdac_0.cdac_sw_9b_0.S[2] sky130_fd_pr__cap_mim_m3_1 l=2 w=2
X1288 single_9b_cdac_0.cdac_sw_9b_0.cdac_sw_3_7.tg_sw_3_3.SWN single_9b_cdac_0.cdac_sw_9b_0.cdac_sw_3_7.nooverlap_clk_0.x10.A VGND VGND sky130_fd_pr__nfet_01v8_lvt ad=0.1036 pd=1.02 as=0.1295 ps=1.09 w=0.74 l=0.15
X1289 a_9281_21076# a_9115_21076# VDPWR VDPWR sky130_fd_pr__pfet_01v8_hvt ad=0.1664 pd=1.8 as=0.0864 ps=0.91 w=0.64 l=0.15
X1290 single_9b_cdac_0.cdac_sw_9b_0.cdac_sw_3_7.nooverlap_clk_0.CLKB0 single_9b_cdac_0.cdac_sw_9b_0.cdac_sw_3_7.nooverlap_clk_0.sky130_fd_sc_hs__inv_8_0.A VDPWR VDPWR sky130_fd_pr__pfet_01v8 ad=0.168 pd=1.42 as=0.168 ps=1.42 w=1.12 l=0.15
X1291 single_9b_cdac_0.cdac_sw_9b_0.cdac_sw_3_6.tg_sw_3_3.SWP single_9b_cdac_0.cdac_sw_9b_0.cdac_sw_3_6.tg_sw_3_3.SWN VDPWR VDPWR sky130_fd_pr__pfet_01v8 ad=0.168 pd=1.42 as=0.168 ps=1.42 w=1.12 l=0.15
X1292 VGND single_9b_cdac_0.cdac_sw_9b_0.cdac_sw_3_6.tg_sw_3_3.SWN single_9b_cdac_0.cdac_sw_9b_0.cdac_sw_3_6.tg_sw_3_3.SWP VGND sky130_fd_pr__nfet_01v8_lvt ad=0.1554 pd=1.16 as=0.1036 ps=1.02 w=0.74 l=0.15
X1293 VGND single_9b_cdac_0.SW[2] a_54032_26990# VGND sky130_fd_pr__nfet_01v8 ad=0.145 pd=1.58 as=0.145 ps=1.58 w=0.5 l=0.5
X1294 VDPWR a_13621_22682# a_13511_22708# VDPWR sky130_fd_pr__pfet_01v8_hvt ad=0.07035 pd=0.755 as=0.1155 ps=0.97 w=0.42 l=0.15
X1295 VGND a_6930_20241# a_6888_19988# VGND sky130_fd_pr__nfet_01v8 ad=0.1197 pd=1.41 as=0.066 ps=0.745 w=0.42 l=0.15
X1296 VGND single_9b_cdac_1.SW[4] a_44418_17740# VGND sky130_fd_pr__nfet_01v8 ad=0.145 pd=1.58 as=0.145 ps=1.58 w=0.5 l=0.5
X1297 th_dif_sw_0.VCP single_9b_cdac_1.cdac_sw_9b_0.S[2] sky130_fd_pr__cap_mim_m3_1 l=2 w=2
X1298 single_9b_cdac_0.cdac_sw_9b_0.cdac_sw_3_4.nooverlap_clk_0.x10.A single_9b_cdac_0.cdac_sw_9b_0.cdac_sw_3_4.nooverlap_clk_0.x8.A VDPWR VDPWR sky130_fd_pr__pfet_01v8 ad=0.168 pd=1.42 as=0.3304 ps=2.83 w=1.12 l=0.15
X1299 th_dif_sw_0.VCP single_9b_cdac_1.cdac_sw_9b_0.S[0] sky130_fd_pr__cap_mim_m3_1 l=2 w=2
X1300 VDPWR single_9b_cdac_0.cdac_sw_9b_0.cdac_sw_3_7.nooverlap_clk_0.sky130_fd_sc_hs__inv_8_0.A single_9b_cdac_0.cdac_sw_9b_0.cdac_sw_3_7.nooverlap_clk_0.CLKB0 VDPWR sky130_fd_pr__pfet_01v8 ad=0.168 pd=1.42 as=0.168 ps=1.42 w=1.12 l=0.15
X1301 single_9b_cdac_0.cdac_sw_9b_0.cdac_sw_3_1.nooverlap_clk_0.sky130_fd_sc_hs__nand2_1_0.Y single_9b_cdac_1.CF[1] a_60565_29911# VGND sky130_fd_pr__nfet_01v8_lvt ad=0.2109 pd=2.05 as=0.0888 ps=0.98 w=0.74 l=0.15
X1302 VGND single_9b_cdac_0.cdac_sw_9b_0.cdac_sw_3_1.nooverlap_clk_0.x4.A single_9b_cdac_0.cdac_sw_9b_0.cdac_sw_3_1.nooverlap_clk_0.x6.A VGND sky130_fd_pr__nfet_01v8_lvt ad=0.2627 pd=2.19 as=0.2109 ps=2.05 w=0.74 l=0.15
X1303 single_9b_cdac_0.cdac_sw_9b_0.cdac_sw_3_1.nooverlap_clk_0.CLK0 single_9b_cdac_0.cdac_sw_9b_0.cdac_sw_3_1.nooverlap_clk_0.CLKB0 VGND VGND sky130_fd_pr__nfet_01v8_lvt ad=0.1036 pd=1.02 as=0.1036 ps=1.02 w=0.74 l=0.15
X1304 th_dif_sw_0.VCP single_9b_cdac_1.cdac_sw_9b_0.S[2] sky130_fd_pr__cap_mim_m3_1 l=2 w=2
X1305 th_dif_sw_0.VCN single_9b_cdac_0.cdac_sw_9b_0.S[0] sky130_fd_pr__cap_mim_m3_1 l=2 w=2
X1306 VDPWR single_9b_cdac_0.cdac_sw_9b_0.cdac_sw_3_6.tg_sw_3_3.SWN single_9b_cdac_0.cdac_sw_9b_0.cdac_sw_3_6.tg_sw_3_3.SWP VDPWR sky130_fd_pr__pfet_01v8 ad=0.168 pd=1.42 as=0.168 ps=1.42 w=1.12 l=0.15
X1307 a_6525_22708# sar9b_0._04_ VGND VGND sky130_fd_pr__nfet_01v8 ad=0.0813 pd=0.83 as=0.1092 ps=1.36 w=0.42 l=0.15
X1308 VGND single_9b_cdac_1.cdac_sw_9b_0.cdac_sw_3_7.tg_sw_3_3.SWN single_9b_cdac_1.cdac_sw_9b_0.cdac_sw_3_7.tg_sw_3_3.SWP VGND sky130_fd_pr__nfet_01v8_lvt ad=0.1036 pd=1.02 as=0.1036 ps=1.02 w=0.74 l=0.15
X1309 single_9b_cdac_1.cdac_sw_9b_0.S[6] single_9b_cdac_1.cdac_sw_9b_0.cdac_sw_3_6.tg_sw_3_3.SWP single_9b_cdac_1.cdac_sw_9b_0.S[6] VDPWR sky130_fd_pr__pfet_01v8 ad=0.435 pd=3.58 as=6.96 ps=57.28 w=1.5 l=0.5
X1310 th_dif_sw_0.th_sw_1.CKB a_21177_7457# VGND VGND sky130_fd_pr__nfet_01v8_lvt ad=0.1036 pd=1.02 as=0.1036 ps=1.02 w=0.74 l=0.15
X1311 VDPWR single_9b_cdac_0.cdac_sw_9b_0.cdac_sw_3_6.nooverlap_clk_0.CLKB0 single_9b_cdac_0.cdac_sw_9b_0.cdac_sw_3_6.nooverlap_clk_0.CLK0 VDPWR sky130_fd_pr__pfet_01v8 ad=0.3304 pd=2.83 as=0.168 ps=1.42 w=1.12 l=0.15
X1312 a_50962_29911# single_9b_cdac_0.cdac_sw_9b_0.cdac_sw_3_4.nooverlap_clk_0.x8.A VGND VGND sky130_fd_pr__nfet_01v8_lvt ad=0.0888 pd=0.98 as=0.2109 ps=2.05 w=0.74 l=0.15
X1313 VGND VDPWR VGND VGND sky130_fd_pr__nfet_01v8 ad=0.143 pd=1.62 as=0 ps=0 w=0.55 l=0.59
X1314 VGND single_9b_cdac_1.cdac_sw_9b_0.cdac_sw_3_6.nooverlap_clk_0.x8.A single_9b_cdac_1.cdac_sw_9b_0.cdac_sw_3_6.nooverlap_clk_0.x10.A VGND sky130_fd_pr__nfet_01v8_lvt ad=0.1221 pd=1.07 as=0.1184 ps=1.06 w=0.74 l=0.15
X1315 single_9b_cdac_1.cdac_sw_9b_0.cdac_sw_3_4.nooverlap_clk_0.CLKB0 single_9b_cdac_1.cdac_sw_9b_0.cdac_sw_3_4.nooverlap_clk_0.sky130_fd_sc_hs__inv_8_0.A VDPWR VDPWR sky130_fd_pr__pfet_01v8 ad=0.168 pd=1.42 as=0.3304 ps=2.83 w=1.12 l=0.15
X1316 th_dif_sw_0.VCN single_9b_cdac_0.cdac_sw_9b_0.S[3] sky130_fd_pr__cap_mim_m3_1 l=2 w=2
X1317 single_9b_cdac_1.cdac_sw_9b_0.cdac_sw_3_1.nooverlap_clk_0.x8.A single_9b_cdac_1.cdac_sw_9b_0.cdac_sw_3_1.nooverlap_clk_0.x6.A VGND VGND sky130_fd_pr__nfet_01v8_lvt ad=0.2109 pd=2.05 as=0.2627 ps=2.19 w=0.74 l=0.15
X1318 VDPWR sar9b_0.clknet_0_CLK a_6149_23770# VDPWR sky130_fd_pr__pfet_01v8_hvt ad=0.14 pd=1.28 as=0.14 ps=1.28 w=1 l=0.15
X1319 VDPWR a_9368_19822# a_9543_19748# VDPWR sky130_fd_pr__pfet_01v8_hvt ad=0.1134 pd=1.38 as=0.0567 ps=0.69 w=0.42 l=0.15
X1320 a_9167_18874# a_9370_19152# VDPWR VDPWR sky130_fd_pr__pfet_01v8_hvt ad=0.0567 pd=0.69 as=0.1134 ps=1.38 w=0.42 l=0.15
X1321 VGND single_9b_cdac_1.cdac_sw_9b_0.cdac_sw_3_6.nooverlap_clk_0.x8.A a_36555_15501# VGND sky130_fd_pr__nfet_01v8_lvt ad=0.2109 pd=2.05 as=0.0888 ps=0.98 w=0.74 l=0.15
X1322 single_9b_cdac_0.cdac_sw_9b_0.cdac_sw_3_6.nooverlap_clk_0.CLK0 single_9b_cdac_0.cdac_sw_9b_0.cdac_sw_3_6.nooverlap_clk_0.CLKB0 VDPWR VDPWR sky130_fd_pr__pfet_01v8 ad=0.168 pd=1.42 as=0.196 ps=1.47 w=1.12 l=0.15
X1323 a_7046_25794# a_5969_25428# a_6884_25428# VDPWR sky130_fd_pr__pfet_01v8_hvt ad=0.0567 pd=0.69 as=0.0588 ps=0.7 w=0.42 l=0.15
X1324 VDPWR VGND VDPWR VDPWR sky130_fd_pr__pfet_01v8_hvt ad=0.2262 pd=2.26 as=0 ps=0 w=0.87 l=0.59
X1325 a_10774_20354# a_10016_20256# a_10211_20225# VDPWR sky130_fd_pr__pfet_01v8_hvt ad=0.0651 pd=0.73 as=0.07245 ps=0.765 w=0.42 l=0.15
X1326 th_dif_sw_0.VCN single_9b_cdac_0.cdac_sw_9b_0.S[1] sky130_fd_pr__cap_mim_m3_1 l=2 w=2
X1327 VDPWR single_9b_cdac_1.CF[6] single_9b_cdac_0.cdac_sw_9b_0.cdac_sw_3_6.nooverlap_clk_0.x3.Y VDPWR sky130_fd_pr__pfet_01v8 ad=0.3864 pd=2.93 as=0.3304 ps=2.83 w=1.12 l=0.15
X1328 a_35519_29917# single_9b_cdac_0.cdac_sw_9b_0.cdac_sw_3_6.nooverlap_clk_0.x1.A single_9b_cdac_0.cdac_sw_9b_0.cdac_sw_3_6.nooverlap_clk_0.x4.A VGND sky130_fd_pr__nfet_01v8_lvt ad=0.0888 pd=0.98 as=0.2109 ps=2.05 w=0.74 l=0.15
X1329 a_12198_19266# a_11121_18900# a_12036_18900# VDPWR sky130_fd_pr__pfet_01v8_hvt ad=0.0567 pd=0.69 as=0.0588 ps=0.7 w=0.42 l=0.15
X1330 single_9b_cdac_1.SW[0] a_14175_18356# VGND VGND sky130_fd_pr__nfet_01v8 ad=0.1352 pd=1.56 as=0.0754 ps=0.81 w=0.52 l=0.15
X1331 th_dif_sw_0.VCP single_9b_cdac_1.cdac_sw_9b_0.S[1] sky130_fd_pr__cap_mim_m3_1 l=2 w=2
X1332 VDPWR single_9b_cdac_1.CF[8] single_9b_cdac_0.cdac_sw_9b_0.cdac_sw_3_8.nooverlap_clk_0.sky130_fd_sc_hs__nand2_1_0.Y VDPWR sky130_fd_pr__pfet_01v8 ad=0.3192 pd=2.81 as=0.168 ps=1.42 w=1.12 l=0.15
X1333 VGND single_9b_cdac_0.SW[8] a_25210_26990# VGND sky130_fd_pr__nfet_01v8 ad=0.145 pd=1.58 as=0.145 ps=1.58 w=0.5 l=0.5
X1334 a_9352_22164# sar9b_0.net2 VDPWR VDPWR sky130_fd_pr__pfet_01v8_hvt ad=0.0651 pd=0.73 as=0.1092 ps=1.36 w=0.42 l=0.15
X1335 th_dif_sw_0.VCP single_9b_cdac_1.cdac_sw_9b_0.S[0] sky130_fd_pr__cap_mim_m3_1 l=2 w=2
X1336 th_dif_sw_0.VCN single_9b_cdac_0.cdac_sw_9b_0.S[1] sky130_fd_pr__cap_mim_m3_1 l=2 w=2
X1337 single_9b_cdac_0.cdac_sw_9b_0.S[3] single_9b_cdac_0.cdac_sw_9b_0.cdac_sw_3_4.tg_sw_3_3.SWN ua[0] VDPWR sky130_fd_pr__pfet_01v8 ad=0.435 pd=3.58 as=0.435 ps=3.58 w=1.5 l=0.5
X1338 VDPWR VGND VDPWR VDPWR sky130_fd_pr__pfet_01v8_hvt ad=0.2262 pd=2.26 as=0 ps=0 w=0.87 l=0.59
X1339 sar9b_0.net27 a_14143_19962# VGND VGND sky130_fd_pr__nfet_01v8 ad=0.169 pd=1.82 as=0.2087 ps=2.02 w=0.65 l=0.15
X1340 ua[0] single_9b_cdac_1.cdac_sw_9b_0.cdac_sw_3_0.tg_sw_3_3.SWP ua[0] VDPWR sky130_fd_pr__pfet_01v8 ad=0.435 pd=3.58 as=0 ps=0 w=1.5 l=0.5
X1341 VGND VDPWR VGND VGND sky130_fd_pr__nfet_01v8 ad=0.143 pd=1.62 as=0 ps=0 w=0.55 l=0.59
X1342 single_9b_cdac_1.cdac_sw_9b_0.cdac_sw_3_6.tg_sw_3_3.SWN single_9b_cdac_1.cdac_sw_9b_0.cdac_sw_3_6.nooverlap_clk_0.x10.A VGND VGND sky130_fd_pr__nfet_01v8_lvt ad=0.1036 pd=1.02 as=0.1036 ps=1.02 w=0.74 l=0.15
X1343 th_dif_sw_0.VCN single_9b_cdac_0.cdac_sw_9b_0.S[0] sky130_fd_pr__cap_mim_m3_1 l=2 w=2
X1344 single_9b_cdac_0.cdac_sw_9b_0.cdac_sw_3_8.nooverlap_clk_0.sky130_fd_sc_hs__nand2_1_0.Y single_9b_cdac_0.cdac_sw_9b_0.cdac_sw_3_8.nooverlap_clk_0.x8.A VDPWR VDPWR sky130_fd_pr__pfet_01v8 ad=0.168 pd=1.42 as=0.3192 ps=2.81 w=1.12 l=0.15
X1345 th_dif_sw_0.VCP single_9b_cdac_1.cdac_sw_9b_0.S[0] sky130_fd_pr__cap_mim_m3_1 l=2 w=2
X1346 th_dif_sw_0.VCP single_9b_cdac_1.cdac_sw_9b_0.S[1] sky130_fd_pr__cap_mim_m3_1 l=2 w=2
X1347 th_dif_sw_0.VCN single_9b_cdac_0.cdac_sw_9b_0.S[3] sky130_fd_pr__cap_mim_m3_1 l=2 w=2
X1348 VDPWR VGND VDPWR VDPWR sky130_fd_pr__pfet_01v8_hvt ad=0.2262 pd=2.26 as=0 ps=0 w=0.87 l=0.59
X1349 th_dif_sw_0.VCN single_9b_cdac_0.cdac_sw_9b_0.S[0] sky130_fd_pr__cap_mim_m3_1 l=2 w=2
X1350 th_dif_sw_0.th_sw_1.CK a_9132_7271# VGND VGND sky130_fd_pr__nfet_01v8_lvt ad=0.1036 pd=1.02 as=0.1554 ps=1.16 w=0.74 l=0.15
X1351 single_9b_cdac_0.cdac_sw_9b_0.cdac_sw_3_5.tg_sw_3_3.SWN single_9b_cdac_0.cdac_sw_9b_0.cdac_sw_3_5.nooverlap_clk_0.x10.A VDPWR VDPWR sky130_fd_pr__pfet_01v8 ad=0.168 pd=1.42 as=0.196 ps=1.47 w=1.12 l=0.15
X1352 VDPWR VGND VDPWR VDPWR sky130_fd_pr__pfet_01v8_hvt ad=0.2262 pd=2.26 as=0 ps=0 w=0.87 l=0.59
X1353 th_dif_sw_0.VCN single_9b_cdac_0.cdac_sw_9b_0.S[1] sky130_fd_pr__cap_mim_m3_1 l=2 w=2
X1354 th_dif_sw_0.th_sw_1.th_sw_main_0.VGS VDPWR a_10482_3438# VGND sky130_fd_pr__nfet_01v8 ad=2.175 pd=15.58 as=2.175 ps=15.58 w=7.5 l=0.15
X1355 single_9b_cdac_1.cdac_sw_9b_0.cdac_sw_3_2.nooverlap_clk_0.CLK0 single_9b_cdac_1.cdac_sw_9b_0.cdac_sw_3_2.nooverlap_clk_0.CLKB0 VGND VGND sky130_fd_pr__nfet_01v8_lvt ad=0.1036 pd=1.02 as=0.2109 ps=2.05 w=0.74 l=0.15
X1356 single_9b_cdac_0.cdac_sw_9b_0.S[3] single_9b_cdac_0.cdac_sw_9b_0.cdac_sw_3_4.nooverlap_clk_0.CLKB0 a_48343_26999# VDPWR sky130_fd_pr__pfet_01v8 ad=0.435 pd=3.58 as=0.435 ps=3.58 w=1.5 l=0.5
X1357 VGND th_dif_sw_0.CK a_9132_7271# VGND sky130_fd_pr__nfet_01v8_lvt ad=0.1036 pd=1.02 as=0.1036 ps=1.02 w=0.74 l=0.15
X1358 VGND VDPWR VGND VGND sky130_fd_pr__nfet_01v8 ad=0.143 pd=1.62 as=0 ps=0 w=0.55 l=0.59
X1359 VDPWR VGND VDPWR VDPWR sky130_fd_pr__pfet_01v8_hvt ad=0.2262 pd=2.26 as=0 ps=0 w=0.87 l=0.59
X1360 a_5579_19676# a_5863_19662# a_5798_19810# VGND sky130_fd_pr__special_nfet_01v8 ad=0.0684 pd=0.74 as=0.066 ps=0.745 w=0.36 l=0.15
X1361 VDPWR single_9b_cdac_1.cdac_sw_9b_0.cdac_sw_3_3.tg_sw_3_3.SWN single_9b_cdac_1.cdac_sw_9b_0.cdac_sw_3_3.tg_sw_3_3.SWP VDPWR sky130_fd_pr__pfet_01v8 ad=0.196 pd=1.47 as=0.168 ps=1.42 w=1.12 l=0.15
X1362 th_dif_sw_0.VCP single_9b_cdac_1.cdac_sw_9b_0.S[2] sky130_fd_pr__cap_mim_m3_1 l=2 w=2
X1363 single_9b_cdac_0.cdac_sw_9b_0.cdac_sw_3_0.tg_sw_3_3.SWP single_9b_cdac_0.cdac_sw_9b_0.cdac_sw_3_0.tg_sw_3_3.SWN VDPWR VDPWR sky130_fd_pr__pfet_01v8 ad=0.168 pd=1.42 as=0.196 ps=1.47 w=1.12 l=0.15
X1364 a_39616_26990# single_9b_cdac_0.cdac_sw_9b_0.cdac_sw_3_5.nooverlap_clk_0.CLK0 single_9b_cdac_0.cdac_sw_9b_0.S[5] VGND sky130_fd_pr__nfet_01v8 ad=0.145 pd=1.58 as=0.145 ps=1.58 w=0.5 l=0.5
X1365 VGND single_9b_cdac_0.cdac_sw_9b_0.cdac_sw_3_0.nooverlap_clk_0.x6.A single_9b_cdac_0.cdac_sw_9b_0.cdac_sw_3_0.nooverlap_clk_0.x8.A VGND sky130_fd_pr__nfet_01v8_lvt ad=0.2627 pd=2.19 as=0.2109 ps=2.05 w=0.74 l=0.15
X1366 VGND single_9b_cdac_0.cdac_sw_9b_0.cdac_sw_3_1.tg_sw_3_3.SWN single_9b_cdac_0.cdac_sw_9b_0.cdac_sw_3_1.tg_sw_3_3.SWP VGND sky130_fd_pr__nfet_01v8_lvt ad=0.2109 pd=2.05 as=0.1036 ps=1.02 w=0.74 l=0.15
X1367 single_9b_cdac_1.cdac_sw_9b_0.cdac_sw_3_3.tg_sw_3_3.SWP single_9b_cdac_1.cdac_sw_9b_0.cdac_sw_3_3.tg_sw_3_3.SWN VDPWR VDPWR sky130_fd_pr__pfet_01v8 ad=0.168 pd=1.42 as=0.168 ps=1.42 w=1.12 l=0.15
X1368 th_dif_sw_0.VCP single_9b_cdac_1.cdac_sw_9b_0.S[2] sky130_fd_pr__cap_mim_m3_1 l=2 w=2
X1369 th_dif_sw_0.VCP single_9b_cdac_1.cdac_sw_9b_0.S[0] sky130_fd_pr__cap_mim_m3_1 l=2 w=2
X1370 single_9b_cdac_0.cdac_sw_9b_0.cdac_sw_3_4.tg_sw_3_3.SWP single_9b_cdac_0.cdac_sw_9b_0.cdac_sw_3_4.tg_sw_3_3.SWN VGND VGND sky130_fd_pr__nfet_01v8_lvt ad=0.1036 pd=1.02 as=0.2146 ps=2.06 w=0.74 l=0.15
X1371 VDPWR single_9b_cdac_0.cdac_sw_9b_0.cdac_sw_3_0.nooverlap_clk_0.CLKB0 single_9b_cdac_0.cdac_sw_9b_0.cdac_sw_3_0.nooverlap_clk_0.CLK0 VDPWR sky130_fd_pr__pfet_01v8 ad=0.196 pd=1.47 as=0.168 ps=1.42 w=1.12 l=0.15
X1372 VDPWR sar9b_0.net7 a_13899_21620# VDPWR sky130_fd_pr__pfet_01v8_hvt ad=0.11455 pd=1.08 as=0.2054 ps=2.1 w=0.79 l=0.15
X1373 th_dif_sw_0.th_sw_1.CKB a_21177_7457# VDPWR VDPWR sky130_fd_pr__pfet_01v8 ad=0.168 pd=1.42 as=0.196 ps=1.47 w=1.12 l=0.15
X1374 VGND single_9b_cdac_0.cdac_sw_9b_0.cdac_sw_3_8.tg_sw_3_3.SWN single_9b_cdac_0.cdac_sw_9b_0.cdac_sw_3_8.tg_sw_3_3.SWP VGND sky130_fd_pr__nfet_01v8_lvt ad=0.1295 pd=1.09 as=0.1036 ps=1.02 w=0.74 l=0.15
X1375 VGND sar9b_0.net15 a_13665_18900# VGND sky130_fd_pr__nfet_01v8 ad=0.1346 pd=1.15 as=0.0441 ps=0.63 w=0.42 l=0.15
X1376 th_dif_sw_0.VCN single_9b_cdac_0.cdac_sw_9b_0.S[1] sky130_fd_pr__cap_mim_m3_1 l=2 w=2
X1377 VDPWR a_8653_27034# a_8543_27060# VDPWR sky130_fd_pr__pfet_01v8_hvt ad=0.07035 pd=0.755 as=0.1155 ps=0.97 w=0.42 l=0.15
X1378 VDPWR single_9b_cdac_0.cdac_sw_9b_0.cdac_sw_3_2.nooverlap_clk_0.x6.A single_9b_cdac_0.cdac_sw_9b_0.cdac_sw_3_2.nooverlap_clk_0.x8.A VDPWR sky130_fd_pr__pfet_01v8 ad=0.3864 pd=2.93 as=0.3304 ps=2.83 w=1.12 l=0.15
X1379 VDPWR VGND VDPWR VDPWR sky130_fd_pr__pfet_01v8_hvt ad=0.2262 pd=2.26 as=0 ps=0 w=0.87 l=0.59
X1380 a_8526_23770# a_8358_23796# VGND VGND sky130_fd_pr__nfet_01v8 ad=0.0989 pd=0.995 as=0.12095 ps=1.085 w=0.64 l=0.15
X1381 a_12487_20836# sar9b_0.net15 VDPWR VDPWR sky130_fd_pr__pfet_01v8_hvt ad=0.0567 pd=0.69 as=0.0819 ps=0.81 w=0.42 l=0.15
X1382 VDPWR single_9b_cdac_1.cdac_sw_9b_0.cdac_sw_3_3.tg_sw_3_3.SWN single_9b_cdac_1.cdac_sw_9b_0.cdac_sw_3_3.tg_sw_3_3.SWP VDPWR sky130_fd_pr__pfet_01v8 ad=0.168 pd=1.42 as=0.168 ps=1.42 w=1.12 l=0.15
X1383 VGND a_21177_7457# th_dif_sw_0.th_sw_1.CKB VGND sky130_fd_pr__nfet_01v8_lvt ad=0.1036 pd=1.02 as=0.1036 ps=1.02 w=0.74 l=0.15
X1384 single_9b_cdac_0.cdac_sw_9b_0.cdac_sw_3_0.nooverlap_clk_0.CLK0 single_9b_cdac_0.cdac_sw_9b_0.cdac_sw_3_0.nooverlap_clk_0.CLKB0 VDPWR VDPWR sky130_fd_pr__pfet_01v8 ad=0.168 pd=1.42 as=0.168 ps=1.42 w=1.12 l=0.15
X1385 VGND sar9b_0._11_ sar9b_0._03_ VGND sky130_fd_pr__nfet_01v8 ad=0.17225 pd=1.83 as=0.091 ps=0.93 w=0.65 l=0.15
X1386 a_9774_19266# a_9687_19042# a_9370_19152# VDPWR sky130_fd_pr__pfet_01v8_hvt ad=0.12915 pd=1.185 as=0.0588 ps=0.7 w=0.42 l=0.15
X1387 single_9b_cdac_1.cdac_sw_9b_0.S[8] single_9b_cdac_1.cdac_sw_9b_0.cdac_sw_3_8.tg_sw_3_3.SWP single_9b_cdac_1.cdac_sw_9b_0.S[8] VDPWR sky130_fd_pr__pfet_01v8 ad=0.435 pd=3.58 as=0 ps=0 w=1.5 l=0.5
X1388 th_dif_sw_0.VCP single_9b_cdac_1.cdac_sw_9b_0.S[0] sky130_fd_pr__cap_mim_m3_1 l=2 w=2
X1389 VDPWR single_9b_cdac_0.cdac_sw_9b_0.cdac_sw_3_5.nooverlap_clk_0.CLKB0 single_9b_cdac_0.cdac_sw_9b_0.cdac_sw_3_5.nooverlap_clk_0.CLK0 VDPWR sky130_fd_pr__pfet_01v8 ad=0.3304 pd=2.83 as=0.168 ps=1.42 w=1.12 l=0.15
X1390 VGND single_9b_cdac_1.cdac_sw_9b_0.cdac_sw_3_5.nooverlap_clk_0.x10.A single_9b_cdac_1.cdac_sw_9b_0.cdac_sw_3_5.tg_sw_3_3.SWN VGND sky130_fd_pr__nfet_01v8_lvt ad=0.1036 pd=1.02 as=0.1036 ps=1.02 w=0.74 l=0.15
X1391 single_9b_cdac_1.cdac_sw_9b_0.cdac_sw_3_3.tg_sw_3_3.SWP single_9b_cdac_1.cdac_sw_9b_0.cdac_sw_3_3.tg_sw_3_3.SWN VDPWR VDPWR sky130_fd_pr__pfet_01v8 ad=0.168 pd=1.42 as=0.196 ps=1.47 w=1.12 l=0.15
X1392 a_16555_12124# tdc_0.OUTN VGND VGND sky130_fd_pr__nfet_01v8_lvt ad=0.0888 pd=0.98 as=0.2109 ps=2.05 w=0.74 l=0.15
X1393 VGND single_9b_cdac_0.cdac_sw_9b_0.cdac_sw_3_6.nooverlap_clk_0.sky130_fd_sc_hs__inv_8_0.A single_9b_cdac_0.cdac_sw_9b_0.cdac_sw_3_6.nooverlap_clk_0.CLKB0 VGND sky130_fd_pr__nfet_01v8_lvt ad=0.1036 pd=1.02 as=0.1036 ps=1.02 w=0.74 l=0.15
X1394 single_9b_cdac_0.cdac_sw_9b_0.cdac_sw_3_0.nooverlap_clk_0.CLKB0 single_9b_cdac_0.cdac_sw_9b_0.cdac_sw_3_0.nooverlap_clk_0.sky130_fd_sc_hs__inv_8_0.A VGND VGND sky130_fd_pr__nfet_01v8_lvt ad=0.1036 pd=1.02 as=0.1036 ps=1.02 w=0.74 l=0.15
X1395 VDPWR single_9b_cdac_0.cdac_sw_9b_0.cdac_sw_3_0.nooverlap_clk_0.CLKB0 single_9b_cdac_0.cdac_sw_9b_0.cdac_sw_3_0.nooverlap_clk_0.CLK0 VDPWR sky130_fd_pr__pfet_01v8 ad=0.168 pd=1.42 as=0.168 ps=1.42 w=1.12 l=0.15
X1396 a_9843_19137# a_9687_19042# a_9988_19266# VDPWR sky130_fd_pr__pfet_01v8_hvt ad=0.07245 pd=0.765 as=0.1155 ps=0.97 w=0.42 l=0.15
X1397 sar9b_0.net1 a_10311_17812# VDPWR VDPWR sky130_fd_pr__pfet_01v8_hvt ad=0.135 pd=1.27 as=0.1625 ps=1.325 w=1 l=0.15
X1398 VDPWR single_9b_cdac_1.cdac_sw_9b_0.cdac_sw_3_8.nooverlap_clk_0.x1.A single_9b_cdac_1.cdac_sw_9b_0.cdac_sw_3_8.nooverlap_clk_0.sky130_fd_sc_hs__inv_8_0.A VDPWR sky130_fd_pr__pfet_01v8 ad=0.3304 pd=2.83 as=0.168 ps=1.42 w=1.12 l=0.15
X1399 VDPWR single_9b_cdac_0.cdac_sw_9b_0.cdac_sw_3_8.nooverlap_clk_0.CLKB0 single_9b_cdac_0.cdac_sw_9b_0.cdac_sw_3_8.nooverlap_clk_0.CLK0 VDPWR sky130_fd_pr__pfet_01v8 ad=0.196 pd=1.47 as=0.168 ps=1.42 w=1.12 l=0.15
X1400 single_9b_cdac_0.cdac_sw_9b_0.cdac_sw_3_5.nooverlap_clk_0.CLK0 single_9b_cdac_0.cdac_sw_9b_0.cdac_sw_3_5.nooverlap_clk_0.CLKB0 VDPWR VDPWR sky130_fd_pr__pfet_01v8 ad=0.168 pd=1.42 as=0.196 ps=1.47 w=1.12 l=0.15
X1401 ua[0] single_9b_cdac_0.cdac_sw_9b_0.cdac_sw_3_4.tg_sw_3_3.SWP ua[0] VDPWR sky130_fd_pr__pfet_01v8 ad=0.435 pd=3.58 as=0 ps=0 w=1.5 l=0.5
X1402 a_6736_23086# a_6337_22714# a_6610_22708# VGND sky130_fd_pr__special_nfet_01v8 ad=0.0696 pd=0.765 as=0.0621 ps=0.705 w=0.36 l=0.15
X1403 sar9b_0.net30 a_14143_23012# VGND VGND sky130_fd_pr__nfet_01v8 ad=0.169 pd=1.82 as=0.2087 ps=2.02 w=0.65 l=0.15
X1404 VDPWR sar9b_0.net4 a_10311_19450# VDPWR sky130_fd_pr__pfet_01v8_hvt ad=0.0864 pd=0.91 as=0.1664 ps=1.8 w=0.64 l=0.15
X1405 VDPWR single_9b_cdac_0.cdac_sw_9b_0.cdac_sw_3_6.nooverlap_clk_0.x4.A single_9b_cdac_0.cdac_sw_9b_0.cdac_sw_3_6.nooverlap_clk_0.x6.A VDPWR sky130_fd_pr__pfet_01v8 ad=0.3864 pd=2.93 as=0.3304 ps=2.83 w=1.12 l=0.15
X1406 single_9b_cdac_1.cdac_sw_9b_0.cdac_sw_3_8.nooverlap_clk_0.sky130_fd_sc_hs__inv_8_0.A single_9b_cdac_1.cdac_sw_9b_0.cdac_sw_3_8.nooverlap_clk_0.x1.A VDPWR VDPWR sky130_fd_pr__pfet_01v8 ad=0.168 pd=1.42 as=0.168 ps=1.42 w=1.12 l=0.15
X1407 a_11376_24162# sar9b_0.net2 VDPWR VDPWR sky130_fd_pr__pfet_01v8_hvt ad=0.0651 pd=0.73 as=0.1092 ps=1.36 w=0.42 l=0.15
X1408 VDPWR VGND VDPWR VDPWR sky130_fd_pr__pfet_01v8_hvt ad=0.2262 pd=2.26 as=0 ps=0 w=0.87 l=0.59
X1409 th_dif_sw_0.VCP single_9b_cdac_1.cdac_sw_9b_0.S[1] sky130_fd_pr__cap_mim_m3_1 l=2 w=2
X1410 a_25210_26990# single_9b_cdac_0.cdac_sw_9b_0.cdac_sw_3_8.nooverlap_clk_0.CLK0 single_9b_cdac_0.cdac_sw_9b_0.S[8] VGND sky130_fd_pr__nfet_01v8 ad=0.145 pd=1.58 as=0.145 ps=1.58 w=0.5 l=0.5
X1411 a_11100_25428# sar9b_0.net13 VGND VGND sky130_fd_pr__nfet_01v8 ad=0.066 pd=0.745 as=0.2205 ps=1.89 w=0.42 l=0.15
X1412 a_11121_18900# a_10955_18900# VDPWR VDPWR sky130_fd_pr__pfet_01v8_hvt ad=0.1664 pd=1.8 as=0.0864 ps=0.91 w=0.64 l=0.15
X1413 th_dif_sw_0.VCN single_9b_cdac_0.cdac_sw_9b_0.S[0] sky130_fd_pr__cap_mim_m3_1 l=2 w=2
X1414 a_13308_26516# sar9b_0.net1 VDPWR VDPWR sky130_fd_pr__pfet_01v8_hvt ad=0.0651 pd=0.73 as=0.1092 ps=1.36 w=0.42 l=0.15
X1415 VGND VDPWR VGND VGND sky130_fd_pr__nfet_01v8 ad=0.143 pd=1.62 as=0 ps=0 w=0.55 l=0.59
X1416 a_11192_22164# sar9b_0.net9 VGND VGND sky130_fd_pr__nfet_01v8 ad=0.066 pd=0.745 as=0.2205 ps=1.89 w=0.42 l=0.15
X1417 th_dif_sw_0.VCP single_9b_cdac_1.cdac_sw_9b_0.S[0] sky130_fd_pr__cap_mim_m3_1 l=2 w=2
X1418 single_9b_cdac_0.cdac_sw_9b_0.cdac_sw_3_2.tg_sw_3_3.SWP single_9b_cdac_0.cdac_sw_9b_0.cdac_sw_3_2.tg_sw_3_3.SWN VGND VGND sky130_fd_pr__nfet_01v8_lvt ad=0.1036 pd=1.02 as=0.1036 ps=1.02 w=0.74 l=0.15
X1419 VDPWR VGND VDPWR VDPWR sky130_fd_pr__pfet_01v8_hvt ad=0.2262 pd=2.26 as=0 ps=0 w=0.87 l=0.59
X1420 VDPWR single_9b_cdac_1.cdac_sw_9b_0.cdac_sw_3_8.nooverlap_clk_0.x1.A single_9b_cdac_1.cdac_sw_9b_0.cdac_sw_3_8.nooverlap_clk_0.sky130_fd_sc_hs__inv_8_0.A VDPWR sky130_fd_pr__pfet_01v8 ad=0.168 pd=1.42 as=0.168 ps=1.42 w=1.12 l=0.15
X1421 single_9b_cdac_1.cdac_sw_9b_0.cdac_sw_3_2.nooverlap_clk_0.sky130_fd_sc_hs__inv_1_1.A single_9b_cdac_1.cdac_sw_9b_0.cdac_sw_3_2.nooverlap_clk_0.sky130_fd_sc_hs__nand2_1_0.Y VGND VGND sky130_fd_pr__nfet_01v8_lvt ad=0.2109 pd=2.05 as=0.2627 ps=2.19 w=0.74 l=0.15
X1422 VDPWR a_6007_27302# a_5968_27176# VDPWR sky130_fd_pr__pfet_01v8_hvt ad=0.0864 pd=0.91 as=0.1664 ps=1.8 w=0.64 l=0.15
X1423 VDPWR VGND VDPWR VDPWR sky130_fd_pr__pfet_01v8_hvt ad=0.2262 pd=2.26 as=0 ps=0 w=0.87 l=0.59
X1424 VGND single_9b_cdac_0.cdac_sw_9b_0.cdac_sw_3_7.nooverlap_clk_0.x8.A single_9b_cdac_0.cdac_sw_9b_0.cdac_sw_3_7.nooverlap_clk_0.x10.A VGND sky130_fd_pr__nfet_01v8_lvt ad=0.1221 pd=1.07 as=0.1036 ps=1.02 w=0.74 l=0.15
X1425 a_9843_19137# a_9648_19168# a_10153_18900# VGND sky130_fd_pr__special_nfet_01v8 ad=0.0594 pd=0.69 as=0.1401 ps=1.1 w=0.36 l=0.15
X1426 th_dif_sw_0.VCP single_9b_cdac_1.cdac_sw_9b_0.S[1] sky130_fd_pr__cap_mim_m3_1 l=2 w=2
X1427 VDPWR th_dif_sw_0.th_sw_1.CKB a_18214_3039# VDPWR sky130_fd_pr__pfet_01v8 ad=0.2175 pd=2.08 as=0.2175 ps=2.08 w=0.75 l=0.15
X1428 VGND sar9b_0.net15 a_9405_18900# VGND sky130_fd_pr__nfet_01v8 ad=0.12495 pd=1.015 as=0.06405 ps=0.725 w=0.42 l=0.15
X1429 th_dif_sw_0.VCP single_9b_cdac_1.cdac_sw_9b_0.S[1] sky130_fd_pr__cap_mim_m3_1 l=2 w=2
X1430 a_14077_19822# a_12887_19450# a_13968_19822# VGND sky130_fd_pr__special_nfet_01v8 ad=0.0669 pd=0.75 as=0.0711 ps=0.755 w=0.36 l=0.15
X1431 VDPWR sar9b_0.net15 a_9988_19266# VDPWR sky130_fd_pr__pfet_01v8_hvt ad=0.07035 pd=0.755 as=0.1092 ps=1.36 w=0.42 l=0.15
X1432 single_9b_cdac_1.cdac_sw_9b_0.cdac_sw_3_8.nooverlap_clk_0.sky130_fd_sc_hs__inv_8_0.A single_9b_cdac_1.cdac_sw_9b_0.cdac_sw_3_8.nooverlap_clk_0.x1.A VDPWR VDPWR sky130_fd_pr__pfet_01v8 ad=0.168 pd=1.42 as=0.3304 ps=2.83 w=1.12 l=0.15
X1433 a_8783_23796# a_7919_23802# a_8526_23770# VDPWR sky130_fd_pr__pfet_01v8_hvt ad=0.0567 pd=0.69 as=0.1095 ps=1.075 w=0.42 l=0.15
X1434 th_dif_sw_0.VCP single_9b_cdac_1.cdac_sw_9b_0.S[0] sky130_fd_pr__cap_mim_m3_1 l=2 w=2
X1435 th_dif_sw_0.VCN single_9b_cdac_0.cdac_sw_9b_0.S[0] sky130_fd_pr__cap_mim_m3_1 l=2 w=2
X1436 VGND single_9b_cdac_1.CF[3] single_9b_cdac_0.cdac_sw_9b_0.cdac_sw_3_4.nooverlap_clk_0.x3.Y VGND sky130_fd_pr__nfet_01v8_lvt ad=0.2627 pd=2.19 as=0.2109 ps=2.05 w=0.74 l=0.15
X1437 VGND a_21177_7457# th_dif_sw_0.th_sw_1.CKB VGND sky130_fd_pr__nfet_01v8_lvt ad=0.1036 pd=1.02 as=0.1036 ps=1.02 w=0.74 l=0.15
X1438 a_8453_23796# a_7919_23802# a_8358_23796# VDPWR sky130_fd_pr__pfet_01v8_hvt ad=0.07665 pd=0.785 as=0.06825 ps=0.745 w=0.42 l=0.15
X1439 th_dif_sw_0.VCN th_dif_sw_0.th_sw_1.CK th_dif_sw_0.VCN VGND sky130_fd_pr__nfet_01v8 ad=5.8 pd=40.58 as=17.4 ps=121.74 w=20 l=0.15
X1440 single_9b_cdac_0.cdac_sw_9b_0.cdac_sw_3_6.tg_sw_3_3.SWP single_9b_cdac_0.cdac_sw_9b_0.cdac_sw_3_6.tg_sw_3_3.SWN VDPWR VDPWR sky130_fd_pr__pfet_01v8 ad=0.168 pd=1.42 as=0.3864 ps=2.93 w=1.12 l=0.15
X1441 VGND single_9b_cdac_1.cdac_sw_9b_0.cdac_sw_3_5.nooverlap_clk_0.CLKB0 single_9b_cdac_1.cdac_sw_9b_0.cdac_sw_3_5.nooverlap_clk_0.CLK0 VGND sky130_fd_pr__nfet_01v8_lvt ad=0.2146 pd=2.06 as=0.1036 ps=1.02 w=0.74 l=0.15
X1442 VGND single_9b_cdac_0.SW[4] a_44418_26990# VGND sky130_fd_pr__nfet_01v8 ad=0.145 pd=1.58 as=0.145 ps=1.58 w=0.5 l=0.5
X1443 a_11746_25250# sar9b_0.net15 VGND VGND sky130_fd_pr__nfet_01v8 ad=0.06405 pd=0.725 as=0.12495 ps=1.015 w=0.42 l=0.15
X1444 a_14130_24884# a_13053_24890# a_13968_25262# VDPWR sky130_fd_pr__pfet_01v8_hvt ad=0.0567 pd=0.69 as=0.0588 ps=0.7 w=0.42 l=0.15
X1445 a_39616_17740# single_9b_cdac_1.cdac_sw_9b_0.cdac_sw_3_5.nooverlap_clk_0.CLK0 single_9b_cdac_1.cdac_sw_9b_0.S[5] VGND sky130_fd_pr__nfet_01v8 ad=0.145 pd=1.58 as=0.145 ps=1.58 w=0.5 l=0.5
X1446 VGND single_9b_cdac_1.SW[5] a_39616_17740# VGND sky130_fd_pr__nfet_01v8 ad=0.145 pd=1.58 as=0.145 ps=1.58 w=0.5 l=0.5
X1447 VDPWR VGND VDPWR VDPWR sky130_fd_pr__pfet_01v8_hvt ad=0.2262 pd=2.26 as=0 ps=0 w=0.87 l=0.59
X1448 th_dif_sw_0.VCP single_9b_cdac_1.cdac_sw_9b_0.S[1] sky130_fd_pr__cap_mim_m3_1 l=2 w=2
X1449 th_dif_sw_0.VCN single_9b_cdac_0.cdac_sw_9b_0.S[0] sky130_fd_pr__cap_mim_m3_1 l=2 w=2
X1450 VGND sar9b_0.net3 a_6213_26516# VGND sky130_fd_pr__nfet_01v8 ad=0.1346 pd=1.15 as=0.0441 ps=0.63 w=0.42 l=0.15
X1451 single_9b_cdac_0.cdac_sw_9b_0.cdac_sw_3_3.nooverlap_clk_0.CLKB0 single_9b_cdac_0.cdac_sw_9b_0.cdac_sw_3_3.nooverlap_clk_0.sky130_fd_sc_hs__inv_8_0.A VGND VGND sky130_fd_pr__nfet_01v8_lvt ad=0.1036 pd=1.02 as=0.1036 ps=1.02 w=0.74 l=0.15
X1452 a_9036_20910# a_8637_20538# a_8910_20532# VGND sky130_fd_pr__special_nfet_01v8 ad=0.0696 pd=0.765 as=0.0621 ps=0.705 w=0.36 l=0.15
X1453 VGND a_10055_20130# a_10016_20256# VGND sky130_fd_pr__nfet_01v8 ad=0.0567 pd=0.69 as=0.1092 ps=1.36 w=0.42 l=0.15
X1454 a_21368_4076# th_dif_sw_0.th_sw_1.CKB a_18214_3039# VGND sky130_fd_pr__nfet_01v8 ad=0.145 pd=1.58 as=0.145 ps=1.58 w=0.5 l=0.15
X1455 single_9b_cdac_1.SW[6] a_14175_20532# VDPWR VDPWR sky130_fd_pr__pfet_01v8_hvt ad=0.2054 pd=2.1 as=0.11455 ps=1.08 w=0.79 l=0.15
X1456 ua[0] single_9b_cdac_0.cdac_sw_9b_0.cdac_sw_3_4.tg_sw_3_3.SWP ua[0] VDPWR sky130_fd_pr__pfet_01v8 ad=0.435 pd=3.58 as=0 ps=0 w=1.5 l=0.5
X1457 single_9b_cdac_0.cdac_sw_9b_0.cdac_sw_3_2.nooverlap_clk_0.sky130_fd_sc_hs__inv_8_0.A single_9b_cdac_0.cdac_sw_9b_0.cdac_sw_3_2.nooverlap_clk_0.x1.A VGND VGND sky130_fd_pr__nfet_01v8_lvt ad=0.1036 pd=1.02 as=0.2109 ps=2.05 w=0.74 l=0.15
X1458 a_13419_23796# sar9b_0.net15 VDPWR VDPWR sky130_fd_pr__pfet_01v8_hvt ad=0.1092 pd=1.36 as=0.07035 ps=0.755 w=0.42 l=0.15
X1459 a_5711_21076# sar9b_0._10_ VGND VGND sky130_fd_pr__nfet_01v8 ad=0.10075 pd=0.96 as=0.08775 ps=0.92 w=0.65 l=0.15
X1460 a_11855_20532# sar9b_0.net15 VDPWR VDPWR sky130_fd_pr__pfet_01v8_hvt ad=0.1092 pd=1.36 as=0.07035 ps=0.755 w=0.42 l=0.15
X1461 th_dif_sw_0.VCP single_9b_cdac_1.cdac_sw_9b_0.S[0] sky130_fd_pr__cap_mim_m3_1 l=2 w=2
X1462 single_9b_cdac_0.cdac_sw_9b_0.cdac_sw_3_7.nooverlap_clk_0.sky130_fd_sc_hs__nand2_1_0.Y single_9b_cdac_1.CF[7] a_31753_29911# VGND sky130_fd_pr__nfet_01v8_lvt ad=0.2109 pd=2.05 as=0.0888 ps=0.98 w=0.74 l=0.15
X1463 VGND a_7735_17812# sar9b_0.net4 VGND sky130_fd_pr__nfet_01v8 ad=0.1092 pd=1.36 as=0.0567 ps=0.69 w=0.42 l=0.15
X1464 th_dif_sw_0.VCP single_9b_cdac_1.cdac_sw_9b_0.S[1] sky130_fd_pr__cap_mim_m3_1 l=2 w=2
X1465 th_dif_sw_0.th_sw_1.CK a_9132_7271# VDPWR VDPWR sky130_fd_pr__pfet_01v8 ad=0.168 pd=1.42 as=0.168 ps=1.42 w=1.12 l=0.15
X1466 single_9b_cdac_0.cdac_sw_9b_0.cdac_sw_3_7.nooverlap_clk_0.CLK0 single_9b_cdac_0.cdac_sw_9b_0.cdac_sw_3_7.nooverlap_clk_0.CLKB0 VGND VGND sky130_fd_pr__nfet_01v8_lvt ad=0.1036 pd=1.02 as=0.1036 ps=1.02 w=0.74 l=0.15
X1467 VGND single_9b_cdac_0.cdac_sw_9b_0.cdac_sw_3_5.nooverlap_clk_0.sky130_fd_sc_hs__nand2_1_0.Y single_9b_cdac_0.cdac_sw_9b_0.cdac_sw_3_5.nooverlap_clk_0.sky130_fd_sc_hs__inv_1_1.A VGND sky130_fd_pr__nfet_01v8_lvt ad=0.2627 pd=2.19 as=0.2109 ps=2.05 w=0.74 l=0.15
X1468 VDPWR single_9b_cdac_1.cdac_sw_9b_0.cdac_sw_3_0.nooverlap_clk_0.x10.A single_9b_cdac_1.cdac_sw_9b_0.cdac_sw_3_0.tg_sw_3_3.SWN VDPWR sky130_fd_pr__pfet_01v8 ad=0.196 pd=1.47 as=0.168 ps=1.42 w=1.12 l=0.15
X1469 a_11045_19418# a_10827_19822# VGND VGND sky130_fd_pr__nfet_01v8 ad=0.0999 pd=0.985 as=0.1346 ps=1.15 w=0.64 l=0.15
X1470 VGND single_9b_cdac_0.cdac_sw_9b_0.cdac_sw_3_1.tg_sw_3_3.SWN single_9b_cdac_0.cdac_sw_9b_0.cdac_sw_3_1.tg_sw_3_3.SWP VGND sky130_fd_pr__nfet_01v8_lvt ad=0.1036 pd=1.02 as=0.1036 ps=1.02 w=0.74 l=0.15
X1471 VGND a_12427_17812# sar9b_0.net2 VGND sky130_fd_pr__nfet_01v8 ad=0.1092 pd=1.36 as=0.0567 ps=0.69 w=0.42 l=0.15
X1472 single_9b_cdac_1.cdac_sw_9b_0.cdac_sw_3_8.nooverlap_clk_0.CLK0 single_9b_cdac_1.cdac_sw_9b_0.cdac_sw_3_8.nooverlap_clk_0.CLKB0 VGND VGND sky130_fd_pr__nfet_01v8_lvt ad=0.1036 pd=1.02 as=0.1295 ps=1.09 w=0.74 l=0.15
X1473 th_dif_sw_0.VCP single_9b_cdac_1.cdac_sw_9b_0.S[0] sky130_fd_pr__cap_mim_m3_1 l=2 w=2
X1474 th_dif_sw_0.VCP single_9b_cdac_1.cdac_sw_9b_0.S[2] sky130_fd_pr__cap_mim_m3_1 l=2 w=2
X1475 single_9b_cdac_1.cdac_sw_9b_0.cdac_sw_3_0.tg_sw_3_3.SWN single_9b_cdac_1.cdac_sw_9b_0.cdac_sw_3_0.nooverlap_clk_0.x10.A VDPWR VDPWR sky130_fd_pr__pfet_01v8 ad=0.168 pd=1.42 as=0.168 ps=1.42 w=1.12 l=0.15
X1476 VGND sar9b_0.net13 a_14451_23252# VGND sky130_fd_pr__nfet_01v8 ad=0.0754 pd=0.81 as=0.1352 ps=1.56 w=0.52 l=0.15
X1477 single_9b_cdac_1.cdac_sw_9b_0.cdac_sw_3_5.nooverlap_clk_0.x1.A single_9b_cdac_1.cdac_sw_9b_0.cdac_sw_3_5.nooverlap_clk_0.sky130_fd_sc_hs__inv_1_1.A VGND VGND sky130_fd_pr__nfet_01v8_lvt ad=0.2109 pd=2.05 as=0.2627 ps=2.19 w=0.74 l=0.15
X1478 th_dif_sw_0.VCP single_9b_cdac_1.cdac_sw_9b_0.S[1] sky130_fd_pr__cap_mim_m3_1 l=2 w=2
X1479 th_dif_sw_0.VCP single_9b_cdac_1.cdac_sw_9b_0.S[5] sky130_fd_pr__cap_mim_m3_1 l=2 w=2
X1480 a_9132_7271# th_dif_sw_0.CK VGND VGND sky130_fd_pr__nfet_01v8_lvt ad=0.1036 pd=1.02 as=0.11655 ps=1.055 w=0.74 l=0.15
X1481 VGND VDPWR VGND VGND sky130_fd_pr__nfet_01v8 ad=0.143 pd=1.62 as=0 ps=0 w=0.55 l=0.59
X1482 VGND single_9b_cdac_0.cdac_sw_9b_0.cdac_sw_3_5.tg_sw_3_3.SWN single_9b_cdac_0.cdac_sw_9b_0.cdac_sw_3_5.tg_sw_3_3.SWP VGND sky130_fd_pr__nfet_01v8_lvt ad=0.1295 pd=1.09 as=0.1036 ps=1.02 w=0.74 l=0.15
X1483 VDPWR single_9b_cdac_0.cdac_sw_9b_0.cdac_sw_3_0.nooverlap_clk_0.sky130_fd_sc_hs__nand2_1_0.Y single_9b_cdac_0.cdac_sw_9b_0.cdac_sw_3_0.nooverlap_clk_0.sky130_fd_sc_hs__inv_1_1.A VDPWR sky130_fd_pr__pfet_01v8 ad=0.3864 pd=2.93 as=0.3304 ps=2.83 w=1.12 l=0.15
X1484 single_9b_cdac_0.cdac_sw_9b_0.S[8] single_9b_cdac_0.cdac_sw_9b_0.cdac_sw_3_8.tg_sw_3_3.SWP ua[0] VGND sky130_fd_pr__nfet_01v8 ad=0.145 pd=1.58 as=0.145 ps=1.58 w=0.5 l=0.5
X1485 VGND VDPWR VGND VGND sky130_fd_pr__nfet_01v8 ad=0.143 pd=1.62 as=0 ps=0 w=0.55 l=0.59
X1486 a_12671_18734# a_12225_18362# a_12575_18734# VGND sky130_fd_pr__special_nfet_01v8 ad=0.1401 pd=1.1 as=0.0594 ps=0.69 w=0.36 l=0.15
X1487 single_9b_cdac_1.cdac_sw_9b_0.cdac_sw_3_3.nooverlap_clk_0.x8.A single_9b_cdac_1.cdac_sw_9b_0.cdac_sw_3_3.nooverlap_clk_0.x6.A VDPWR VDPWR sky130_fd_pr__pfet_01v8 ad=0.3304 pd=2.83 as=0.3864 ps=2.93 w=1.12 l=0.15
X1488 VDPWR single_9b_cdac_1.cdac_sw_9b_0.cdac_sw_3_0.nooverlap_clk_0.x10.A single_9b_cdac_1.cdac_sw_9b_0.cdac_sw_3_0.tg_sw_3_3.SWN VDPWR sky130_fd_pr__pfet_01v8 ad=0.168 pd=1.42 as=0.168 ps=1.42 w=1.12 l=0.15
X1489 th_dif_sw_0.VCP single_9b_cdac_1.cdac_sw_9b_0.S[3] sky130_fd_pr__cap_mim_m3_1 l=2 w=2
X1490 single_9b_cdac_0.cdac_sw_9b_0.cdac_sw_3_0.nooverlap_clk_0.CLKB0 single_9b_cdac_0.cdac_sw_9b_0.cdac_sw_3_0.nooverlap_clk_0.sky130_fd_sc_hs__inv_8_0.A VGND VGND sky130_fd_pr__nfet_01v8_lvt ad=0.1036 pd=1.02 as=0.1295 ps=1.09 w=0.74 l=0.15
X1491 VDPWR VGND VDPWR VDPWR sky130_fd_pr__pfet_01v8_hvt ad=0.2262 pd=2.26 as=0 ps=0 w=0.87 l=0.59
X1492 single_9b_cdac_1.cdac_sw_9b_0.cdac_sw_3_0.tg_sw_3_3.SWN single_9b_cdac_1.cdac_sw_9b_0.cdac_sw_3_0.nooverlap_clk_0.x10.A VDPWR VDPWR sky130_fd_pr__pfet_01v8 ad=0.168 pd=1.42 as=0.196 ps=1.47 w=1.12 l=0.15
X1493 VDPWR th_dif_sw_0.CKB a_21177_7457# VDPWR sky130_fd_pr__pfet_01v8 ad=0.168 pd=1.42 as=0.168 ps=1.42 w=1.12 l=0.15
X1494 a_5863_19662# sar9b_0.clknet_1_0__leaf_CLK VGND VGND sky130_fd_pr__nfet_01v8 ad=0.1092 pd=1.36 as=0.0567 ps=0.69 w=0.42 l=0.15
X1495 VGND single_9b_cdac_1.cdac_sw_9b_0.cdac_sw_3_7.tg_sw_3_3.SWN single_9b_cdac_1.cdac_sw_9b_0.cdac_sw_3_7.tg_sw_3_3.SWP VGND sky130_fd_pr__nfet_01v8_lvt ad=0.1295 pd=1.09 as=0.1036 ps=1.02 w=0.74 l=0.15
X1496 a_9631_26516# a_9115_26516# a_9536_26516# VGND sky130_fd_pr__special_nfet_01v8 ad=0.0594 pd=0.69 as=0.066 ps=0.745 w=0.36 l=0.15
X1497 single_9b_cdac_0.cdac_sw_9b_0.S[3] single_9b_cdac_0.cdac_sw_9b_0.cdac_sw_3_4.tg_sw_3_3.SWP ua[0] VGND sky130_fd_pr__nfet_01v8 ad=0.145 pd=1.58 as=0.145 ps=1.58 w=0.5 l=0.5
X1498 VGND single_9b_cdac_0.cdac_sw_9b_0.cdac_sw_3_4.nooverlap_clk_0.CLKB0 single_9b_cdac_0.cdac_sw_9b_0.cdac_sw_3_4.nooverlap_clk_0.CLK0 VGND sky130_fd_pr__nfet_01v8_lvt ad=0.1554 pd=1.16 as=0.1036 ps=1.02 w=0.74 l=0.15
X1499 VDPWR a_8526_23770# a_8453_23796# VDPWR sky130_fd_pr__pfet_01v8_hvt ad=0.17887 pd=1.26 as=0.07665 ps=0.785 w=0.42 l=0.15
X1500 VGND sar9b_0.net7 a_13899_21620# VGND sky130_fd_pr__nfet_01v8 ad=0.0754 pd=0.81 as=0.1352 ps=1.56 w=0.52 l=0.15
X1501 th_dif_sw_0.VCN single_9b_cdac_0.cdac_sw_9b_0.S[0] sky130_fd_pr__cap_mim_m3_1 l=2 w=2
X1502 VDPWR single_9b_cdac_0.cdac_sw_9b_0.cdac_sw_3_2.nooverlap_clk_0.x3.Y single_9b_cdac_0.cdac_sw_9b_0.cdac_sw_3_2.nooverlap_clk_0.x4.A VDPWR sky130_fd_pr__pfet_01v8 ad=0.3192 pd=2.81 as=0.168 ps=1.42 w=1.12 l=0.15
X1503 a_6219_22316# sar9b_0._09_ a_6453_22164# VGND sky130_fd_pr__nfet_01v8 ad=0.1092 pd=1.36 as=0.0441 ps=0.63 w=0.42 l=0.15
X1504 a_9281_21076# a_9115_21076# VGND VGND sky130_fd_pr__nfet_01v8 ad=0.1092 pd=1.36 as=0.0567 ps=0.69 w=0.42 l=0.15
X1505 sar9b_0.clknet_1_0__leaf_CLK a_6701_20506# VDPWR VDPWR sky130_fd_pr__pfet_01v8_hvt ad=0.14 pd=1.28 as=0.14 ps=1.28 w=1 l=0.15
X1506 a_12390_18900# sar9b_0.net15 VGND VGND sky130_fd_pr__nfet_01v8 ad=0.06405 pd=0.725 as=0.12495 ps=1.015 w=0.42 l=0.15
X1507 single_9b_cdac_1.cdac_sw_9b_0.cdac_sw_3_6.nooverlap_clk_0.CLK0 single_9b_cdac_1.cdac_sw_9b_0.cdac_sw_3_6.nooverlap_clk_0.CLKB0 VGND VGND sky130_fd_pr__nfet_01v8_lvt ad=0.1036 pd=1.02 as=0.2109 ps=2.05 w=0.74 l=0.15
X1508 VGND single_9b_cdac_1.cdac_sw_9b_0.cdac_sw_3_0.nooverlap_clk_0.CLKB0 single_9b_cdac_1.cdac_sw_9b_0.cdac_sw_3_0.nooverlap_clk_0.CLK0 VGND sky130_fd_pr__nfet_01v8_lvt ad=0.1036 pd=1.02 as=0.1036 ps=1.02 w=0.74 l=0.15
X1509 ua[0] single_9b_cdac_0.cdac_sw_9b_0.cdac_sw_3_8.tg_sw_3_3.SWN ua[0] VGND sky130_fd_pr__nfet_01v8 ad=0.145 pd=1.58 as=0 ps=0 w=0.5 l=0.5
X1510 a_8669_23074# a_8634_22840# a_8431_22682# VGND sky130_fd_pr__nfet_01v8 ad=0.06405 pd=0.725 as=0.1092 ps=1.36 w=0.42 l=0.15
X1511 th_dif_sw_0.VCN single_9b_cdac_0.cdac_sw_9b_0.S[1] sky130_fd_pr__cap_mim_m3_1 l=2 w=2
X1512 th_dif_sw_0.VCN single_9b_cdac_0.cdac_sw_9b_0.S[0] sky130_fd_pr__cap_mim_m3_1 l=2 w=2
X1513 a_55773_15501# single_9b_cdac_1.CF[2] single_9b_cdac_1.cdac_sw_9b_0.cdac_sw_3_0.nooverlap_clk_0.sky130_fd_sc_hs__nand2_1_0.Y VGND sky130_fd_pr__nfet_01v8_lvt ad=0.0888 pd=0.98 as=0.2109 ps=2.05 w=0.74 l=0.15
X1514 VGND single_9b_cdac_0.cdac_sw_9b_0.cdac_sw_3_4.nooverlap_clk_0.x3.Y a_49926_29917# VGND sky130_fd_pr__nfet_01v8_lvt ad=0.2109 pd=2.05 as=0.0888 ps=0.98 w=0.74 l=0.15
X1515 th_dif_sw_0.VCN single_9b_cdac_0.cdac_sw_9b_0.S[1] sky130_fd_pr__cap_mim_m3_1 l=2 w=2
X1516 VDPWR clk a_15151_10456# VDPWR sky130_fd_pr__pfet_01v8 ad=0.1988 pd=1.505 as=0.147 ps=1.19 w=0.84 l=0.15
X1517 single_9b_cdac_0.cdac_sw_9b_0.cdac_sw_3_2.nooverlap_clk_0.x4.A single_9b_cdac_0.cdac_sw_9b_0.cdac_sw_3_2.nooverlap_clk_0.x1.A VDPWR VDPWR sky130_fd_pr__pfet_01v8 ad=0.168 pd=1.42 as=0.3192 ps=2.81 w=1.12 l=0.15
X1518 sar9b_0.clk_div_0.COUNT\[3\] a_9503_20506# VDPWR VDPWR sky130_fd_pr__pfet_01v8_hvt ad=0.26 pd=2.52 as=0.135 ps=1.27 w=1 l=0.15
X1519 single_9b_cdac_0.cdac_sw_9b_0.cdac_sw_3_0.nooverlap_clk_0.CLK0 single_9b_cdac_0.cdac_sw_9b_0.cdac_sw_3_0.nooverlap_clk_0.CLKB0 VDPWR VDPWR sky130_fd_pr__pfet_01v8 ad=0.168 pd=1.42 as=0.3864 ps=2.93 w=1.12 l=0.15
X1520 a_7238_25428# sar9b_0.net3 VGND VGND sky130_fd_pr__nfet_01v8 ad=0.06405 pd=0.725 as=0.12495 ps=1.015 w=0.42 l=0.15
X1521 a_13511_22530# sar9b_0.net15 VDPWR VDPWR sky130_fd_pr__pfet_01v8_hvt ad=0.1092 pd=1.36 as=0.07035 ps=0.755 w=0.42 l=0.15
X1522 a_14143_21050# sar9b_0.net15 VDPWR VDPWR sky130_fd_pr__pfet_01v8_hvt ad=0.0567 pd=0.69 as=0.0819 ps=0.81 w=0.42 l=0.15
X1523 sar9b_0.clk_div_0.COUNT\[3\] a_9503_20506# VGND VGND sky130_fd_pr__nfet_01v8 ad=0.169 pd=1.82 as=0.08775 ps=0.92 w=0.65 l=0.15
X1524 VGND single_9b_cdac_1.cdac_sw_9b_0.cdac_sw_3_4.nooverlap_clk_0.x1.A single_9b_cdac_1.cdac_sw_9b_0.cdac_sw_3_4.nooverlap_clk_0.sky130_fd_sc_hs__inv_8_0.A VGND sky130_fd_pr__nfet_01v8_lvt ad=0.1221 pd=1.07 as=0.1184 ps=1.06 w=0.74 l=0.15
X1525 VGND single_9b_cdac_0.cdac_sw_9b_0.cdac_sw_3_5.nooverlap_clk_0.CLKB0 single_9b_cdac_0.cdac_sw_9b_0.cdac_sw_3_5.nooverlap_clk_0.CLK0 VGND sky130_fd_pr__nfet_01v8_lvt ad=0.2109 pd=2.05 as=0.1036 ps=1.02 w=0.74 l=0.15
X1526 single_9b_cdac_1.cdac_sw_9b_0.cdac_sw_3_6.nooverlap_clk_0.x10.A single_9b_cdac_1.cdac_sw_9b_0.cdac_sw_3_6.nooverlap_clk_0.x8.A VGND VGND sky130_fd_pr__nfet_01v8_lvt ad=0.1036 pd=1.02 as=0.1221 ps=1.07 w=0.74 l=0.15
X1527 VGND single_9b_cdac_1.cdac_sw_9b_0.cdac_sw_3_0.nooverlap_clk_0.x8.A single_9b_cdac_1.cdac_sw_9b_0.cdac_sw_3_0.nooverlap_clk_0.x10.A VGND sky130_fd_pr__nfet_01v8_lvt ad=0.2109 pd=2.05 as=0.1036 ps=1.02 w=0.74 l=0.15
X1528 th_dif_sw_0.VCN single_9b_cdac_0.cdac_sw_9b_0.S[1] sky130_fd_pr__cap_mim_m3_1 l=2 w=2
X1529 VDPWR a_9107_22682# a_9038_22708# VDPWR sky130_fd_pr__pfet_01v8_hvt ad=0.2184 pd=2.2 as=0.12915 ps=1.185 w=0.84 l=0.15
X1530 VDPWR single_9b_cdac_1.cdac_sw_9b_0.cdac_sw_3_8.nooverlap_clk_0.sky130_fd_sc_hs__inv_8_0.A single_9b_cdac_1.cdac_sw_9b_0.cdac_sw_3_8.nooverlap_clk_0.CLKB0 VDPWR sky130_fd_pr__pfet_01v8 ad=0.196 pd=1.47 as=0.168 ps=1.42 w=1.12 l=0.15
X1531 th_dif_sw_0.VCP single_9b_cdac_1.cdac_sw_9b_0.S[1] sky130_fd_pr__cap_mim_m3_1 l=2 w=2
X1532 single_9b_cdac_1.cdac_sw_9b_0.S[0] single_9b_cdac_1.cdac_sw_9b_0.cdac_sw_3_2.tg_sw_3_3.SWN ua[0] VDPWR sky130_fd_pr__pfet_01v8 ad=0.435 pd=3.58 as=0.435 ps=3.58 w=1.5 l=0.5
X1533 VDPWR single_9b_cdac_0.cdac_sw_9b_0.cdac_sw_3_6.nooverlap_clk_0.x6.A single_9b_cdac_0.cdac_sw_9b_0.cdac_sw_3_6.nooverlap_clk_0.x8.A VDPWR sky130_fd_pr__pfet_01v8 ad=0.3864 pd=2.93 as=0.3304 ps=2.83 w=1.12 l=0.15
X1534 VDPWR VGND VDPWR VDPWR sky130_fd_pr__pfet_01v8_hvt ad=0.2262 pd=2.26 as=0 ps=0 w=0.87 l=0.59
X1535 a_54032_17740# single_9b_cdac_1.cdac_sw_9b_0.cdac_sw_3_0.nooverlap_clk_0.CLK0 single_9b_cdac_1.cdac_sw_9b_0.S[2] VGND sky130_fd_pr__nfet_01v8 ad=0.145 pd=1.58 as=0.145 ps=1.58 w=0.5 l=0.5
X1536 th_dif_sw_0.VCP single_9b_cdac_1.cdac_sw_9b_0.S[2] sky130_fd_pr__cap_mim_m3_1 l=2 w=2
X1537 sar9b_0.net8 a_12487_20836# VDPWR VDPWR sky130_fd_pr__pfet_01v8_hvt ad=0.26 pd=2.52 as=0.3012 ps=2.66 w=1 l=0.15
X1538 th_dif_sw_0.VCP single_9b_cdac_1.cdac_sw_9b_0.S[0] sky130_fd_pr__cap_mim_m3_1 l=2 w=2
X1539 single_9b_cdac_0.cdac_sw_9b_0.cdac_sw_3_6.tg_sw_3_3.SWP single_9b_cdac_0.cdac_sw_9b_0.cdac_sw_3_6.tg_sw_3_3.SWN VGND VGND sky130_fd_pr__nfet_01v8_lvt ad=0.1036 pd=1.02 as=0.1554 ps=1.16 w=0.74 l=0.15
X1540 sar9b_0._12_ sar9b_0.clk_div_0.COUNT\[2\] VDPWR VDPWR sky130_fd_pr__pfet_01v8_hvt ad=0.135 pd=1.27 as=0.26 ps=2.52 w=1 l=0.15
X1541 VDPWR sar9b_0.net4 a_10679_25428# VDPWR sky130_fd_pr__pfet_01v8_hvt ad=0.0864 pd=0.91 as=0.1664 ps=1.8 w=0.64 l=0.15
X1542 a_5785_23252# a_5619_23252# VGND VGND sky130_fd_pr__nfet_01v8 ad=0.1092 pd=1.36 as=0.0567 ps=0.69 w=0.42 l=0.15
X1543 single_9b_cdac_1.cdac_sw_9b_0.cdac_sw_3_6.tg_sw_3_3.SWN single_9b_cdac_1.cdac_sw_9b_0.cdac_sw_3_6.nooverlap_clk_0.x10.A VGND VGND sky130_fd_pr__nfet_01v8_lvt ad=0.1036 pd=1.02 as=0.1295 ps=1.09 w=0.74 l=0.15
X1544 VGND single_9b_cdac_1.cdac_sw_9b_0.cdac_sw_3_0.nooverlap_clk_0.x10.A single_9b_cdac_1.cdac_sw_9b_0.cdac_sw_3_0.tg_sw_3_3.SWN VGND sky130_fd_pr__nfet_01v8_lvt ad=0.1554 pd=1.16 as=0.1036 ps=1.02 w=0.74 l=0.15
X1545 VDPWR single_9b_cdac_1.cdac_sw_9b_0.cdac_sw_3_2.nooverlap_clk_0.CLKB0 single_9b_cdac_1.cdac_sw_9b_0.cdac_sw_3_2.nooverlap_clk_0.CLK0 VDPWR sky130_fd_pr__pfet_01v8 ad=0.196 pd=1.47 as=0.168 ps=1.42 w=1.12 l=0.15
X1546 a_9809_27279# sar9b_0.net21 VDPWR VDPWR sky130_fd_pr__pfet_01v8_hvt ad=0.2054 pd=2.1 as=0.11455 ps=1.08 w=0.79 l=0.15
X1547 VDPWR sar9b_0.net4 a_10771_22164# VDPWR sky130_fd_pr__pfet_01v8_hvt ad=0.0864 pd=0.91 as=0.1664 ps=1.8 w=0.64 l=0.15
X1548 single_9b_cdac_1.cdac_sw_9b_0.cdac_sw_3_2.nooverlap_clk_0.CLK0 single_9b_cdac_1.cdac_sw_9b_0.cdac_sw_3_2.nooverlap_clk_0.CLKB0 VGND VGND sky130_fd_pr__nfet_01v8_lvt ad=0.1036 pd=1.02 as=0.1036 ps=1.02 w=0.74 l=0.15
X1549 single_9b_cdac_0.cdac_sw_9b_0.S[5] single_9b_cdac_0.cdac_sw_9b_0.cdac_sw_3_5.nooverlap_clk_0.CLKB0 a_38738_26999# VDPWR sky130_fd_pr__pfet_01v8 ad=0.435 pd=3.58 as=0.435 ps=3.58 w=1.5 l=0.5
X1550 VGND VDPWR VGND VGND sky130_fd_pr__nfet_01v8 ad=0.143 pd=1.62 as=0 ps=0 w=0.55 l=0.59
X1551 a_10477_23252# a_10311_23252# VGND VGND sky130_fd_pr__nfet_01v8 ad=0.1092 pd=1.36 as=0.0567 ps=0.69 w=0.42 l=0.15
X1552 VGND a_12211_18874# a_12145_18900# VGND sky130_fd_pr__nfet_01v8 ad=0.12495 pd=1.015 as=0.0669 ps=0.75 w=0.42 l=0.15
X1553 single_9b_cdac_1.cdac_sw_9b_0.S[8] single_9b_cdac_1.cdac_sw_9b_0.cdac_sw_3_8.tg_sw_3_3.SWN single_9b_cdac_1.cdac_sw_9b_0.S[8] VGND sky130_fd_pr__nfet_01v8 ad=0.145 pd=1.58 as=0 ps=0 w=0.5 l=0.5
X1554 VGND single_9b_cdac_1.cdac_sw_9b_0.cdac_sw_3_3.tg_sw_3_3.SWN single_9b_cdac_1.cdac_sw_9b_0.cdac_sw_3_3.tg_sw_3_3.SWP VGND sky130_fd_pr__nfet_01v8_lvt ad=0.2146 pd=2.06 as=0.1036 ps=1.02 w=0.74 l=0.15
X1555 single_9b_cdac_1.cdac_sw_9b_0.cdac_sw_3_4.nooverlap_clk_0.CLKB0 single_9b_cdac_1.cdac_sw_9b_0.cdac_sw_3_4.nooverlap_clk_0.sky130_fd_sc_hs__inv_8_0.A VGND VGND sky130_fd_pr__nfet_01v8_lvt ad=0.1036 pd=1.02 as=0.1036 ps=1.02 w=0.74 l=0.15
X1556 a_6587_21852# a_6859_21710# VGND VGND sky130_fd_pr__nfet_01v8 ad=0.1092 pd=1.36 as=0.0567 ps=0.69 w=0.42 l=0.15
X1557 th_dif_sw_0.VCP ua[0] sky130_fd_pr__cap_mim_m3_1 l=2 w=2
X1558 th_dif_sw_0.VCN single_9b_cdac_0.cdac_sw_9b_0.S[0] sky130_fd_pr__cap_mim_m3_1 l=2 w=2
X1559 single_9b_cdac_1.cdac_sw_9b_0.cdac_sw_3_2.nooverlap_clk_0.CLK0 single_9b_cdac_1.cdac_sw_9b_0.cdac_sw_3_2.nooverlap_clk_0.CLKB0 VDPWR VDPWR sky130_fd_pr__pfet_01v8 ad=0.168 pd=1.42 as=0.168 ps=1.42 w=1.12 l=0.15
X1560 a_6308_27060# a_6094_27060# VDPWR VDPWR sky130_fd_pr__pfet_01v8_hvt ad=0.1155 pd=0.97 as=0.07035 ps=0.755 w=0.42 l=0.15
X1561 VGND a_7325_26681# uio_out[0] VGND sky130_fd_pr__nfet_01v8 ad=0.0754 pd=0.81 as=0.1352 ps=1.56 w=0.52 l=0.15
X1562 ua[0] single_9b_cdac_1.cdac_sw_9b_0.cdac_sw_3_0.tg_sw_3_3.SWN ua[0] VGND sky130_fd_pr__nfet_01v8 ad=0.145 pd=1.58 as=0 ps=0 w=0.5 l=0.5
X1563 VGND sar9b_0.FINAL a_7919_27066# VGND sky130_fd_pr__nfet_01v8 ad=0.0567 pd=0.69 as=0.1092 ps=1.36 w=0.42 l=0.15
X1564 single_9b_cdac_0.cdac_sw_9b_0.cdac_sw_3_3.nooverlap_clk_0.CLKB0 single_9b_cdac_0.cdac_sw_9b_0.cdac_sw_3_3.nooverlap_clk_0.sky130_fd_sc_hs__inv_8_0.A VGND VGND sky130_fd_pr__nfet_01v8_lvt ad=0.1036 pd=1.02 as=0.1295 ps=1.09 w=0.74 l=0.15
X1565 VGND VDPWR VGND VGND sky130_fd_pr__nfet_01v8 ad=0.143 pd=1.62 as=0 ps=0 w=0.55 l=0.59
X1566 VGND single_9b_cdac_0.SW[8] a_25210_26990# VGND sky130_fd_pr__nfet_01v8 ad=0.145 pd=1.58 as=0.145 ps=1.58 w=0.5 l=0.5
X1567 VGND single_9b_cdac_0.SW[3] a_49221_26990# VGND sky130_fd_pr__nfet_01v8 ad=0.145 pd=1.58 as=0.145 ps=1.58 w=0.5 l=0.5
X1568 a_13968_26516# a_13053_26516# a_13621_26758# VGND sky130_fd_pr__special_nfet_01v8 ad=0.0711 pd=0.755 as=0.0999 ps=0.985 w=0.36 l=0.15
X1569 VDPWR single_9b_cdac_1.cdac_sw_9b_0.cdac_sw_3_2.nooverlap_clk_0.CLKB0 single_9b_cdac_1.cdac_sw_9b_0.cdac_sw_3_2.nooverlap_clk_0.CLK0 VDPWR sky130_fd_pr__pfet_01v8 ad=0.168 pd=1.42 as=0.168 ps=1.42 w=1.12 l=0.15
X1570 VGND a_6701_20506# sar9b_0.clknet_1_0__leaf_CLK VGND sky130_fd_pr__nfet_01v8 ad=0.0588 pd=0.7 as=0.0588 ps=0.7 w=0.42 l=0.15
X1571 VGND VDPWR VGND VGND sky130_fd_pr__nfet_01v8 ad=0.143 pd=1.62 as=0 ps=0 w=0.55 l=0.59
X1572 VDPWR VGND VDPWR VDPWR sky130_fd_pr__pfet_01v8_hvt ad=0.2262 pd=2.26 as=0 ps=0 w=0.87 l=0.59
X1573 single_9b_cdac_1.cdac_sw_9b_0.S[3] single_9b_cdac_1.cdac_sw_9b_0.cdac_sw_3_4.tg_sw_3_3.SWP ua[0] VGND sky130_fd_pr__nfet_01v8 ad=0.145 pd=1.58 as=0.145 ps=1.58 w=0.5 l=0.5
X1574 th_dif_sw_0.VCN single_9b_cdac_0.cdac_sw_9b_0.S[4] sky130_fd_pr__cap_mim_m3_1 l=2 w=2
X1575 VDPWR single_9b_cdac_1.cdac_sw_9b_0.cdac_sw_3_2.nooverlap_clk_0.x8.A single_9b_cdac_1.cdac_sw_9b_0.cdac_sw_3_2.nooverlap_clk_0.x10.A VDPWR sky130_fd_pr__pfet_01v8 ad=0.3304 pd=2.83 as=0.168 ps=1.42 w=1.12 l=0.15
X1576 single_9b_cdac_0.cdac_sw_9b_0.cdac_sw_3_8.nooverlap_clk_0.x10.A single_9b_cdac_0.cdac_sw_9b_0.cdac_sw_3_8.nooverlap_clk_0.x8.A VDPWR VDPWR sky130_fd_pr__pfet_01v8 ad=0.168 pd=1.42 as=0.168 ps=1.42 w=1.12 l=0.15
X1577 VDPWR single_9b_cdac_0.cdac_sw_9b_0.cdac_sw_3_2.tg_sw_3_3.SWN single_9b_cdac_0.cdac_sw_9b_0.cdac_sw_3_2.tg_sw_3_3.SWP VDPWR sky130_fd_pr__pfet_01v8 ad=0.196 pd=1.47 as=0.168 ps=1.42 w=1.12 l=0.15
X1578 a_11554_24884# a_10477_24890# a_11392_25262# VDPWR sky130_fd_pr__pfet_01v8_hvt ad=0.0567 pd=0.69 as=0.0588 ps=0.7 w=0.42 l=0.15
X1579 a_9419_20532# a_8637_20538# a_9335_20532# VDPWR sky130_fd_pr__pfet_01v8_hvt ad=0.0882 pd=0.84 as=0.0567 ps=0.69 w=0.42 l=0.15
X1580 single_9b_cdac_1.cdac_sw_9b_0.cdac_sw_3_6.nooverlap_clk_0.sky130_fd_sc_hs__inv_1_1.A single_9b_cdac_1.cdac_sw_9b_0.cdac_sw_3_6.nooverlap_clk_0.sky130_fd_sc_hs__nand2_1_0.Y VGND VGND sky130_fd_pr__nfet_01v8_lvt ad=0.2109 pd=2.05 as=0.2627 ps=2.19 w=0.74 l=0.15
X1581 th_dif_sw_0.VCN single_9b_cdac_0.cdac_sw_9b_0.S[1] sky130_fd_pr__cap_mim_m3_1 l=2 w=2
X1582 single_9b_cdac_1.cdac_sw_9b_0.cdac_sw_3_2.nooverlap_clk_0.CLK0 single_9b_cdac_1.cdac_sw_9b_0.cdac_sw_3_2.nooverlap_clk_0.CLKB0 VDPWR VDPWR sky130_fd_pr__pfet_01v8 ad=0.168 pd=1.42 as=0.196 ps=1.47 w=1.12 l=0.15
X1583 VGND single_9b_cdac_0.cdac_sw_9b_0.cdac_sw_3_3.nooverlap_clk_0.x4.A single_9b_cdac_0.cdac_sw_9b_0.cdac_sw_3_3.nooverlap_clk_0.x6.A VGND sky130_fd_pr__nfet_01v8_lvt ad=0.2627 pd=2.19 as=0.2109 ps=2.05 w=0.74 l=0.15
X1584 VDPWR VGND VDPWR VDPWR sky130_fd_pr__pfet_01v8_hvt ad=0.2262 pd=2.26 as=0 ps=0 w=0.87 l=0.59
X1585 VGND single_9b_cdac_1.cdac_sw_9b_0.cdac_sw_3_3.nooverlap_clk_0.CLKB0 single_9b_cdac_1.cdac_sw_9b_0.cdac_sw_3_3.nooverlap_clk_0.CLK0 VGND sky130_fd_pr__nfet_01v8_lvt ad=0.1036 pd=1.02 as=0.1036 ps=1.02 w=0.74 l=0.15
X1586 a_46159_15501# single_9b_cdac_1.CF[4] single_9b_cdac_1.cdac_sw_9b_0.cdac_sw_3_3.nooverlap_clk_0.sky130_fd_sc_hs__nand2_1_0.Y VGND sky130_fd_pr__nfet_01v8_lvt ad=0.0888 pd=0.98 as=0.2109 ps=2.05 w=0.74 l=0.15
X1587 VDPWR a_9132_7271# th_dif_sw_0.th_sw_1.CK VDPWR sky130_fd_pr__pfet_01v8 ad=0.168 pd=1.42 as=0.168 ps=1.42 w=1.12 l=0.15
X1588 a_6163_27034# a_5968_27176# a_6473_27426# VGND sky130_fd_pr__special_nfet_01v8 ad=0.0594 pd=0.69 as=0.1401 ps=1.1 w=0.36 l=0.15
X1589 VDPWR sar9b_0.net30 a_14451_25972# VDPWR sky130_fd_pr__pfet_01v8_hvt ad=0.11455 pd=1.08 as=0.2054 ps=2.1 w=0.79 l=0.15
X1590 a_13573_24162# a_13529_23770# a_13407_24174# VGND sky130_fd_pr__nfet_01v8 ad=0.0441 pd=0.63 as=0.1401 ps=1.1 w=0.42 l=0.15
X1591 VDPWR a_14051_24100# a_14038_23796# VDPWR sky130_fd_pr__pfet_01v8_hvt ad=0.0819 pd=0.81 as=0.0567 ps=0.69 w=0.42 l=0.15
X1592 th_dif_sw_0.VCN single_9b_cdac_0.cdac_sw_9b_0.S[1] sky130_fd_pr__cap_mim_m3_1 l=2 w=2
X1593 single_9b_cdac_1.cdac_sw_9b_0.cdac_sw_3_2.nooverlap_clk_0.x10.A single_9b_cdac_1.cdac_sw_9b_0.cdac_sw_3_2.nooverlap_clk_0.x8.A VDPWR VDPWR sky130_fd_pr__pfet_01v8 ad=0.168 pd=1.42 as=0.168 ps=1.42 w=1.12 l=0.15
X1594 VDPWR single_9b_cdac_0.cdac_sw_9b_0.cdac_sw_3_8.nooverlap_clk_0.x8.A single_9b_cdac_0.cdac_sw_9b_0.cdac_sw_3_8.nooverlap_clk_0.x10.A VDPWR sky130_fd_pr__pfet_01v8 ad=0.168 pd=1.42 as=0.168 ps=1.42 w=1.12 l=0.15
X1595 a_49221_17740# single_9b_cdac_1.cdac_sw_9b_0.cdac_sw_3_4.nooverlap_clk_0.CLK0 single_9b_cdac_1.cdac_sw_9b_0.S[3] VGND sky130_fd_pr__nfet_01v8 ad=0.145 pd=1.58 as=0.145 ps=1.58 w=0.5 l=0.5
X1596 th_dif_sw_0.VCN single_9b_cdac_0.cdac_sw_9b_0.S[0] sky130_fd_pr__cap_mim_m3_1 l=2 w=2
X1597 VGND VDPWR VGND VGND sky130_fd_pr__nfet_01v8 ad=0.143 pd=1.62 as=0 ps=0 w=0.55 l=0.59
X1598 a_11852_22164# a_10771_22164# a_11505_22406# VDPWR sky130_fd_pr__pfet_01v8_hvt ad=0.0588 pd=0.7 as=0.12915 ps=1.185 w=0.42 l=0.15
X1599 single_9b_cdac_1.cdac_sw_9b_0.cdac_sw_3_3.nooverlap_clk_0.x8.A single_9b_cdac_1.cdac_sw_9b_0.cdac_sw_3_3.nooverlap_clk_0.x6.A VGND VGND sky130_fd_pr__nfet_01v8_lvt ad=0.2109 pd=2.05 as=0.2627 ps=2.19 w=0.74 l=0.15
X1600 VDPWR single_9b_cdac_1.cdac_sw_9b_0.cdac_sw_3_2.nooverlap_clk_0.x8.A single_9b_cdac_1.cdac_sw_9b_0.cdac_sw_3_2.nooverlap_clk_0.x10.A VDPWR sky130_fd_pr__pfet_01v8 ad=0.168 pd=1.42 as=0.168 ps=1.42 w=1.12 l=0.15
X1601 VGND sar9b_0.net15 a_11733_21076# VGND sky130_fd_pr__nfet_01v8 ad=0.1346 pd=1.15 as=0.0441 ps=0.63 w=0.42 l=0.15
X1602 VDPWR single_9b_cdac_1.cdac_sw_9b_0.cdac_sw_3_4.tg_sw_3_3.SWN single_9b_cdac_1.cdac_sw_9b_0.cdac_sw_3_4.tg_sw_3_3.SWP VDPWR sky130_fd_pr__pfet_01v8 ad=0.3864 pd=2.93 as=0.168 ps=1.42 w=1.12 l=0.15
X1603 single_9b_cdac_0.cdac_sw_9b_0.cdac_sw_3_8.nooverlap_clk_0.x10.A single_9b_cdac_0.cdac_sw_9b_0.cdac_sw_3_8.nooverlap_clk_0.x8.A VDPWR VDPWR sky130_fd_pr__pfet_01v8 ad=0.168 pd=1.42 as=0.3304 ps=2.83 w=1.12 l=0.15
X1604 a_39616_26990# single_9b_cdac_0.cdac_sw_9b_0.cdac_sw_3_5.nooverlap_clk_0.CLK0 single_9b_cdac_0.cdac_sw_9b_0.S[5] VGND sky130_fd_pr__nfet_01v8 ad=0.145 pd=1.58 as=0.145 ps=1.58 w=0.5 l=0.5
X1605 VGND single_9b_cdac_0.SW[5] a_39616_26990# VGND sky130_fd_pr__nfet_01v8 ad=0.145 pd=1.58 as=0.145 ps=1.58 w=0.5 l=0.5
X1606 a_9003_24706# sar9b_0.net15 VDPWR VDPWR sky130_fd_pr__pfet_01v8_hvt ad=0.1092 pd=1.36 as=0.07035 ps=0.755 w=0.42 l=0.15
X1607 a_10935_23618# a_10311_23252# a_10827_23252# VDPWR sky130_fd_pr__pfet_01v8_hvt ad=0.1155 pd=0.97 as=0.07245 ps=0.765 w=0.42 l=0.15
X1608 single_9b_cdac_1.SW[6] a_14175_20532# VGND VGND sky130_fd_pr__nfet_01v8 ad=0.1352 pd=1.56 as=0.0754 ps=0.81 w=0.52 l=0.15
X1609 a_44418_17740# single_9b_cdac_1.cdac_sw_9b_0.cdac_sw_3_3.nooverlap_clk_0.CLK0 single_9b_cdac_1.cdac_sw_9b_0.S[4] VGND sky130_fd_pr__nfet_01v8 ad=0.145 pd=1.58 as=0.145 ps=1.58 w=0.5 l=0.5
X1610 single_9b_cdac_0.cdac_sw_9b_0.S[4] single_9b_cdac_0.cdac_sw_9b_0.cdac_sw_3_3.tg_sw_3_3.SWN ua[0] VDPWR sky130_fd_pr__pfet_01v8 ad=0.435 pd=3.58 as=0.435 ps=3.58 w=1.5 l=0.5
X1611 VGND a_6759_20354# a_6930_20241# VGND sky130_fd_pr__nfet_01v8 ad=0.10563 pd=0.975 as=0.169 ps=1.82 w=0.65 l=0.15
X1612 single_9b_cdac_1.cdac_sw_9b_0.cdac_sw_3_4.tg_sw_3_3.SWP single_9b_cdac_1.cdac_sw_9b_0.cdac_sw_3_4.tg_sw_3_3.SWN VDPWR VDPWR sky130_fd_pr__pfet_01v8 ad=0.168 pd=1.42 as=0.196 ps=1.47 w=1.12 l=0.15
X1613 single_9b_cdac_1.cdac_sw_9b_0.cdac_sw_3_2.nooverlap_clk_0.x10.A single_9b_cdac_1.cdac_sw_9b_0.cdac_sw_3_2.nooverlap_clk_0.x8.A VDPWR VDPWR sky130_fd_pr__pfet_01v8 ad=0.168 pd=1.42 as=0.3304 ps=2.83 w=1.12 l=0.15
X1614 VDPWR single_9b_cdac_1.cdac_sw_9b_0.cdac_sw_3_4.nooverlap_clk_0.CLKB0 single_9b_cdac_1.cdac_sw_9b_0.cdac_sw_3_4.nooverlap_clk_0.CLK0 VDPWR sky130_fd_pr__pfet_01v8 ad=0.196 pd=1.47 as=0.168 ps=1.42 w=1.12 l=0.15
X1615 VGND a_9132_7271# th_dif_sw_0.th_sw_1.CK VGND sky130_fd_pr__nfet_01v8_lvt ad=0.2109 pd=2.05 as=0.1036 ps=1.02 w=0.74 l=0.15
X1616 VGND single_9b_cdac_0.cdac_sw_9b_0.cdac_sw_3_1.nooverlap_clk_0.sky130_fd_sc_hs__inv_8_0.A single_9b_cdac_0.cdac_sw_9b_0.cdac_sw_3_1.nooverlap_clk_0.CLKB0 VGND sky130_fd_pr__nfet_01v8_lvt ad=0.1554 pd=1.16 as=0.1036 ps=1.02 w=0.74 l=0.15
X1617 ua[0] single_9b_cdac_1.cdac_sw_9b_0.cdac_sw_3_4.tg_sw_3_3.SWP ua[0] VDPWR sky130_fd_pr__pfet_01v8 ad=0.435 pd=3.58 as=0 ps=0 w=1.5 l=0.5
X1618 VGND single_9b_cdac_1.SW[2] a_54032_17740# VGND sky130_fd_pr__nfet_01v8 ad=0.145 pd=1.58 as=0.145 ps=1.58 w=0.5 l=0.5
X1619 th_dif_sw_0.VCP single_9b_cdac_1.cdac_sw_9b_0.S[0] sky130_fd_pr__cap_mim_m3_1 l=2 w=2
X1620 a_16159_13315# tdc_0.phase_detector_0.pd_out_0.B a_16185_12837# VDPWR sky130_fd_pr__pfet_01v8 ad=0.295 pd=2.59 as=0.135 ps=1.27 w=1 l=0.15
X1621 VDPWR sar9b_0.net4 a_9115_21076# VDPWR sky130_fd_pr__pfet_01v8_hvt ad=0.0864 pd=0.91 as=0.1664 ps=1.8 w=0.64 l=0.15
X1622 single_9b_cdac_1.cdac_sw_9b_0.cdac_sw_3_4.nooverlap_clk_0.CLK0 single_9b_cdac_1.cdac_sw_9b_0.cdac_sw_3_4.nooverlap_clk_0.CLKB0 VDPWR VDPWR sky130_fd_pr__pfet_01v8 ad=0.168 pd=1.42 as=0.3304 ps=2.83 w=1.12 l=0.15
X1623 th_dif_sw_0.th_sw_1.CKB a_21177_7457# VDPWR VDPWR sky130_fd_pr__pfet_01v8 ad=0.168 pd=1.42 as=0.168 ps=1.42 w=1.12 l=0.15
X1624 a_9727_26516# a_9281_26516# a_9631_26516# VGND sky130_fd_pr__special_nfet_01v8 ad=0.1401 pd=1.1 as=0.0594 ps=0.69 w=0.36 l=0.15
X1625 a_6817_21736# sar9b_0.net15 a_6722_21736# VDPWR sky130_fd_pr__pfet_01v8_hvt ad=0.0441 pd=0.63 as=0.06825 ps=0.745 w=0.42 l=0.15
X1626 VDPWR single_9b_cdac_0.cdac_sw_9b_0.cdac_sw_3_0.nooverlap_clk_0.sky130_fd_sc_hs__inv_1_1.A single_9b_cdac_0.cdac_sw_9b_0.cdac_sw_3_0.nooverlap_clk_0.x1.A VDPWR sky130_fd_pr__pfet_01v8 ad=0.3864 pd=2.93 as=0.3304 ps=2.83 w=1.12 l=0.15
X1627 sar9b_0.net10 a_12027_22138# VDPWR VDPWR sky130_fd_pr__pfet_01v8_hvt ad=0.26 pd=2.52 as=0.3012 ps=2.66 w=1 l=0.15
X1628 single_9b_cdac_1.cdac_sw_9b_0.cdac_sw_3_8.tg_sw_3_3.SWN single_9b_cdac_1.cdac_sw_9b_0.cdac_sw_3_8.nooverlap_clk_0.x10.A VGND VGND sky130_fd_pr__nfet_01v8_lvt ad=0.1036 pd=1.02 as=0.1554 ps=1.16 w=0.74 l=0.15
X1629 th_dif_sw_0.VCN single_9b_cdac_0.cdac_sw_9b_0.S[0] sky130_fd_pr__cap_mim_m3_1 l=2 w=2
X1630 th_dif_sw_0.th_sw_1.CKB a_21177_7457# VGND VGND sky130_fd_pr__nfet_01v8_lvt ad=0.1036 pd=1.02 as=0.1036 ps=1.02 w=0.74 l=0.15
X1631 single_9b_cdac_1.cdac_sw_9b_0.cdac_sw_3_1.nooverlap_clk_0.sky130_fd_sc_hs__inv_8_0.A single_9b_cdac_1.cdac_sw_9b_0.cdac_sw_3_1.nooverlap_clk_0.x1.A VGND VGND sky130_fd_pr__nfet_01v8_lvt ad=0.1184 pd=1.06 as=0.2331 ps=2.11 w=0.74 l=0.15
X1632 single_9b_cdac_0.cdac_sw_9b_0.cdac_sw_3_6.nooverlap_clk_0.sky130_fd_sc_hs__inv_8_0.A single_9b_cdac_0.cdac_sw_9b_0.cdac_sw_3_6.nooverlap_clk_0.x1.A VGND VGND sky130_fd_pr__nfet_01v8_lvt ad=0.1036 pd=1.02 as=0.2109 ps=2.05 w=0.74 l=0.15
X1633 VDPWR single_9b_cdac_0.cdac_sw_9b_0.cdac_sw_3_5.nooverlap_clk_0.x10.A single_9b_cdac_0.cdac_sw_9b_0.cdac_sw_3_5.tg_sw_3_3.SWN VDPWR sky130_fd_pr__pfet_01v8 ad=0.196 pd=1.47 as=0.168 ps=1.42 w=1.12 l=0.15
X1634 single_9b_cdac_0.cdac_sw_9b_0.S[4] single_9b_cdac_0.cdac_sw_9b_0.cdac_sw_3_3.nooverlap_clk_0.CLKB0 a_43540_26999# VDPWR sky130_fd_pr__pfet_01v8 ad=0.435 pd=3.58 as=0.435 ps=3.58 w=1.5 l=0.5
X1635 VGND single_9b_cdac_0.cdac_sw_9b_0.cdac_sw_3_0.nooverlap_clk_0.x1.A single_9b_cdac_0.cdac_sw_9b_0.cdac_sw_3_0.nooverlap_clk_0.sky130_fd_sc_hs__inv_8_0.A VGND sky130_fd_pr__nfet_01v8_lvt ad=0.1221 pd=1.07 as=0.1036 ps=1.02 w=0.74 l=0.15
X1636 VDPWR sar9b_0.net15 a_10356_20354# VDPWR sky130_fd_pr__pfet_01v8_hvt ad=0.07035 pd=0.755 as=0.1092 ps=1.36 w=0.42 l=0.15
X1637 single_9b_cdac_1.cdac_sw_9b_0.S[7] single_9b_cdac_1.cdac_sw_9b_0.cdac_sw_3_7.tg_sw_3_3.SWN ua[0] VDPWR sky130_fd_pr__pfet_01v8 ad=0.435 pd=3.58 as=0.435 ps=3.58 w=1.5 l=0.5
X1638 single_9b_cdac_1.cdac_sw_9b_0.S[4] single_9b_cdac_1.cdac_sw_9b_0.cdac_sw_3_3.tg_sw_3_3.SWN ua[0] VDPWR sky130_fd_pr__pfet_01v8 ad=0.435 pd=3.58 as=0.435 ps=3.58 w=1.5 l=0.5
X1639 single_9b_cdac_0.cdac_sw_9b_0.cdac_sw_3_8.nooverlap_clk_0.CLKB0 single_9b_cdac_0.cdac_sw_9b_0.cdac_sw_3_8.nooverlap_clk_0.sky130_fd_sc_hs__inv_8_0.A VDPWR VDPWR sky130_fd_pr__pfet_01v8 ad=0.168 pd=1.42 as=0.196 ps=1.47 w=1.12 l=0.15
X1640 a_6960_26338# sar9b_0.net38 VGND VGND sky130_fd_pr__nfet_01v8 ad=0.066 pd=0.745 as=0.2205 ps=1.89 w=0.42 l=0.15
X1641 VGND single_9b_cdac_1.cdac_sw_9b_0.cdac_sw_3_1.nooverlap_clk_0.sky130_fd_sc_hs__inv_8_0.A single_9b_cdac_1.cdac_sw_9b_0.cdac_sw_3_1.nooverlap_clk_0.CLKB0 VGND sky130_fd_pr__nfet_01v8_lvt ad=0.1295 pd=1.09 as=0.1036 ps=1.02 w=0.74 l=0.15
X1642 VDPWR a_12211_21050# a_12198_21442# VDPWR sky130_fd_pr__pfet_01v8_hvt ad=0.0819 pd=0.81 as=0.0567 ps=0.69 w=0.42 l=0.15
X1643 VDPWR VGND VDPWR VDPWR sky130_fd_pr__pfet_01v8_hvt ad=0.2262 pd=2.26 as=0 ps=0 w=0.87 l=0.59
X1644 VDPWR single_9b_cdac_1.cdac_sw_9b_0.cdac_sw_3_7.tg_sw_3_3.SWN single_9b_cdac_1.cdac_sw_9b_0.cdac_sw_3_7.tg_sw_3_3.SWP VDPWR sky130_fd_pr__pfet_01v8 ad=0.196 pd=1.47 as=0.168 ps=1.42 w=1.12 l=0.15
X1645 th_dif_sw_0.VCN single_9b_cdac_0.cdac_sw_9b_0.S[4] sky130_fd_pr__cap_mim_m3_1 l=2 w=2
X1646 single_9b_cdac_0.cdac_sw_9b_0.cdac_sw_3_7.nooverlap_clk_0.x10.A single_9b_cdac_0.cdac_sw_9b_0.cdac_sw_3_7.nooverlap_clk_0.x8.A VGND VGND sky130_fd_pr__nfet_01v8_lvt ad=0.1184 pd=1.06 as=0.1221 ps=1.07 w=0.74 l=0.15
X1647 single_9b_cdac_0.cdac_sw_9b_0.cdac_sw_3_5.tg_sw_3_3.SWN single_9b_cdac_0.cdac_sw_9b_0.cdac_sw_3_5.nooverlap_clk_0.x10.A VDPWR VDPWR sky130_fd_pr__pfet_01v8 ad=0.168 pd=1.42 as=0.168 ps=1.42 w=1.12 l=0.15
X1648 VGND single_9b_cdac_0.cdac_sw_9b_0.cdac_sw_3_5.nooverlap_clk_0.CLKB0 single_9b_cdac_0.cdac_sw_9b_0.cdac_sw_3_5.nooverlap_clk_0.CLK0 VGND sky130_fd_pr__nfet_01v8_lvt ad=0.1036 pd=1.02 as=0.1036 ps=1.02 w=0.74 l=0.15
X1649 VGND single_9b_cdac_0.cdac_sw_9b_0.cdac_sw_3_4.nooverlap_clk_0.x6.A single_9b_cdac_0.cdac_sw_9b_0.cdac_sw_3_4.nooverlap_clk_0.x8.A VGND sky130_fd_pr__nfet_01v8_lvt ad=0.2627 pd=2.19 as=0.2109 ps=2.05 w=0.74 l=0.15
X1650 a_11579_26882# sar9b_0.net3 VDPWR VDPWR sky130_fd_pr__pfet_01v8_hvt ad=0.1092 pd=1.36 as=0.07035 ps=0.755 w=0.42 l=0.15
X1651 a_25210_26990# single_9b_cdac_0.cdac_sw_9b_0.cdac_sw_3_8.nooverlap_clk_0.CLK0 single_9b_cdac_0.cdac_sw_9b_0.S[8] VGND sky130_fd_pr__nfet_01v8 ad=0.145 pd=1.58 as=0.145 ps=1.58 w=0.5 l=0.5
X1652 VGND single_9b_cdac_0.cdac_sw_9b_0.cdac_sw_3_3.tg_sw_3_3.SWN single_9b_cdac_0.cdac_sw_9b_0.cdac_sw_3_3.tg_sw_3_3.SWP VGND sky130_fd_pr__nfet_01v8_lvt ad=0.2109 pd=2.05 as=0.1036 ps=1.02 w=0.74 l=0.15
X1653 single_9b_cdac_0.cdac_sw_9b_0.S[0] single_9b_cdac_0.cdac_sw_9b_0.cdac_sw_3_2.tg_sw_3_3.SWN single_9b_cdac_0.cdac_sw_9b_0.S[0] VGND sky130_fd_pr__nfet_01v8 ad=0.145 pd=1.58 as=2.32 ps=25.28 w=0.5 l=0.5
X1654 a_8991_24340# a_8545_24340# a_8895_24340# VGND sky130_fd_pr__special_nfet_01v8 ad=0.1401 pd=1.1 as=0.0594 ps=0.69 w=0.36 l=0.15
X1655 VDPWR a_14143_22138# a_14130_22530# VDPWR sky130_fd_pr__pfet_01v8_hvt ad=0.0819 pd=0.81 as=0.0567 ps=0.69 w=0.42 l=0.15
X1656 VDPWR VGND VDPWR VDPWR sky130_fd_pr__pfet_01v8_hvt ad=0.2262 pd=2.26 as=0 ps=0 w=0.87 l=0.59
X1657 a_13968_19988# a_13053_19988# a_13621_20230# VGND sky130_fd_pr__special_nfet_01v8 ad=0.0711 pd=0.755 as=0.0999 ps=0.985 w=0.36 l=0.15
X1658 VDPWR a_13621_26758# a_13511_26882# VDPWR sky130_fd_pr__pfet_01v8_hvt ad=0.07035 pd=0.755 as=0.1155 ps=0.97 w=0.42 l=0.15
X1659 VDPWR single_9b_cdac_0.cdac_sw_9b_0.cdac_sw_3_5.nooverlap_clk_0.x10.A single_9b_cdac_0.cdac_sw_9b_0.cdac_sw_3_5.tg_sw_3_3.SWN VDPWR sky130_fd_pr__pfet_01v8 ad=0.168 pd=1.42 as=0.168 ps=1.42 w=1.12 l=0.15
X1660 VDPWR sar9b_0.net15 a_14451_17812# VDPWR sky130_fd_pr__pfet_01v8_hvt ad=0.11455 pd=1.08 as=0.2054 ps=2.1 w=0.79 l=0.15
X1661 single_9b_cdac_1.cdac_sw_9b_0.cdac_sw_3_7.tg_sw_3_3.SWP single_9b_cdac_1.cdac_sw_9b_0.cdac_sw_3_7.tg_sw_3_3.SWN VDPWR VDPWR sky130_fd_pr__pfet_01v8 ad=0.168 pd=1.42 as=0.168 ps=1.42 w=1.12 l=0.15
X1662 th_dif_sw_0.VCP single_9b_cdac_1.cdac_sw_9b_0.S[0] sky130_fd_pr__cap_mim_m3_1 l=2 w=2
X1663 a_13511_22708# sar9b_0.net15 VDPWR VDPWR sky130_fd_pr__pfet_01v8_hvt ad=0.1092 pd=1.36 as=0.07035 ps=0.755 w=0.42 l=0.15
X1664 a_12145_21076# a_10955_21076# a_12036_21076# VGND sky130_fd_pr__special_nfet_01v8 ad=0.0669 pd=0.75 as=0.0711 ps=0.755 w=0.36 l=0.15
X1665 VDPWR VGND VDPWR VDPWR sky130_fd_pr__pfet_01v8_hvt ad=0.2262 pd=2.26 as=0 ps=0 w=0.87 l=0.59
X1666 VGND single_9b_cdac_1.SW[8] a_25210_17740# VGND sky130_fd_pr__nfet_01v8 ad=0.145 pd=1.58 as=0.145 ps=1.58 w=0.5 l=0.5
X1667 th_dif_sw_0.VCN single_9b_cdac_0.cdac_sw_9b_0.S[0] sky130_fd_pr__cap_mim_m3_1 l=2 w=2
X1668 VDPWR single_9b_cdac_0.cdac_sw_9b_0.cdac_sw_3_3.tg_sw_3_3.SWN single_9b_cdac_0.cdac_sw_9b_0.cdac_sw_3_3.tg_sw_3_3.SWP VDPWR sky130_fd_pr__pfet_01v8 ad=0.3304 pd=2.83 as=0.168 ps=1.42 w=1.12 l=0.15
X1669 VDPWR single_9b_cdac_1.cdac_sw_9b_0.cdac_sw_3_7.tg_sw_3_3.SWN single_9b_cdac_1.cdac_sw_9b_0.cdac_sw_3_7.tg_sw_3_3.SWP VDPWR sky130_fd_pr__pfet_01v8 ad=0.168 pd=1.42 as=0.168 ps=1.42 w=1.12 l=0.15
X1670 th_dif_sw_0.VCN single_9b_cdac_0.cdac_sw_9b_0.S[1] sky130_fd_pr__cap_mim_m3_1 l=2 w=2
X1671 VGND a_10187_22138# a_10121_22164# VGND sky130_fd_pr__nfet_01v8 ad=0.12495 pd=1.015 as=0.0669 ps=0.75 w=0.42 l=0.15
X1672 VGND VDPWR VGND VGND sky130_fd_pr__nfet_01v8 ad=0.143 pd=1.62 as=0 ps=0 w=0.55 l=0.59
X1673 VDPWR VGND VDPWR VDPWR sky130_fd_pr__pfet_01v8_hvt ad=0.2262 pd=2.26 as=0 ps=0 w=0.87 l=0.59
X1674 th_dif_sw_0.VCP single_9b_cdac_1.cdac_sw_9b_0.S[0] sky130_fd_pr__cap_mim_m3_1 l=2 w=2
X1675 sar9b_0.clknet_1_1__leaf_CLK a_6149_23770# VDPWR VDPWR sky130_fd_pr__pfet_01v8_hvt ad=0.14 pd=1.28 as=0.265 ps=2.53 w=1 l=0.15
X1676 VDPWR sar9b_0.net6 a_12887_19988# VDPWR sky130_fd_pr__pfet_01v8_hvt ad=0.0864 pd=0.91 as=0.1664 ps=1.8 w=0.64 l=0.15
X1677 tdc_0.phase_detector_0.INP a_15151_10456# VGND VGND sky130_fd_pr__nfet_01v8_lvt ad=0.2109 pd=2.05 as=0.15535 ps=1.17 w=0.74 l=0.15
X1678 single_9b_cdac_0.cdac_sw_9b_0.cdac_sw_3_3.tg_sw_3_3.SWP single_9b_cdac_0.cdac_sw_9b_0.cdac_sw_3_3.tg_sw_3_3.SWN VDPWR VDPWR sky130_fd_pr__pfet_01v8 ad=0.168 pd=1.42 as=0.196 ps=1.47 w=1.12 l=0.15
X1679 a_12112_26338# sar9b_0.net43 VDPWR VDPWR sky130_fd_pr__pfet_01v8_hvt ad=0.0651 pd=0.73 as=0.1092 ps=1.36 w=0.42 l=0.15
X1680 a_14077_22164# a_12887_22164# a_13968_22164# VGND sky130_fd_pr__special_nfet_01v8 ad=0.0669 pd=0.75 as=0.0711 ps=0.755 w=0.36 l=0.15
X1681 single_9b_cdac_1.cdac_sw_9b_0.cdac_sw_3_7.tg_sw_3_3.SWP single_9b_cdac_1.cdac_sw_9b_0.cdac_sw_3_7.tg_sw_3_3.SWN VDPWR VDPWR sky130_fd_pr__pfet_01v8 ad=0.168 pd=1.42 as=0.196 ps=1.47 w=1.12 l=0.15
X1682 th_dif_sw_0.VCP single_9b_cdac_1.cdac_sw_9b_0.S[1] sky130_fd_pr__cap_mim_m3_1 l=2 w=2
X1683 VGND VDPWR VGND VGND sky130_fd_pr__nfet_01v8 ad=0.143 pd=1.62 as=0 ps=0 w=0.55 l=0.59
X1684 sar9b_0.net27 a_14143_19962# VDPWR VDPWR sky130_fd_pr__pfet_01v8_hvt ad=0.26 pd=2.52 as=0.3012 ps=2.66 w=1 l=0.15
X1685 th_dif_sw_0.VCN single_9b_cdac_0.cdac_sw_9b_0.S[5] sky130_fd_pr__cap_mim_m3_1 l=2 w=2
X1686 th_dif_sw_0.VCN single_9b_cdac_0.cdac_sw_9b_0.S[3] sky130_fd_pr__cap_mim_m3_1 l=2 w=2
X1687 a_6094_27060# a_6007_27302# a_5690_27192# VDPWR sky130_fd_pr__pfet_01v8_hvt ad=0.12915 pd=1.185 as=0.0588 ps=0.7 w=0.42 l=0.15
X1688 VDPWR sar9b_0.clknet_1_1__leaf_CLK a_6171_22714# VDPWR sky130_fd_pr__pfet_01v8_hvt ad=0.0864 pd=0.91 as=0.1664 ps=1.8 w=0.64 l=0.15
X1689 VDPWR single_9b_cdac_0.cdac_sw_9b_0.cdac_sw_3_6.nooverlap_clk_0.x3.Y single_9b_cdac_0.cdac_sw_9b_0.cdac_sw_3_6.nooverlap_clk_0.x4.A VDPWR sky130_fd_pr__pfet_01v8 ad=0.3192 pd=2.81 as=0.168 ps=1.42 w=1.12 l=0.15
X1690 single_9b_cdac_1.cdac_sw_9b_0.cdac_sw_3_2.nooverlap_clk_0.x1.A single_9b_cdac_1.cdac_sw_9b_0.cdac_sw_3_2.nooverlap_clk_0.sky130_fd_sc_hs__inv_1_1.A VDPWR VDPWR sky130_fd_pr__pfet_01v8 ad=0.3304 pd=2.83 as=0.3864 ps=2.93 w=1.12 l=0.15
X1691 VGND single_9b_cdac_0.cdac_sw_9b_0.cdac_sw_3_8.nooverlap_clk_0.x1.A single_9b_cdac_0.cdac_sw_9b_0.cdac_sw_3_8.nooverlap_clk_0.sky130_fd_sc_hs__inv_8_0.A VGND sky130_fd_pr__nfet_01v8_lvt ad=0.2331 pd=2.11 as=0.1184 ps=1.06 w=0.74 l=0.15
X1692 th_dif_sw_0.VCN single_9b_cdac_0.cdac_sw_9b_0.S[0] sky130_fd_pr__cap_mim_m3_1 l=2 w=2
X1693 single_9b_cdac_0.cdac_sw_9b_0.cdac_sw_3_6.nooverlap_clk_0.x4.A single_9b_cdac_0.cdac_sw_9b_0.cdac_sw_3_6.nooverlap_clk_0.x1.A VDPWR VDPWR sky130_fd_pr__pfet_01v8 ad=0.168 pd=1.42 as=0.3192 ps=2.81 w=1.12 l=0.15
X1694 VDPWR a_6070_19721# a_5999_19822# VDPWR sky130_fd_pr__pfet_01v8_hvt ad=0.17887 pd=1.26 as=0.1095 ps=1.075 w=0.75 l=0.15
X1695 th_dif_sw_0.VCP single_9b_cdac_1.cdac_sw_9b_0.S[2] sky130_fd_pr__cap_mim_m3_1 l=2 w=2
X1696 sar9b_0.net19 a_7059_25402# VGND VGND sky130_fd_pr__nfet_01v8 ad=0.169 pd=1.82 as=0.2087 ps=2.02 w=0.65 l=0.15
X1697 VGND single_9b_cdac_1.cdac_sw_9b_0.cdac_sw_3_6.nooverlap_clk_0.x10.A single_9b_cdac_1.cdac_sw_9b_0.cdac_sw_3_6.tg_sw_3_3.SWN VGND sky130_fd_pr__nfet_01v8_lvt ad=0.2146 pd=2.06 as=0.1036 ps=1.02 w=0.74 l=0.15
X1698 VGND single_9b_cdac_0.cdac_sw_9b_0.cdac_sw_3_3.nooverlap_clk_0.x1.A single_9b_cdac_0.cdac_sw_9b_0.cdac_sw_3_3.nooverlap_clk_0.sky130_fd_sc_hs__inv_8_0.A VGND sky130_fd_pr__nfet_01v8_lvt ad=0.1221 pd=1.07 as=0.1036 ps=1.02 w=0.74 l=0.15
X1699 VGND th_dif_sw_0.CKB a_21177_7457# VGND sky130_fd_pr__nfet_01v8_lvt ad=0.11655 pd=1.055 as=0.1036 ps=1.02 w=0.74 l=0.15
X1700 single_9b_cdac_0.cdac_sw_9b_0.S[1] single_9b_cdac_0.cdac_sw_9b_0.cdac_sw_3_1.tg_sw_3_3.SWP single_9b_cdac_0.cdac_sw_9b_0.S[1] VDPWR sky130_fd_pr__pfet_01v8 ad=0.435 pd=3.58 as=6.96 ps=57.28 w=1.5 l=0.5
X1701 single_9b_cdac_0.cdac_sw_9b_0.S[8] single_9b_cdac_0.cdac_sw_9b_0.cdac_sw_3_8.tg_sw_3_3.SWN ua[0] VDPWR sky130_fd_pr__pfet_01v8 ad=0.435 pd=3.58 as=0.435 ps=3.58 w=1.5 l=0.5
X1702 a_9460_26350# a_8379_25978# a_9113_25946# VDPWR sky130_fd_pr__pfet_01v8_hvt ad=0.0588 pd=0.7 as=0.12915 ps=1.185 w=0.42 l=0.15
X1703 single_9b_cdac_1.cdac_sw_9b_0.S[6] single_9b_cdac_1.cdac_sw_9b_0.cdac_sw_3_6.tg_sw_3_3.SWN ua[0] VDPWR sky130_fd_pr__pfet_01v8 ad=0.435 pd=3.58 as=0.435 ps=3.58 w=1.5 l=0.5
X1704 single_9b_cdac_0.cdac_sw_9b_0.cdac_sw_3_0.tg_sw_3_3.SWN single_9b_cdac_0.cdac_sw_9b_0.cdac_sw_3_0.nooverlap_clk_0.x10.A VGND VGND sky130_fd_pr__nfet_01v8_lvt ad=0.1036 pd=1.02 as=0.2146 ps=2.06 w=0.74 l=0.15
X1705 VGND a_6587_21852# sar9b_0._08_ VGND sky130_fd_pr__nfet_01v8 ad=0.10025 pd=0.985 as=0.17875 ps=1.85 w=0.65 l=0.15
X1706 ua[1] th_dif_sw_0.th_sw_1.CK ua[1] VGND sky130_fd_pr__nfet_01v8 ad=5.8 pd=40.58 as=18.56 ps=130.32001 w=20 l=0.15
X1707 VGND VDPWR VGND VGND sky130_fd_pr__nfet_01v8 ad=0.143 pd=1.62 as=0 ps=0 w=0.55 l=0.59
X1708 VDPWR sar9b_0.clk_div_0.COUNT\[3\] a_7039_22138# VDPWR sky130_fd_pr__pfet_01v8_hvt ad=0.1226 pd=1.32 as=0.1176 ps=1.4 w=0.42 l=0.15
X1709 a_13665_21076# a_13621_21318# a_13499_21076# VGND sky130_fd_pr__nfet_01v8 ad=0.0441 pd=0.63 as=0.1401 ps=1.1 w=0.42 l=0.15
X1710 a_8825_20532# sar9b_0._05_ VGND VGND sky130_fd_pr__nfet_01v8 ad=0.0813 pd=0.83 as=0.1092 ps=1.36 w=0.42 l=0.15
X1711 dw_17224_1400# a_21368_4076# sky130_fd_pr__cap_mim_m3_1 l=2 w=2
X1712 a_12683_18356# sar9b_0.net15 VDPWR VDPWR sky130_fd_pr__pfet_01v8_hvt ad=0.1092 pd=1.36 as=0.07035 ps=0.755 w=0.42 l=0.15
X1713 th_dif_sw_0.VCP single_9b_cdac_1.cdac_sw_9b_0.S[0] sky130_fd_pr__cap_mim_m3_1 l=2 w=2
X1714 th_dif_sw_0.VCN single_9b_cdac_0.cdac_sw_9b_0.S[1] sky130_fd_pr__cap_mim_m3_1 l=2 w=2
X1715 single_9b_cdac_1.cdac_sw_9b_0.cdac_sw_3_6.nooverlap_clk_0.CLK0 single_9b_cdac_1.cdac_sw_9b_0.cdac_sw_3_6.nooverlap_clk_0.CLKB0 VGND VGND sky130_fd_pr__nfet_01v8_lvt ad=0.1036 pd=1.02 as=0.1036 ps=1.02 w=0.74 l=0.15
X1716 VGND single_9b_cdac_1.cdac_sw_9b_0.cdac_sw_3_0.nooverlap_clk_0.CLKB0 single_9b_cdac_1.cdac_sw_9b_0.cdac_sw_3_0.nooverlap_clk_0.CLK0 VGND sky130_fd_pr__nfet_01v8_lvt ad=0.1295 pd=1.09 as=0.1036 ps=1.02 w=0.74 l=0.15
X1717 single_9b_cdac_0.cdac_sw_9b_0.S[8] single_9b_cdac_0.cdac_sw_9b_0.cdac_sw_3_8.nooverlap_clk_0.CLKB0 a_24332_26999# VDPWR sky130_fd_pr__pfet_01v8 ad=0.435 pd=3.58 as=0.435 ps=3.58 w=1.5 l=0.5
X1718 VGND VDPWR VGND VGND sky130_fd_pr__nfet_01v8 ad=0.143 pd=1.62 as=0 ps=0 w=0.55 l=0.59
X1719 VGND sar9b_0.clknet_1_0__leaf_CLK a_5895_19988# VGND sky130_fd_pr__nfet_01v8 ad=0.0567 pd=0.69 as=0.1092 ps=1.36 w=0.42 l=0.15
X1720 VDPWR VGND VDPWR VDPWR sky130_fd_pr__pfet_01v8_hvt ad=0.2262 pd=2.26 as=0 ps=0 w=0.87 l=0.59
X1721 VGND single_9b_cdac_1.cdac_sw_9b_0.cdac_sw_3_7.tg_sw_3_3.SWN single_9b_cdac_1.cdac_sw_9b_0.cdac_sw_3_7.tg_sw_3_3.SWP VGND sky130_fd_pr__nfet_01v8_lvt ad=0.1554 pd=1.16 as=0.1036 ps=1.02 w=0.74 l=0.15
X1722 dw_17224_1400# a_21368_4076# sky130_fd_pr__cap_mim_m3_1 l=2 w=2
X1723 VDPWR single_9b_cdac_1.cdac_sw_9b_0.cdac_sw_3_2.nooverlap_clk_0.x10.A single_9b_cdac_1.cdac_sw_9b_0.cdac_sw_3_2.tg_sw_3_3.SWN VDPWR sky130_fd_pr__pfet_01v8 ad=0.196 pd=1.47 as=0.168 ps=1.42 w=1.12 l=0.15
X1724 VGND single_9b_cdac_0.cdac_sw_9b_0.cdac_sw_3_2.nooverlap_clk_0.x10.A single_9b_cdac_0.cdac_sw_9b_0.cdac_sw_3_2.tg_sw_3_3.SWN VGND sky130_fd_pr__nfet_01v8_lvt ad=0.1554 pd=1.16 as=0.1036 ps=1.02 w=0.74 l=0.15
X1725 single_9b_cdac_1.SW[4] a_13623_20532# VDPWR VDPWR sky130_fd_pr__pfet_01v8_hvt ad=0.2054 pd=2.1 as=0.11455 ps=1.08 w=0.79 l=0.15
X1726 VDPWR a_21177_7457# th_dif_sw_0.th_sw_1.CKB VDPWR sky130_fd_pr__pfet_01v8 ad=0.168 pd=1.42 as=0.168 ps=1.42 w=1.12 l=0.15
X1727 VDPWR sar9b_0.clknet_1_1__leaf_CLK a_7919_23802# VDPWR sky130_fd_pr__pfet_01v8_hvt ad=0.0864 pd=0.91 as=0.1664 ps=1.8 w=0.64 l=0.15
X1728 a_25210_17740# single_9b_cdac_1.cdac_sw_9b_0.cdac_sw_3_8.nooverlap_clk_0.CLK0 single_9b_cdac_1.cdac_sw_9b_0.S[8] VGND sky130_fd_pr__nfet_01v8 ad=0.145 pd=1.58 as=0.145 ps=1.58 w=0.5 l=0.5
X1729 a_41357_29911# single_9b_cdac_0.cdac_sw_9b_0.cdac_sw_3_5.nooverlap_clk_0.x8.A VGND VGND sky130_fd_pr__nfet_01v8_lvt ad=0.0888 pd=0.98 as=0.2109 ps=2.05 w=0.74 l=0.15
X1730 th_dif_sw_0.VCN single_9b_cdac_0.cdac_sw_9b_0.S[3] sky130_fd_pr__cap_mim_m3_1 l=2 w=2
X1731 single_9b_cdac_1.cdac_sw_9b_0.cdac_sw_3_2.nooverlap_clk_0.x10.A single_9b_cdac_1.cdac_sw_9b_0.cdac_sw_3_2.nooverlap_clk_0.x8.A VGND VGND sky130_fd_pr__nfet_01v8_lvt ad=0.1184 pd=1.06 as=0.2331 ps=2.11 w=0.74 l=0.15
X1732 VGND single_9b_cdac_1.cdac_sw_9b_0.cdac_sw_3_1.nooverlap_clk_0.sky130_fd_sc_hs__inv_8_0.A single_9b_cdac_1.cdac_sw_9b_0.cdac_sw_3_1.nooverlap_clk_0.CLKB0 VGND sky130_fd_pr__nfet_01v8_lvt ad=0.1036 pd=1.02 as=0.1036 ps=1.02 w=0.74 l=0.15
X1733 VDPWR single_9b_cdac_0.cdac_sw_9b_0.cdac_sw_3_6.tg_sw_3_3.SWN single_9b_cdac_0.cdac_sw_9b_0.cdac_sw_3_6.tg_sw_3_3.SWP VDPWR sky130_fd_pr__pfet_01v8 ad=0.196 pd=1.47 as=0.168 ps=1.42 w=1.12 l=0.15
X1734 VGND a_6226_23364# a_6184_23252# VGND sky130_fd_pr__nfet_01v8 ad=0.12095 pd=1.085 as=0.0696 ps=0.765 w=0.42 l=0.15
X1735 VDPWR single_9b_cdac_1.cdac_sw_9b_0.cdac_sw_3_6.nooverlap_clk_0.x8.A single_9b_cdac_1.cdac_sw_9b_0.cdac_sw_3_6.nooverlap_clk_0.x10.A VDPWR sky130_fd_pr__pfet_01v8 ad=0.3304 pd=2.83 as=0.168 ps=1.42 w=1.12 l=0.15
X1736 single_9b_cdac_1.cdac_sw_9b_0.cdac_sw_3_5.tg_sw_3_3.SWN single_9b_cdac_1.cdac_sw_9b_0.cdac_sw_3_5.nooverlap_clk_0.x10.A VGND VGND sky130_fd_pr__nfet_01v8_lvt ad=0.1036 pd=1.02 as=0.1554 ps=1.16 w=0.74 l=0.15
X1737 a_6691_26490# a_6516_26516# a_6870_26516# VGND sky130_fd_pr__nfet_01v8 ad=0.1092 pd=1.36 as=0.06405 ps=0.725 w=0.42 l=0.15
X1738 sar9b_0.net23 a_10371_26490# VDPWR VDPWR sky130_fd_pr__pfet_01v8_hvt ad=0.26 pd=2.52 as=0.3012 ps=2.66 w=1 l=0.15
X1739 VGND sar9b_0.net11 a_13899_23252# VGND sky130_fd_pr__nfet_01v8 ad=0.0754 pd=0.81 as=0.1352 ps=1.56 w=0.52 l=0.15
X1740 VGND single_9b_cdac_1.cdac_sw_9b_0.cdac_sw_3_2.nooverlap_clk_0.x10.A single_9b_cdac_1.cdac_sw_9b_0.cdac_sw_3_2.tg_sw_3_3.SWN VGND sky130_fd_pr__nfet_01v8_lvt ad=0.1295 pd=1.09 as=0.1036 ps=1.02 w=0.74 l=0.15
X1741 VDPWR single_9b_cdac_0.cdac_sw_9b_0.cdac_sw_3_1.tg_sw_3_3.SWN single_9b_cdac_0.cdac_sw_9b_0.cdac_sw_3_1.tg_sw_3_3.SWP VDPWR sky130_fd_pr__pfet_01v8 ad=0.196 pd=1.47 as=0.168 ps=1.42 w=1.12 l=0.15
X1742 sar9b_0.net7 a_12211_18874# VDPWR VDPWR sky130_fd_pr__pfet_01v8_hvt ad=0.26 pd=2.52 as=0.3012 ps=2.66 w=1 l=0.15
X1743 VGND VDPWR VGND VGND sky130_fd_pr__nfet_01v8 ad=0.143 pd=1.62 as=0 ps=0 w=0.55 l=0.59
X1744 single_9b_cdac_1.cdac_sw_9b_0.cdac_sw_3_6.nooverlap_clk_0.x10.A single_9b_cdac_1.cdac_sw_9b_0.cdac_sw_3_6.nooverlap_clk_0.x8.A VDPWR VDPWR sky130_fd_pr__pfet_01v8 ad=0.168 pd=1.42 as=0.168 ps=1.42 w=1.12 l=0.15
X1745 single_9b_cdac_1.cdac_sw_9b_0.cdac_sw_3_4.nooverlap_clk_0.sky130_fd_sc_hs__inv_8_0.A single_9b_cdac_1.cdac_sw_9b_0.cdac_sw_3_4.nooverlap_clk_0.x1.A VGND VGND sky130_fd_pr__nfet_01v8_lvt ad=0.1036 pd=1.02 as=0.1221 ps=1.07 w=0.74 l=0.15
X1746 VGND VDPWR VGND VGND sky130_fd_pr__nfet_01v8 ad=0.143 pd=1.62 as=0 ps=0 w=0.55 l=0.59
X1747 th_dif_sw_0.VCN single_9b_cdac_0.cdac_sw_9b_0.S[0] sky130_fd_pr__cap_mim_m3_1 l=2 w=2
X1748 VGND single_9b_cdac_0.cdac_sw_9b_0.cdac_sw_3_3.tg_sw_3_3.SWN single_9b_cdac_0.cdac_sw_9b_0.cdac_sw_3_3.tg_sw_3_3.SWP VGND sky130_fd_pr__nfet_01v8_lvt ad=0.1036 pd=1.02 as=0.1036 ps=1.02 w=0.74 l=0.15
X1749 a_11689_23770# a_11471_24174# VGND VGND sky130_fd_pr__nfet_01v8 ad=0.0999 pd=0.985 as=0.1346 ps=1.15 w=0.64 l=0.15
X1750 VDPWR VGND VDPWR VDPWR sky130_fd_pr__pfet_01v8_hvt ad=0.2262 pd=2.26 as=0 ps=0 w=0.87 l=0.59
X1751 single_9b_cdac_0.cdac_sw_9b_0.cdac_sw_3_6.tg_sw_3_3.SWP single_9b_cdac_0.cdac_sw_9b_0.cdac_sw_3_6.tg_sw_3_3.SWN VGND VGND sky130_fd_pr__nfet_01v8_lvt ad=0.1036 pd=1.02 as=0.1295 ps=1.09 w=0.74 l=0.15
X1752 single_9b_cdac_0.cdac_sw_9b_0.cdac_sw_3_1.tg_sw_3_3.SWP single_9b_cdac_0.cdac_sw_9b_0.cdac_sw_3_1.tg_sw_3_3.SWN VDPWR VDPWR sky130_fd_pr__pfet_01v8 ad=0.168 pd=1.42 as=0.168 ps=1.42 w=1.12 l=0.15
X1753 VGND single_9b_cdac_0.cdac_sw_9b_0.cdac_sw_3_1.tg_sw_3_3.SWN single_9b_cdac_0.cdac_sw_9b_0.cdac_sw_3_1.tg_sw_3_3.SWP VGND sky130_fd_pr__nfet_01v8_lvt ad=0.1554 pd=1.16 as=0.1036 ps=1.02 w=0.74 l=0.15
X1754 VGND VDPWR VGND VGND sky130_fd_pr__nfet_01v8 ad=0.143 pd=1.62 as=0 ps=0 w=0.55 l=0.59
X1755 single_9b_cdac_1.cdac_sw_9b_0.S[4] single_9b_cdac_1.cdac_sw_9b_0.cdac_sw_3_3.tg_sw_3_3.SWP ua[0] VGND sky130_fd_pr__nfet_01v8 ad=0.145 pd=1.58 as=0.145 ps=1.58 w=0.5 l=0.5
X1756 single_9b_cdac_1.cdac_sw_9b_0.S[3] single_9b_cdac_1.cdac_sw_9b_0.cdac_sw_3_4.nooverlap_clk_0.CLKB0 a_48343_16877# VDPWR sky130_fd_pr__pfet_01v8 ad=0.435 pd=3.58 as=0.435 ps=3.58 w=1.5 l=0.5
X1757 single_9b_cdac_0.cdac_sw_9b_0.cdac_sw_3_4.nooverlap_clk_0.CLK0 single_9b_cdac_0.cdac_sw_9b_0.cdac_sw_3_4.nooverlap_clk_0.CLKB0 VGND VGND sky130_fd_pr__nfet_01v8_lvt ad=0.1036 pd=1.02 as=0.1554 ps=1.16 w=0.74 l=0.15
X1758 a_9622_25972# a_8545_25978# a_9460_26350# VDPWR sky130_fd_pr__pfet_01v8_hvt ad=0.0567 pd=0.69 as=0.0588 ps=0.7 w=0.42 l=0.15
X1759 a_9906_23252# sar9b_0.net15 VGND VGND sky130_fd_pr__nfet_01v8 ad=0.06405 pd=0.725 as=0.12495 ps=1.015 w=0.42 l=0.15
X1760 VDPWR single_9b_cdac_1.cdac_sw_9b_0.cdac_sw_3_6.nooverlap_clk_0.x8.A single_9b_cdac_1.cdac_sw_9b_0.cdac_sw_3_6.nooverlap_clk_0.x10.A VDPWR sky130_fd_pr__pfet_01v8 ad=0.168 pd=1.42 as=0.168 ps=1.42 w=1.12 l=0.15
X1761 VDPWR single_9b_cdac_1.CF[2] single_9b_cdac_0.cdac_sw_9b_0.cdac_sw_3_0.nooverlap_clk_0.sky130_fd_sc_hs__nand2_1_0.Y VDPWR sky130_fd_pr__pfet_01v8 ad=0.3192 pd=2.81 as=0.168 ps=1.42 w=1.12 l=0.15
X1762 VDPWR a_6884_25428# a_7059_25402# VDPWR sky130_fd_pr__pfet_01v8_hvt ad=0.1134 pd=1.38 as=0.0567 ps=0.69 w=0.42 l=0.15
X1763 a_9709_22164# a_9665_22406# a_9543_22164# VGND sky130_fd_pr__nfet_01v8 ad=0.0441 pd=0.63 as=0.1401 ps=1.1 w=0.42 l=0.15
X1764 single_9b_cdac_1.cdac_sw_9b_0.cdac_sw_3_4.nooverlap_clk_0.CLKB0 single_9b_cdac_1.cdac_sw_9b_0.cdac_sw_3_4.nooverlap_clk_0.sky130_fd_sc_hs__inv_8_0.A VGND VGND sky130_fd_pr__nfet_01v8_lvt ad=0.1036 pd=1.02 as=0.1295 ps=1.09 w=0.74 l=0.15
X1765 a_8543_27060# a_7919_27066# a_8435_27438# VDPWR sky130_fd_pr__pfet_01v8_hvt ad=0.1155 pd=0.97 as=0.07245 ps=0.765 w=0.42 l=0.15
X1766 single_9b_cdac_0.cdac_sw_9b_0.cdac_sw_3_3.nooverlap_clk_0.sky130_fd_sc_hs__inv_8_0.A single_9b_cdac_0.cdac_sw_9b_0.cdac_sw_3_3.nooverlap_clk_0.x1.A VDPWR VDPWR sky130_fd_pr__pfet_01v8 ad=0.168 pd=1.42 as=0.168 ps=1.42 w=1.12 l=0.15
X1767 VGND single_9b_cdac_0.SW[2] a_54032_26990# VGND sky130_fd_pr__nfet_01v8 ad=0.145 pd=1.58 as=0.145 ps=1.58 w=0.5 l=0.5
X1768 VDPWR single_9b_cdac_0.cdac_sw_9b_0.cdac_sw_3_1.tg_sw_3_3.SWN single_9b_cdac_0.cdac_sw_9b_0.cdac_sw_3_1.tg_sw_3_3.SWP VDPWR sky130_fd_pr__pfet_01v8 ad=0.168 pd=1.42 as=0.168 ps=1.42 w=1.12 l=0.15
X1769 VGND sar9b_0.net4 a_10679_25428# VGND sky130_fd_pr__nfet_01v8 ad=0.0567 pd=0.69 as=0.1092 ps=1.36 w=0.42 l=0.15
X1770 a_13621_24858# a_13403_25262# VGND VGND sky130_fd_pr__nfet_01v8 ad=0.0999 pd=0.985 as=0.1346 ps=1.15 w=0.64 l=0.15
X1771 VDPWR a_14143_23012# a_14130_22708# VDPWR sky130_fd_pr__pfet_01v8_hvt ad=0.0819 pd=0.81 as=0.0567 ps=0.69 w=0.42 l=0.15
X1772 a_13053_18900# a_12887_18900# VDPWR VDPWR sky130_fd_pr__pfet_01v8_hvt ad=0.1664 pd=1.8 as=0.0864 ps=0.91 w=0.64 l=0.15
X1773 single_9b_cdac_1.SW[1] a_14451_18356# VGND VGND sky130_fd_pr__nfet_01v8 ad=0.1352 pd=1.56 as=0.0754 ps=0.81 w=0.52 l=0.15
X1774 single_9b_cdac_1.cdac_sw_9b_0.cdac_sw_3_6.nooverlap_clk_0.x10.A single_9b_cdac_1.cdac_sw_9b_0.cdac_sw_3_6.nooverlap_clk_0.x8.A VDPWR VDPWR sky130_fd_pr__pfet_01v8 ad=0.168 pd=1.42 as=0.3304 ps=2.83 w=1.12 l=0.15
X1775 single_9b_cdac_1.cdac_sw_9b_0.S[1] single_9b_cdac_1.cdac_sw_9b_0.cdac_sw_3_1.tg_sw_3_3.SWP single_9b_cdac_1.cdac_sw_9b_0.S[1] VDPWR sky130_fd_pr__pfet_01v8 ad=0.435 pd=3.58 as=6.96 ps=57.28 w=1.5 l=0.5
X1776 a_8545_24340# a_8379_24340# VDPWR VDPWR sky130_fd_pr__pfet_01v8_hvt ad=0.1664 pd=1.8 as=0.0864 ps=0.91 w=0.64 l=0.15
X1777 single_9b_cdac_1.cdac_sw_9b_0.cdac_sw_3_7.nooverlap_clk_0.x8.A single_9b_cdac_1.cdac_sw_9b_0.cdac_sw_3_7.nooverlap_clk_0.x6.A VDPWR VDPWR sky130_fd_pr__pfet_01v8 ad=0.3304 pd=2.83 as=0.3864 ps=2.93 w=1.12 l=0.15
X1778 VGND single_9b_cdac_0.cdac_sw_9b_0.cdac_sw_3_7.nooverlap_clk_0.sky130_fd_sc_hs__inv_8_0.A single_9b_cdac_0.cdac_sw_9b_0.cdac_sw_3_7.nooverlap_clk_0.CLKB0 VGND sky130_fd_pr__nfet_01v8_lvt ad=0.1554 pd=1.16 as=0.1036 ps=1.02 w=0.74 l=0.15
X1779 single_9b_cdac_0.cdac_sw_9b_0.cdac_sw_3_0.nooverlap_clk_0.sky130_fd_sc_hs__nand2_1_0.Y single_9b_cdac_0.cdac_sw_9b_0.cdac_sw_3_0.nooverlap_clk_0.x8.A VDPWR VDPWR sky130_fd_pr__pfet_01v8 ad=0.168 pd=1.42 as=0.3192 ps=2.81 w=1.12 l=0.15
X1780 VGND sar9b_0.net4 a_10771_22164# VGND sky130_fd_pr__nfet_01v8 ad=0.0567 pd=0.69 as=0.1092 ps=1.36 w=0.42 l=0.15
X1781 th_dif_sw_0.VCN single_9b_cdac_0.cdac_sw_9b_0.S[1] sky130_fd_pr__cap_mim_m3_1 l=2 w=2
X1782 VGND single_9b_cdac_1.cdac_sw_9b_0.cdac_sw_3_1.nooverlap_clk_0.x8.A single_9b_cdac_1.cdac_sw_9b_0.cdac_sw_3_1.nooverlap_clk_0.x10.A VGND sky130_fd_pr__nfet_01v8_lvt ad=0.1221 pd=1.07 as=0.1184 ps=1.06 w=0.74 l=0.15
X1783 VDPWR single_9b_cdac_0.cdac_sw_9b_0.cdac_sw_3_3.nooverlap_clk_0.x1.A single_9b_cdac_0.cdac_sw_9b_0.cdac_sw_3_3.nooverlap_clk_0.sky130_fd_sc_hs__inv_8_0.A VDPWR sky130_fd_pr__pfet_01v8 ad=0.168 pd=1.42 as=0.168 ps=1.42 w=1.12 l=0.15
X1784 VGND VDPWR VGND VGND sky130_fd_pr__nfet_01v8 ad=0.143 pd=1.62 as=0 ps=0 w=0.55 l=0.59
X1785 single_9b_cdac_1.cdac_sw_9b_0.S[4] single_9b_cdac_1.cdac_sw_9b_0.cdac_sw_3_3.tg_sw_3_3.SWN ua[0] VDPWR sky130_fd_pr__pfet_01v8 ad=0.435 pd=3.58 as=0.435 ps=3.58 w=1.5 l=0.5
X1786 th_dif_sw_0.VCP single_9b_cdac_1.cdac_sw_9b_0.S[1] sky130_fd_pr__cap_mim_m3_1 l=2 w=2
X1787 single_9b_cdac_0.cdac_sw_9b_0.cdac_sw_3_6.nooverlap_clk_0.CLK0 single_9b_cdac_0.cdac_sw_9b_0.cdac_sw_3_6.nooverlap_clk_0.CLKB0 VDPWR VDPWR sky130_fd_pr__pfet_01v8 ad=0.168 pd=1.42 as=0.196 ps=1.47 w=1.12 l=0.15
X1788 a_38738_26999# single_9b_cdac_0.SW[5] VDPWR VDPWR sky130_fd_pr__pfet_01v8 ad=0.435 pd=3.58 as=0.435 ps=3.58 w=1.5 l=0.5
X1789 sar9b_0._02_ sar9b_0._10_ VGND VGND sky130_fd_pr__nfet_01v8 ad=0.08775 pd=0.92 as=0.169 ps=1.82 w=0.65 l=0.15
X1790 a_9988_19266# a_9774_19266# VDPWR VDPWR sky130_fd_pr__pfet_01v8_hvt ad=0.1155 pd=0.97 as=0.07035 ps=0.755 w=0.42 l=0.15
X1791 VGND single_9b_cdac_1.cdac_sw_9b_0.cdac_sw_3_3.nooverlap_clk_0.CLKB0 single_9b_cdac_1.cdac_sw_9b_0.cdac_sw_3_3.nooverlap_clk_0.CLK0 VGND sky130_fd_pr__nfet_01v8_lvt ad=0.1295 pd=1.09 as=0.1036 ps=1.02 w=0.74 l=0.15
X1792 single_9b_cdac_0.cdac_sw_9b_0.cdac_sw_3_3.nooverlap_clk_0.sky130_fd_sc_hs__inv_8_0.A single_9b_cdac_0.cdac_sw_9b_0.cdac_sw_3_3.nooverlap_clk_0.x1.A VDPWR VDPWR sky130_fd_pr__pfet_01v8 ad=0.168 pd=1.42 as=0.3304 ps=2.83 w=1.12 l=0.15
X1793 a_9003_24706# a_8379_24340# a_8895_24340# VDPWR sky130_fd_pr__pfet_01v8_hvt ad=0.1155 pd=0.97 as=0.07245 ps=0.765 w=0.42 l=0.15
X1794 th_dif_sw_0.VCP single_9b_cdac_1.cdac_sw_9b_0.S[1] sky130_fd_pr__cap_mim_m3_1 l=2 w=2
X1795 VDPWR single_9b_cdac_1.CF[1] single_9b_cdac_0.cdac_sw_9b_0.cdac_sw_3_1.nooverlap_clk_0.x3.Y VDPWR sky130_fd_pr__pfet_01v8 ad=0.3864 pd=2.93 as=0.3304 ps=2.83 w=1.12 l=0.15
X1796 a_59529_29917# single_9b_cdac_0.cdac_sw_9b_0.cdac_sw_3_1.nooverlap_clk_0.x1.A single_9b_cdac_0.cdac_sw_9b_0.cdac_sw_3_1.nooverlap_clk_0.x4.A VGND sky130_fd_pr__nfet_01v8_lvt ad=0.0888 pd=0.98 as=0.2109 ps=2.05 w=0.74 l=0.15
X1797 a_12772_26350# a_11691_25978# a_12425_25946# VDPWR sky130_fd_pr__pfet_01v8_hvt ad=0.0588 pd=0.7 as=0.12915 ps=1.185 w=0.42 l=0.15
X1798 a_11746_19810# sar9b_0.net15 VGND VGND sky130_fd_pr__nfet_01v8 ad=0.06405 pd=0.725 as=0.12495 ps=1.015 w=0.42 l=0.15
X1799 single_9b_cdac_1.cdac_sw_9b_0.cdac_sw_3_7.nooverlap_clk_0.sky130_fd_sc_hs__inv_8_0.A single_9b_cdac_1.cdac_sw_9b_0.cdac_sw_3_7.nooverlap_clk_0.x1.A VGND VGND sky130_fd_pr__nfet_01v8_lvt ad=0.1184 pd=1.06 as=0.2331 ps=2.11 w=0.74 l=0.15
X1800 th_dif_sw_0.VCN single_9b_cdac_0.cdac_sw_9b_0.S[0] sky130_fd_pr__cap_mim_m3_1 l=2 w=2
X1801 sar9b_0.clknet_1_1__leaf_CLK a_6149_23770# VGND VGND sky130_fd_pr__nfet_01v8 ad=0.0588 pd=0.7 as=0.05775 ps=0.695 w=0.42 l=0.15
X1802 VDPWR VGND VDPWR VDPWR sky130_fd_pr__pfet_01v8_hvt ad=0.2262 pd=2.26 as=0 ps=0 w=0.87 l=0.59
X1803 VGND single_9b_cdac_1.cdac_sw_9b_0.cdac_sw_3_7.nooverlap_clk_0.sky130_fd_sc_hs__inv_8_0.A single_9b_cdac_1.cdac_sw_9b_0.cdac_sw_3_7.nooverlap_clk_0.CLKB0 VGND sky130_fd_pr__nfet_01v8_lvt ad=0.1295 pd=1.09 as=0.1036 ps=1.02 w=0.74 l=0.15
X1804 VDPWR VGND VDPWR VDPWR sky130_fd_pr__pfet_01v8_hvt ad=0.2262 pd=2.26 as=0 ps=0 w=0.87 l=0.59
X1805 th_dif_sw_0.VCP single_9b_cdac_1.cdac_sw_9b_0.S[0] sky130_fd_pr__cap_mim_m3_1 l=2 w=2
X1806 VGND a_9727_23226# a_9661_23252# VGND sky130_fd_pr__nfet_01v8 ad=0.12495 pd=1.015 as=0.0669 ps=0.75 w=0.42 l=0.15
X1807 VDPWR VGND VDPWR VDPWR sky130_fd_pr__pfet_01v8_hvt ad=0.2262 pd=2.26 as=0 ps=0 w=0.87 l=0.59
X1808 single_9b_cdac_1.cdac_sw_9b_0.cdac_sw_3_1.tg_sw_3_3.SWN single_9b_cdac_1.cdac_sw_9b_0.cdac_sw_3_1.nooverlap_clk_0.x10.A VGND VGND sky130_fd_pr__nfet_01v8_lvt ad=0.1036 pd=1.02 as=0.1036 ps=1.02 w=0.74 l=0.15
X1809 th_dif_sw_0.VCN single_9b_cdac_0.cdac_sw_9b_0.S[0] sky130_fd_pr__cap_mim_m3_1 l=2 w=2
X1810 th_dif_sw_0.VCN single_9b_cdac_0.cdac_sw_9b_0.S[1] sky130_fd_pr__cap_mim_m3_1 l=2 w=2
X1811 VGND a_21177_7457# th_dif_sw_0.th_sw_1.CKB VGND sky130_fd_pr__nfet_01v8_lvt ad=0.1036 pd=1.02 as=0.1036 ps=1.02 w=0.74 l=0.15
X1812 VGND single_9b_cdac_0.SW[8] a_25210_26990# VGND sky130_fd_pr__nfet_01v8 ad=0.145 pd=1.58 as=0.145 ps=1.58 w=0.5 l=0.5
X1813 VGND a_6502_20124# a_6440_19988# VGND sky130_fd_pr__nfet_01v8 ad=0.1493 pd=1.22 as=0.0687 ps=0.76 w=0.42 l=0.15
X1814 single_9b_cdac_0.cdac_sw_9b_0.cdac_sw_3_8.tg_sw_3_3.SWN single_9b_cdac_0.cdac_sw_9b_0.cdac_sw_3_8.nooverlap_clk_0.x10.A VGND VGND sky130_fd_pr__nfet_01v8_lvt ad=0.1036 pd=1.02 as=0.1036 ps=1.02 w=0.74 l=0.15
X1815 single_9b_cdac_0.cdac_sw_9b_0.S[6] single_9b_cdac_0.cdac_sw_9b_0.cdac_sw_3_6.tg_sw_3_3.SWN single_9b_cdac_0.cdac_sw_9b_0.S[6] VGND sky130_fd_pr__nfet_01v8 ad=0.145 pd=1.58 as=2.32 ps=25.28 w=0.5 l=0.5
X1816 VGND single_9b_cdac_1.SW[7] a_30012_17740# VGND sky130_fd_pr__nfet_01v8 ad=0.145 pd=1.58 as=0.145 ps=1.58 w=0.5 l=0.5
X1817 single_9b_cdac_0.cdac_sw_9b_0.cdac_sw_3_2.tg_sw_3_3.SWN single_9b_cdac_0.cdac_sw_9b_0.cdac_sw_3_2.nooverlap_clk_0.x10.A VDPWR VDPWR sky130_fd_pr__pfet_01v8 ad=0.168 pd=1.42 as=0.196 ps=1.47 w=1.12 l=0.15
X1818 ua[0] single_9b_cdac_1.cdac_sw_9b_0.cdac_sw_3_5.tg_sw_3_3.SWP ua[0] VDPWR sky130_fd_pr__pfet_01v8 ad=0.435 pd=3.58 as=0 ps=0 w=1.5 l=0.5
X1819 VGND single_9b_cdac_1.cdac_sw_9b_0.cdac_sw_3_4.nooverlap_clk_0.x8.A single_9b_cdac_1.cdac_sw_9b_0.cdac_sw_3_4.nooverlap_clk_0.x10.A VGND sky130_fd_pr__nfet_01v8_lvt ad=0.2109 pd=2.05 as=0.1036 ps=1.02 w=0.74 l=0.15
X1820 VDPWR a_9113_25946# a_9003_25972# VDPWR sky130_fd_pr__pfet_01v8_hvt ad=0.07035 pd=0.755 as=0.1155 ps=0.97 w=0.42 l=0.15
X1821 VGND VDPWR VGND VGND sky130_fd_pr__nfet_01v8 ad=0.143 pd=1.62 as=0 ps=0 w=0.55 l=0.59
X1822 VGND VDPWR VGND VGND sky130_fd_pr__nfet_01v8 ad=0.143 pd=1.62 as=0 ps=0 w=0.55 l=0.59
X1823 dw_17224_1400# a_21368_4076# sky130_fd_pr__cap_mim_m3_1 l=2 w=2
X1824 th_dif_sw_0.VCN single_9b_cdac_0.cdac_sw_9b_0.S[0] sky130_fd_pr__cap_mim_m3_1 l=2 w=2
X1825 a_10550_26516# sar9b_0.net3 VGND VGND sky130_fd_pr__nfet_01v8 ad=0.06405 pd=0.725 as=0.12495 ps=1.015 w=0.42 l=0.15
X1826 th_dif_sw_0.VCP single_9b_cdac_1.cdac_sw_9b_0.S[1] sky130_fd_pr__cap_mim_m3_1 l=2 w=2
X1827 th_dif_sw_0.VCN single_9b_cdac_0.cdac_sw_9b_0.S[1] sky130_fd_pr__cap_mim_m3_1 l=2 w=2
X1828 VDPWR VGND VDPWR VDPWR sky130_fd_pr__pfet_01v8_hvt ad=0.2262 pd=2.26 as=0 ps=0 w=0.87 l=0.59
X1829 VGND sar9b_0.net15 a_14451_17812# VGND sky130_fd_pr__nfet_01v8 ad=0.0754 pd=0.81 as=0.1352 ps=1.56 w=0.52 l=0.15
X1830 VGND single_9b_cdac_1.cdac_sw_9b_0.cdac_sw_3_4.nooverlap_clk_0.x10.A single_9b_cdac_1.cdac_sw_9b_0.cdac_sw_3_4.tg_sw_3_3.SWN VGND sky130_fd_pr__nfet_01v8_lvt ad=0.1554 pd=1.16 as=0.1036 ps=1.02 w=0.74 l=0.15
X1831 VDPWR single_9b_cdac_1.cdac_sw_9b_0.cdac_sw_3_0.nooverlap_clk_0.x1.A single_9b_cdac_1.cdac_sw_9b_0.cdac_sw_3_0.nooverlap_clk_0.sky130_fd_sc_hs__inv_8_0.A VDPWR sky130_fd_pr__pfet_01v8 ad=0.3304 pd=2.83 as=0.168 ps=1.42 w=1.12 l=0.15
X1832 ua[0] single_9b_cdac_0.cdac_sw_9b_0.cdac_sw_3_8.tg_sw_3_3.SWP ua[0] VDPWR sky130_fd_pr__pfet_01v8 ad=0.435 pd=3.58 as=0 ps=0 w=1.5 l=0.5
X1833 VDPWR single_9b_cdac_0.cdac_sw_9b_0.cdac_sw_3_0.nooverlap_clk_0.CLKB0 single_9b_cdac_0.cdac_sw_9b_0.cdac_sw_3_0.nooverlap_clk_0.CLK0 VDPWR sky130_fd_pr__pfet_01v8 ad=0.196 pd=1.47 as=0.168 ps=1.42 w=1.12 l=0.15
X1834 th_dif_sw_0.VCP single_9b_cdac_1.cdac_sw_9b_0.S[1] sky130_fd_pr__cap_mim_m3_1 l=2 w=2
X1835 th_dif_sw_0.VCP single_9b_cdac_1.cdac_sw_9b_0.S[0] sky130_fd_pr__cap_mim_m3_1 l=2 w=2
X1836 VGND sar9b_0.net15 a_13573_24162# VGND sky130_fd_pr__nfet_01v8 ad=0.1346 pd=1.15 as=0.0441 ps=0.63 w=0.42 l=0.15
X1837 sar9b_0.clknet_1_0__leaf_CLK a_6701_20506# VDPWR VDPWR sky130_fd_pr__pfet_01v8_hvt ad=0.14 pd=1.28 as=0.265 ps=2.53 w=1 l=0.15
X1838 sar9b_0.clknet_1_0__leaf_CLK a_6701_20506# VDPWR VDPWR sky130_fd_pr__pfet_01v8_hvt ad=0.14 pd=1.28 as=0.14 ps=1.28 w=1 l=0.15
X1839 VGND a_5863_19662# a_5870_19566# VGND sky130_fd_pr__nfet_01v8 ad=0.0567 pd=0.69 as=0.1092 ps=1.36 w=0.42 l=0.15
X1840 VDPWR VGND VDPWR VDPWR sky130_fd_pr__pfet_01v8_hvt ad=0.2262 pd=2.26 as=0 ps=0 w=0.87 l=0.59
X1841 single_9b_cdac_1.cdac_sw_9b_0.cdac_sw_3_0.nooverlap_clk_0.sky130_fd_sc_hs__inv_8_0.A single_9b_cdac_1.cdac_sw_9b_0.cdac_sw_3_0.nooverlap_clk_0.x1.A VDPWR VDPWR sky130_fd_pr__pfet_01v8 ad=0.168 pd=1.42 as=0.168 ps=1.42 w=1.12 l=0.15
X1842 th_dif_sw_0.th_sw_1.CKB a_21177_7457# VDPWR VDPWR sky130_fd_pr__pfet_01v8 ad=0.168 pd=1.42 as=0.3304 ps=2.83 w=1.12 l=0.15
X1843 VGND single_9b_cdac_0.SW[5] a_39616_26990# VGND sky130_fd_pr__nfet_01v8 ad=0.145 pd=1.58 as=0.145 ps=1.58 w=0.5 l=0.5
X1844 VGND single_9b_cdac_0.cdac_sw_9b_0.cdac_sw_3_1.nooverlap_clk_0.CLKB0 single_9b_cdac_0.cdac_sw_9b_0.cdac_sw_3_1.nooverlap_clk_0.CLK0 VGND sky130_fd_pr__nfet_01v8_lvt ad=0.1295 pd=1.09 as=0.1036 ps=1.02 w=0.74 l=0.15
X1845 VDPWR VGND VDPWR VDPWR sky130_fd_pr__pfet_01v8_hvt ad=0.2262 pd=2.26 as=0 ps=0 w=0.87 l=0.59
X1846 VGND VDPWR VGND VGND sky130_fd_pr__nfet_01v8 ad=0.143 pd=1.62 as=0 ps=0 w=0.55 l=0.59
X1847 dw_17224_1400# a_21368_4076# sky130_fd_pr__cap_mim_m3_1 l=2 w=2
X1848 VGND a_9132_7271# th_dif_sw_0.th_sw_1.CK VGND sky130_fd_pr__nfet_01v8_lvt ad=0.1554 pd=1.16 as=0.1036 ps=1.02 w=0.74 l=0.15
X1849 a_6224_25428# sar9b_0.net37 VDPWR VDPWR sky130_fd_pr__pfet_01v8_hvt ad=0.0651 pd=0.73 as=0.1092 ps=1.36 w=0.42 l=0.15
X1850 VGND sar9b_0.net4 a_9115_21076# VGND sky130_fd_pr__nfet_01v8 ad=0.0567 pd=0.69 as=0.1092 ps=1.36 w=0.42 l=0.15
X1851 VDPWR VGND VDPWR VDPWR sky130_fd_pr__pfet_01v8_hvt ad=0.2262 pd=2.26 as=0 ps=0 w=0.87 l=0.59
X1852 ua[0] single_9b_cdac_1.cdac_sw_9b_0.cdac_sw_3_4.tg_sw_3_3.SWN ua[0] VGND sky130_fd_pr__nfet_01v8 ad=0.145 pd=1.58 as=0 ps=0 w=0.5 l=0.5
X1853 th_dif_sw_0.VCP single_9b_cdac_1.cdac_sw_9b_0.S[1] sky130_fd_pr__cap_mim_m3_1 l=2 w=2
X1854 th_dif_sw_0.VCP single_9b_cdac_1.cdac_sw_9b_0.S[4] sky130_fd_pr__cap_mim_m3_1 l=2 w=2
X1855 VDPWR sar9b_0.net32 a_13899_25972# VDPWR sky130_fd_pr__pfet_01v8_hvt ad=0.11455 pd=1.08 as=0.2054 ps=2.1 w=0.79 l=0.15
X1856 VGND VDPWR VGND VGND sky130_fd_pr__nfet_01v8 ad=0.143 pd=1.62 as=0 ps=0 w=0.55 l=0.59
X1857 VDPWR VGND VDPWR VDPWR sky130_fd_pr__pfet_01v8_hvt ad=0.2262 pd=2.26 as=0 ps=0 w=0.87 l=0.59
X1858 VDPWR single_9b_cdac_1.cdac_sw_9b_0.cdac_sw_3_0.nooverlap_clk_0.x1.A single_9b_cdac_1.cdac_sw_9b_0.cdac_sw_3_0.nooverlap_clk_0.sky130_fd_sc_hs__inv_8_0.A VDPWR sky130_fd_pr__pfet_01v8 ad=0.168 pd=1.42 as=0.168 ps=1.42 w=1.12 l=0.15
X1859 single_9b_cdac_0.cdac_sw_9b_0.cdac_sw_3_6.tg_sw_3_3.SWN single_9b_cdac_0.cdac_sw_9b_0.cdac_sw_3_6.nooverlap_clk_0.x10.A VGND VGND sky130_fd_pr__nfet_01v8_lvt ad=0.1036 pd=1.02 as=0.1554 ps=1.16 w=0.74 l=0.15
X1860 single_9b_cdac_0.cdac_sw_9b_0.cdac_sw_3_0.nooverlap_clk_0.sky130_fd_sc_hs__inv_8_0.A single_9b_cdac_0.cdac_sw_9b_0.cdac_sw_3_0.nooverlap_clk_0.x1.A VGND VGND sky130_fd_pr__nfet_01v8_lvt ad=0.1184 pd=1.06 as=0.1221 ps=1.07 w=0.74 l=0.15
X1861 VDPWR single_9b_cdac_0.cdac_sw_9b_0.cdac_sw_3_2.nooverlap_clk_0.CLKB0 single_9b_cdac_0.cdac_sw_9b_0.cdac_sw_3_2.nooverlap_clk_0.CLK0 VDPWR sky130_fd_pr__pfet_01v8 ad=0.3304 pd=2.83 as=0.168 ps=1.42 w=1.12 l=0.15
X1862 a_13053_24890# a_12887_24890# VDPWR VDPWR sky130_fd_pr__pfet_01v8_hvt ad=0.1664 pd=1.8 as=0.0864 ps=0.91 w=0.64 l=0.15
X1863 a_11376_18900# sar9b_0.net6 VDPWR VDPWR sky130_fd_pr__pfet_01v8_hvt ad=0.0651 pd=0.73 as=0.1092 ps=1.36 w=0.42 l=0.15
X1864 VGND single_9b_cdac_1.cdac_sw_9b_0.cdac_sw_3_2.nooverlap_clk_0.x10.A single_9b_cdac_1.cdac_sw_9b_0.cdac_sw_3_2.tg_sw_3_3.SWN VGND sky130_fd_pr__nfet_01v8_lvt ad=0.1036 pd=1.02 as=0.1036 ps=1.02 w=0.74 l=0.15
X1865 a_11689_26758# a_11471_26516# VGND VGND sky130_fd_pr__nfet_01v8 ad=0.0999 pd=0.985 as=0.1346 ps=1.15 w=0.64 l=0.15
X1866 th_dif_sw_0.VCP single_9b_cdac_1.cdac_sw_9b_0.S[1] sky130_fd_pr__cap_mim_m3_1 l=2 w=2
X1867 a_21177_7457# th_dif_sw_0.CKB VDPWR VDPWR sky130_fd_pr__pfet_01v8 ad=0.168 pd=1.42 as=0.168 ps=1.42 w=1.12 l=0.15
X1868 single_9b_cdac_0.cdac_sw_9b_0.cdac_sw_3_5.nooverlap_clk_0.CLK0 single_9b_cdac_0.cdac_sw_9b_0.cdac_sw_3_5.nooverlap_clk_0.CLKB0 VDPWR VDPWR sky130_fd_pr__pfet_01v8 ad=0.168 pd=1.42 as=0.196 ps=1.47 w=1.12 l=0.15
X1869 single_9b_cdac_1.cdac_sw_9b_0.cdac_sw_3_0.nooverlap_clk_0.sky130_fd_sc_hs__inv_8_0.A single_9b_cdac_1.cdac_sw_9b_0.cdac_sw_3_0.nooverlap_clk_0.x1.A VDPWR VDPWR sky130_fd_pr__pfet_01v8 ad=0.168 pd=1.42 as=0.3304 ps=2.83 w=1.12 l=0.15
X1870 VGND a_12487_20836# a_12421_20910# VGND sky130_fd_pr__nfet_01v8 ad=0.12495 pd=1.015 as=0.0669 ps=0.75 w=0.42 l=0.15
X1871 th_dif_sw_0.VCN single_9b_cdac_0.cdac_sw_9b_0.S[0] sky130_fd_pr__cap_mim_m3_1 l=2 w=2
X1872 single_9b_cdac_0.cdac_sw_9b_0.S[7] single_9b_cdac_0.cdac_sw_9b_0.cdac_sw_3_7.tg_sw_3_3.SWP single_9b_cdac_0.cdac_sw_9b_0.S[7] VDPWR sky130_fd_pr__pfet_01v8 ad=0.435 pd=3.58 as=6.96 ps=57.28 w=1.5 l=0.5
X1873 VDPWR single_9b_cdac_0.cdac_sw_9b_0.cdac_sw_3_0.nooverlap_clk_0.x10.A single_9b_cdac_0.cdac_sw_9b_0.cdac_sw_3_0.tg_sw_3_3.SWN VDPWR sky130_fd_pr__pfet_01v8 ad=0.3304 pd=2.83 as=0.168 ps=1.42 w=1.12 l=0.15
X1874 single_9b_cdac_0.cdac_sw_9b_0.cdac_sw_3_2.nooverlap_clk_0.CLK0 single_9b_cdac_0.cdac_sw_9b_0.cdac_sw_3_2.nooverlap_clk_0.CLKB0 VDPWR VDPWR sky130_fd_pr__pfet_01v8 ad=0.168 pd=1.42 as=0.196 ps=1.47 w=1.12 l=0.15
X1875 VDPWR VGND VDPWR VDPWR sky130_fd_pr__pfet_01v8_hvt ad=0.2262 pd=2.26 as=0 ps=0 w=0.87 l=0.59
X1876 VDPWR single_9b_cdac_0.cdac_sw_9b_0.cdac_sw_3_1.nooverlap_clk_0.x4.A single_9b_cdac_0.cdac_sw_9b_0.cdac_sw_3_1.nooverlap_clk_0.x6.A VDPWR sky130_fd_pr__pfet_01v8 ad=0.3864 pd=2.93 as=0.3304 ps=2.83 w=1.12 l=0.15
X1877 single_9b_cdac_1.SW[4] a_13623_20532# VGND VGND sky130_fd_pr__nfet_01v8 ad=0.1352 pd=1.56 as=0.0754 ps=0.81 w=0.52 l=0.15
X1878 single_9b_cdac_0.cdac_sw_9b_0.S[8] single_9b_cdac_0.cdac_sw_9b_0.cdac_sw_3_8.nooverlap_clk_0.CLKB0 a_24332_26999# VDPWR sky130_fd_pr__pfet_01v8 ad=0.435 pd=3.58 as=0.435 ps=3.58 w=1.5 l=0.5
X1879 a_6587_21852# a_6859_21710# a_6817_21736# VDPWR sky130_fd_pr__pfet_01v8_hvt ad=0.1092 pd=1.36 as=0.0441 ps=0.63 w=0.42 l=0.15
X1880 th_dif_sw_0.VCN single_9b_cdac_0.cdac_sw_9b_0.S[0] sky130_fd_pr__cap_mim_m3_1 l=2 w=2
X1881 a_12036_21076# a_11121_21076# a_11689_21318# VGND sky130_fd_pr__special_nfet_01v8 ad=0.0711 pd=0.755 as=0.0999 ps=0.985 w=0.36 l=0.15
X1882 th_dif_sw_0.VCN single_9b_cdac_0.cdac_sw_9b_0.S[0] sky130_fd_pr__cap_mim_m3_1 l=2 w=2
X1883 single_9b_cdac_0.cdac_sw_9b_0.cdac_sw_3_0.tg_sw_3_3.SWN single_9b_cdac_0.cdac_sw_9b_0.cdac_sw_3_0.nooverlap_clk_0.x10.A VDPWR VDPWR sky130_fd_pr__pfet_01v8 ad=0.168 pd=1.42 as=0.196 ps=1.47 w=1.12 l=0.15
X1884 a_21177_7457# th_dif_sw_0.CKB VGND VGND sky130_fd_pr__nfet_01v8_lvt ad=0.1036 pd=1.02 as=0.1036 ps=1.02 w=0.74 l=0.15
X1885 VGND sar9b_0.net4 a_10311_24890# VGND sky130_fd_pr__nfet_01v8 ad=0.0567 pd=0.69 as=0.1092 ps=1.36 w=0.42 l=0.15
X1886 VGND a_7059_21228# sar9b_0._09_ VGND sky130_fd_pr__nfet_01v8 ad=0.1118 pd=1.04 as=0.182 ps=1.86 w=0.65 l=0.15
X1887 sar9b_0.net18 a_6691_26490# VDPWR VDPWR sky130_fd_pr__pfet_01v8_hvt ad=0.26 pd=2.52 as=0.3012 ps=2.66 w=1 l=0.15
X1888 th_dif_sw_0.VCP single_9b_cdac_1.cdac_sw_9b_0.S[0] sky130_fd_pr__cap_mim_m3_1 l=2 w=2
X1889 a_25210_26990# single_9b_cdac_0.cdac_sw_9b_0.cdac_sw_3_8.nooverlap_clk_0.CLK0 single_9b_cdac_0.cdac_sw_9b_0.S[8] VGND sky130_fd_pr__nfet_01v8 ad=0.145 pd=1.58 as=0.145 ps=1.58 w=0.5 l=0.5
X1890 VDPWR VGND VDPWR VDPWR sky130_fd_pr__pfet_01v8_hvt ad=0.2262 pd=2.26 as=0 ps=0 w=0.87 l=0.59
X1891 VDPWR single_9b_cdac_1.cdac_sw_9b_0.cdac_sw_3_6.nooverlap_clk_0.x10.A single_9b_cdac_1.cdac_sw_9b_0.cdac_sw_3_6.tg_sw_3_3.SWN VDPWR sky130_fd_pr__pfet_01v8 ad=0.196 pd=1.47 as=0.168 ps=1.42 w=1.12 l=0.15
X1892 single_9b_cdac_0.cdac_sw_9b_0.cdac_sw_3_1.nooverlap_clk_0.sky130_fd_sc_hs__inv_8_0.A single_9b_cdac_0.cdac_sw_9b_0.cdac_sw_3_1.nooverlap_clk_0.x1.A VDPWR VDPWR sky130_fd_pr__pfet_01v8 ad=0.168 pd=1.42 as=0.168 ps=1.42 w=1.12 l=0.15
X1893 ua[0] single_9b_cdac_1.cdac_sw_9b_0.cdac_sw_3_3.tg_sw_3_3.SWP ua[0] VDPWR sky130_fd_pr__pfet_01v8 ad=0.435 pd=3.58 as=0 ps=0 w=1.5 l=0.5
X1894 th_dif_sw_0.VCN single_9b_cdac_0.cdac_sw_9b_0.S[6] sky130_fd_pr__cap_mim_m3_1 l=2 w=2
X1895 VGND a_6701_20506# sar9b_0.clknet_1_0__leaf_CLK VGND sky130_fd_pr__nfet_01v8 ad=0.0588 pd=0.7 as=0.0588 ps=0.7 w=0.42 l=0.15
X1896 VDPWR single_9b_cdac_1.cdac_sw_9b_0.cdac_sw_3_6.nooverlap_clk_0.sky130_fd_sc_hs__inv_8_0.A single_9b_cdac_1.cdac_sw_9b_0.cdac_sw_3_6.nooverlap_clk_0.CLKB0 VDPWR sky130_fd_pr__pfet_01v8 ad=0.196 pd=1.47 as=0.168 ps=1.42 w=1.12 l=0.15
X1897 VGND single_9b_cdac_1.SW[3] a_49221_17740# VGND sky130_fd_pr__nfet_01v8 ad=0.145 pd=1.58 as=0.145 ps=1.58 w=0.5 l=0.5
X1898 th_dif_sw_0.VCP single_9b_cdac_1.cdac_sw_9b_0.S[0] sky130_fd_pr__cap_mim_m3_1 l=2 w=2
X1899 VDPWR single_9b_cdac_0.cdac_sw_9b_0.cdac_sw_3_1.nooverlap_clk_0.x1.A single_9b_cdac_0.cdac_sw_9b_0.cdac_sw_3_1.nooverlap_clk_0.sky130_fd_sc_hs__inv_8_0.A VDPWR sky130_fd_pr__pfet_01v8 ad=0.168 pd=1.42 as=0.168 ps=1.42 w=1.12 l=0.15
X1900 single_9b_cdac_1.cdac_sw_9b_0.S[2] single_9b_cdac_1.cdac_sw_9b_0.cdac_sw_3_0.tg_sw_3_3.SWN ua[0] VDPWR sky130_fd_pr__pfet_01v8 ad=0.435 pd=3.58 as=0.435 ps=3.58 w=1.5 l=0.5
X1901 VDPWR single_9b_cdac_1.cdac_sw_9b_0.cdac_sw_3_8.tg_sw_3_3.SWN single_9b_cdac_1.cdac_sw_9b_0.cdac_sw_3_8.tg_sw_3_3.SWP VDPWR sky130_fd_pr__pfet_01v8 ad=0.3864 pd=2.93 as=0.168 ps=1.42 w=1.12 l=0.15
X1902 th_dif_sw_0.VCP single_9b_cdac_1.cdac_sw_9b_0.S[0] sky130_fd_pr__cap_mim_m3_1 l=2 w=2
X1903 single_9b_cdac_1.cdac_sw_9b_0.cdac_sw_3_0.nooverlap_clk_0.x3.Y single_9b_cdac_1.CF[2] VGND VGND sky130_fd_pr__nfet_01v8_lvt ad=0.2109 pd=2.05 as=0.2627 ps=2.19 w=0.74 l=0.15
X1904 single_9b_cdac_1.cdac_sw_9b_0.cdac_sw_3_6.nooverlap_clk_0.CLKB0 single_9b_cdac_1.cdac_sw_9b_0.cdac_sw_3_6.nooverlap_clk_0.sky130_fd_sc_hs__inv_8_0.A VDPWR VDPWR sky130_fd_pr__pfet_01v8 ad=0.168 pd=1.42 as=0.168 ps=1.42 w=1.12 l=0.15
X1905 th_dif_sw_0.VCN single_9b_cdac_0.cdac_sw_9b_0.S[0] sky130_fd_pr__cap_mim_m3_1 l=2 w=2
X1906 single_9b_cdac_0.cdac_sw_9b_0.cdac_sw_3_1.tg_sw_3_3.SWP single_9b_cdac_0.cdac_sw_9b_0.cdac_sw_3_1.tg_sw_3_3.SWN VDPWR VDPWR sky130_fd_pr__pfet_01v8 ad=0.168 pd=1.42 as=0.3864 ps=2.93 w=1.12 l=0.15
X1907 VDPWR a_12425_25946# a_12315_25972# VDPWR sky130_fd_pr__pfet_01v8_hvt ad=0.07035 pd=0.755 as=0.1155 ps=0.97 w=0.42 l=0.15
X1908 a_14322_23074# sar9b_0.net15 VGND VGND sky130_fd_pr__nfet_01v8 ad=0.06405 pd=0.725 as=0.12495 ps=1.015 w=0.42 l=0.15
X1909 single_9b_cdac_1.SW[7] a_14451_20532# VDPWR VDPWR sky130_fd_pr__pfet_01v8_hvt ad=0.2054 pd=2.1 as=0.11455 ps=1.08 w=0.79 l=0.15
X1910 VGND single_9b_cdac_1.cdac_sw_9b_0.cdac_sw_3_7.nooverlap_clk_0.sky130_fd_sc_hs__inv_8_0.A single_9b_cdac_1.cdac_sw_9b_0.cdac_sw_3_7.nooverlap_clk_0.CLKB0 VGND sky130_fd_pr__nfet_01v8_lvt ad=0.1036 pd=1.02 as=0.1036 ps=1.02 w=0.74 l=0.15
X1911 th_dif_sw_0.VCN single_9b_cdac_0.cdac_sw_9b_0.S[2] sky130_fd_pr__cap_mim_m3_1 l=2 w=2
X1912 VGND single_9b_cdac_1.cdac_sw_9b_0.cdac_sw_3_2.nooverlap_clk_0.CLKB0 single_9b_cdac_1.cdac_sw_9b_0.cdac_sw_3_2.nooverlap_clk_0.CLK0 VGND sky130_fd_pr__nfet_01v8_lvt ad=0.2146 pd=2.06 as=0.1036 ps=1.02 w=0.74 l=0.15
X1913 single_9b_cdac_0.cdac_sw_9b_0.cdac_sw_3_1.nooverlap_clk_0.sky130_fd_sc_hs__inv_8_0.A single_9b_cdac_0.cdac_sw_9b_0.cdac_sw_3_1.nooverlap_clk_0.x1.A VDPWR VDPWR sky130_fd_pr__pfet_01v8 ad=0.168 pd=1.42 as=0.3304 ps=2.83 w=1.12 l=0.15
X1914 sar9b_0.clk_div_0.COUNT\[1\] a_8951_23770# VDPWR VDPWR sky130_fd_pr__pfet_01v8_hvt ad=0.26 pd=2.52 as=0.135 ps=1.27 w=1 l=0.15
X1915 single_9b_cdac_1.cdac_sw_9b_0.cdac_sw_3_8.tg_sw_3_3.SWP single_9b_cdac_1.cdac_sw_9b_0.cdac_sw_3_8.tg_sw_3_3.SWN VDPWR VDPWR sky130_fd_pr__pfet_01v8 ad=0.168 pd=1.42 as=0.196 ps=1.47 w=1.12 l=0.15
X1916 VGND single_9b_cdac_1.cdac_sw_9b_0.cdac_sw_3_4.nooverlap_clk_0.sky130_fd_sc_hs__inv_8_0.A single_9b_cdac_1.cdac_sw_9b_0.cdac_sw_3_4.nooverlap_clk_0.CLKB0 VGND sky130_fd_pr__nfet_01v8_lvt ad=0.2146 pd=2.06 as=0.1036 ps=1.02 w=0.74 l=0.15
X1917 th_dif_sw_0.VCP single_9b_cdac_1.cdac_sw_9b_0.S[0] sky130_fd_pr__cap_mim_m3_1 l=2 w=2
X1918 VDPWR single_9b_cdac_0.cdac_sw_9b_0.cdac_sw_3_8.nooverlap_clk_0.sky130_fd_sc_hs__inv_8_0.A single_9b_cdac_0.cdac_sw_9b_0.cdac_sw_3_8.nooverlap_clk_0.CLKB0 VDPWR sky130_fd_pr__pfet_01v8 ad=0.196 pd=1.47 as=0.168 ps=1.42 w=1.12 l=0.15
X1919 VDPWR single_9b_cdac_1.cdac_sw_9b_0.cdac_sw_3_6.nooverlap_clk_0.sky130_fd_sc_hs__inv_8_0.A single_9b_cdac_1.cdac_sw_9b_0.cdac_sw_3_6.nooverlap_clk_0.CLKB0 VDPWR sky130_fd_pr__pfet_01v8 ad=0.168 pd=1.42 as=0.168 ps=1.42 w=1.12 l=0.15
X1920 single_9b_cdac_1.cdac_sw_9b_0.S[5] single_9b_cdac_1.cdac_sw_9b_0.cdac_sw_3_5.tg_sw_3_3.SWP ua[0] VGND sky130_fd_pr__nfet_01v8 ad=0.145 pd=1.58 as=0.145 ps=1.58 w=0.5 l=0.5
X1921 single_9b_cdac_0.cdac_sw_9b_0.cdac_sw_3_8.tg_sw_3_3.SWN single_9b_cdac_0.cdac_sw_9b_0.cdac_sw_3_8.nooverlap_clk_0.x10.A VGND VGND sky130_fd_pr__nfet_01v8_lvt ad=0.1036 pd=1.02 as=0.1295 ps=1.09 w=0.74 l=0.15
X1922 single_9b_cdac_0.cdac_sw_9b_0.cdac_sw_3_3.nooverlap_clk_0.sky130_fd_sc_hs__inv_8_0.A single_9b_cdac_0.cdac_sw_9b_0.cdac_sw_3_3.nooverlap_clk_0.x1.A VGND VGND sky130_fd_pr__nfet_01v8_lvt ad=0.1184 pd=1.06 as=0.1221 ps=1.07 w=0.74 l=0.15
X1923 single_9b_cdac_0.cdac_sw_9b_0.cdac_sw_3_8.nooverlap_clk_0.CLKB0 single_9b_cdac_0.cdac_sw_9b_0.cdac_sw_3_8.nooverlap_clk_0.sky130_fd_sc_hs__inv_8_0.A VDPWR VDPWR sky130_fd_pr__pfet_01v8 ad=0.168 pd=1.42 as=0.168 ps=1.42 w=1.12 l=0.15
X1924 VGND single_9b_cdac_1.SW[5] a_39616_17740# VGND sky130_fd_pr__nfet_01v8 ad=0.145 pd=1.58 as=0.145 ps=1.58 w=0.5 l=0.5
X1925 sar9b_0.clknet_0_CLK a_7345_21594# VDPWR VDPWR sky130_fd_pr__pfet_01v8_hvt ad=0.14 pd=1.28 as=0.14 ps=1.28 w=1 l=0.15
X1926 single_9b_cdac_1.cdac_sw_9b_0.cdac_sw_3_6.nooverlap_clk_0.CLKB0 single_9b_cdac_1.cdac_sw_9b_0.cdac_sw_3_6.nooverlap_clk_0.sky130_fd_sc_hs__inv_8_0.A VDPWR VDPWR sky130_fd_pr__pfet_01v8 ad=0.168 pd=1.42 as=0.196 ps=1.47 w=1.12 l=0.15
X1927 th_dif_sw_0.VCN single_9b_cdac_0.cdac_sw_9b_0.S[0] sky130_fd_pr__cap_mim_m3_1 l=2 w=2
X1928 single_9b_cdac_0.cdac_sw_9b_0.cdac_sw_3_5.tg_sw_3_3.SWN single_9b_cdac_0.cdac_sw_9b_0.cdac_sw_3_5.nooverlap_clk_0.x10.A VGND VGND sky130_fd_pr__nfet_01v8_lvt ad=0.1036 pd=1.02 as=0.1036 ps=1.02 w=0.74 l=0.15
X1929 VGND single_9b_cdac_0.cdac_sw_9b_0.cdac_sw_3_5.nooverlap_clk_0.CLKB0 single_9b_cdac_0.cdac_sw_9b_0.cdac_sw_3_5.nooverlap_clk_0.CLK0 VGND sky130_fd_pr__nfet_01v8_lvt ad=0.1554 pd=1.16 as=0.1036 ps=1.02 w=0.74 l=0.15
X1930 a_7817_21076# sar9b_0._09_ a_7735_21076# VGND sky130_fd_pr__nfet_01v8 ad=0.0441 pd=0.63 as=0.1092 ps=1.36 w=0.42 l=0.15
X1931 VGND single_9b_cdac_1.cdac_sw_9b_0.cdac_sw_3_0.nooverlap_clk_0.CLKB0 single_9b_cdac_1.cdac_sw_9b_0.cdac_sw_3_0.nooverlap_clk_0.CLK0 VGND sky130_fd_pr__nfet_01v8_lvt ad=0.1554 pd=1.16 as=0.1036 ps=1.02 w=0.74 l=0.15
X1932 a_12211_26490# a_12036_26516# a_12390_26516# VGND sky130_fd_pr__nfet_01v8 ad=0.1092 pd=1.36 as=0.06405 ps=0.725 w=0.42 l=0.15
X1933 VDPWR single_9b_cdac_0.cdac_sw_9b_0.cdac_sw_3_8.nooverlap_clk_0.sky130_fd_sc_hs__inv_8_0.A single_9b_cdac_0.cdac_sw_9b_0.cdac_sw_3_8.nooverlap_clk_0.CLKB0 VDPWR sky130_fd_pr__pfet_01v8 ad=0.168 pd=1.42 as=0.168 ps=1.42 w=1.12 l=0.15
X1934 VGND single_9b_cdac_1.cdac_sw_9b_0.cdac_sw_3_8.tg_sw_3_3.SWN single_9b_cdac_1.cdac_sw_9b_0.cdac_sw_3_8.tg_sw_3_3.SWP VGND sky130_fd_pr__nfet_01v8_lvt ad=0.1036 pd=1.02 as=0.1036 ps=1.02 w=0.74 l=0.15
X1935 th_dif_sw_0.VCP single_9b_cdac_1.cdac_sw_9b_0.S[0] sky130_fd_pr__cap_mim_m3_1 l=2 w=2
X1936 th_dif_sw_0.VCN single_9b_cdac_0.cdac_sw_9b_0.S[2] sky130_fd_pr__cap_mim_m3_1 l=2 w=2
X1937 th_dif_sw_0.th_sw_1.CKB a_21177_7457# VGND VGND sky130_fd_pr__nfet_01v8_lvt ad=0.1036 pd=1.02 as=0.1036 ps=1.02 w=0.74 l=0.15
X1938 th_dif_sw_0.th_sw_1.CK a_9132_7271# VDPWR VDPWR sky130_fd_pr__pfet_01v8 ad=0.168 pd=1.42 as=0.168 ps=1.42 w=1.12 l=0.15
X1939 VGND single_9b_cdac_0.cdac_sw_9b_0.cdac_sw_3_2.nooverlap_clk_0.sky130_fd_sc_hs__nand2_1_0.Y single_9b_cdac_0.cdac_sw_9b_0.cdac_sw_3_2.nooverlap_clk_0.sky130_fd_sc_hs__inv_1_1.A VGND sky130_fd_pr__nfet_01v8_lvt ad=0.2627 pd=2.19 as=0.2109 ps=2.05 w=0.74 l=0.15
X1940 single_9b_cdac_1.cdac_sw_9b_0.S[7] single_9b_cdac_1.cdac_sw_9b_0.cdac_sw_3_7.tg_sw_3_3.SWP single_9b_cdac_1.cdac_sw_9b_0.S[7] VDPWR sky130_fd_pr__pfet_01v8 ad=0.435 pd=3.58 as=6.96 ps=57.28 w=1.5 l=0.5
X1941 single_9b_cdac_1.cdac_sw_9b_0.cdac_sw_3_0.tg_sw_3_3.SWN single_9b_cdac_1.cdac_sw_9b_0.cdac_sw_3_0.nooverlap_clk_0.x10.A VDPWR VDPWR sky130_fd_pr__pfet_01v8 ad=0.168 pd=1.42 as=0.3304 ps=2.83 w=1.12 l=0.15
X1942 dw_17224_1400# a_21368_4076# sky130_fd_pr__cap_mim_m3_1 l=2 w=2
X1943 th_dif_sw_0.VCP single_9b_cdac_1.cdac_sw_9b_0.S[0] sky130_fd_pr__cap_mim_m3_1 l=2 w=2
X1944 VDPWR single_9b_cdac_0.cdac_sw_9b_0.cdac_sw_3_7.tg_sw_3_3.SWN single_9b_cdac_0.cdac_sw_9b_0.cdac_sw_3_7.tg_sw_3_3.SWP VDPWR sky130_fd_pr__pfet_01v8 ad=0.3304 pd=2.83 as=0.168 ps=1.42 w=1.12 l=0.15
X1945 a_5821_19444# a_5483_19676# VDPWR VDPWR sky130_fd_pr__pfet_01v8_hvt ad=0.0882 pd=0.84 as=0.1113 ps=1.37 w=0.42 l=0.15
X1946 th_dif_sw_0.VCP single_9b_cdac_1.cdac_sw_9b_0.S[3] sky130_fd_pr__cap_mim_m3_1 l=2 w=2
X1947 VGND a_14143_23012# a_14077_23086# VGND sky130_fd_pr__nfet_01v8 ad=0.12495 pd=1.015 as=0.0669 ps=0.75 w=0.42 l=0.15
X1948 a_11843_20910# a_11397_20538# a_11747_20910# VGND sky130_fd_pr__special_nfet_01v8 ad=0.1401 pd=1.1 as=0.0594 ps=0.69 w=0.36 l=0.15
X1949 VDPWR a_6759_20354# a_6930_20241# VDPWR sky130_fd_pr__pfet_01v8_hvt ad=0.1625 pd=1.325 as=0.28 ps=2.56 w=1 l=0.15
X1950 VGND single_9b_cdac_1.cdac_sw_9b_0.cdac_sw_3_5.nooverlap_clk_0.x1.A single_9b_cdac_1.cdac_sw_9b_0.cdac_sw_3_5.nooverlap_clk_0.sky130_fd_sc_hs__inv_8_0.A VGND sky130_fd_pr__nfet_01v8_lvt ad=0.1221 pd=1.07 as=0.1184 ps=1.06 w=0.74 l=0.15
X1951 th_dif_sw_0.VCN single_9b_cdac_0.cdac_sw_9b_0.S[0] sky130_fd_pr__cap_mim_m3_1 l=2 w=2
X1952 single_9b_cdac_1.cdac_sw_9b_0.cdac_sw_3_2.nooverlap_clk_0.x1.A single_9b_cdac_1.cdac_sw_9b_0.cdac_sw_3_2.nooverlap_clk_0.sky130_fd_sc_hs__inv_1_1.A VGND VGND sky130_fd_pr__nfet_01v8_lvt ad=0.2109 pd=2.05 as=0.2627 ps=2.19 w=0.74 l=0.15
X1953 sar9b_0.clknet_1_0__leaf_CLK a_6701_20506# VGND VGND sky130_fd_pr__nfet_01v8 ad=0.0588 pd=0.7 as=0.0588 ps=0.7 w=0.42 l=0.15
X1954 dw_17224_1400# a_21368_4076# sky130_fd_pr__cap_mim_m3_1 l=2 w=2
X1955 th_dif_sw_0.VCP single_9b_cdac_1.cdac_sw_9b_0.S[0] sky130_fd_pr__cap_mim_m3_1 l=2 w=2
X1956 single_9b_cdac_0.cdac_sw_9b_0.cdac_sw_3_7.tg_sw_3_3.SWP single_9b_cdac_0.cdac_sw_9b_0.cdac_sw_3_7.tg_sw_3_3.SWN VDPWR VDPWR sky130_fd_pr__pfet_01v8 ad=0.168 pd=1.42 as=0.196 ps=1.47 w=1.12 l=0.15
X1957 VGND single_9b_cdac_0.cdac_sw_9b_0.cdac_sw_3_2.tg_sw_3_3.SWN single_9b_cdac_0.cdac_sw_9b_0.cdac_sw_3_2.tg_sw_3_3.SWP VGND sky130_fd_pr__nfet_01v8_lvt ad=0.1295 pd=1.09 as=0.1036 ps=1.02 w=0.74 l=0.15
X1958 single_9b_cdac_0.cdac_sw_9b_0.S[0] single_9b_cdac_0.cdac_sw_9b_0.cdac_sw_3_2.tg_sw_3_3.SWP single_9b_cdac_0.cdac_sw_9b_0.S[0] VDPWR sky130_fd_pr__pfet_01v8 ad=0.435 pd=3.58 as=0 ps=0 w=1.5 l=0.5
X1959 ua[0] single_9b_cdac_1.cdac_sw_9b_0.cdac_sw_3_7.tg_sw_3_3.SWP ua[0] VDPWR sky130_fd_pr__pfet_01v8 ad=0.435 pd=3.58 as=0 ps=0 w=1.5 l=0.5
X1960 single_9b_cdac_1.cdac_sw_9b_0.S[5] single_9b_cdac_1.cdac_sw_9b_0.cdac_sw_3_5.nooverlap_clk_0.CLKB0 a_38738_16877# VDPWR sky130_fd_pr__pfet_01v8 ad=0.435 pd=3.58 as=0.435 ps=3.58 w=1.5 l=0.5
X1961 th_dif_sw_0.VCP single_9b_cdac_1.cdac_sw_9b_0.S[0] sky130_fd_pr__cap_mim_m3_1 l=2 w=2
X1962 th_dif_sw_0.VCP single_9b_cdac_1.cdac_sw_9b_0.S[0] sky130_fd_pr__cap_mim_m3_1 l=2 w=2
X1963 th_dif_sw_0.VCP single_9b_cdac_1.cdac_sw_9b_0.S[0] sky130_fd_pr__cap_mim_m3_1 l=2 w=2
X1964 VDPWR VGND VDPWR VDPWR sky130_fd_pr__pfet_01v8_hvt ad=0.2262 pd=2.26 as=0 ps=0 w=0.87 l=0.59
X1965 VGND sar9b_0.net15 a_13665_21076# VGND sky130_fd_pr__nfet_01v8 ad=0.1346 pd=1.15 as=0.0441 ps=0.63 w=0.42 l=0.15
X1966 th_dif_sw_0.VCN single_9b_cdac_0.cdac_sw_9b_0.S[4] sky130_fd_pr__cap_mim_m3_1 l=2 w=2
X1967 th_dif_sw_0.VCN single_9b_cdac_0.cdac_sw_9b_0.S[2] sky130_fd_pr__cap_mim_m3_1 l=2 w=2
X1968 single_9b_cdac_0.cdac_sw_9b_0.S[8] single_9b_cdac_0.cdac_sw_9b_0.cdac_sw_3_8.tg_sw_3_3.SWP ua[0] VGND sky130_fd_pr__nfet_01v8 ad=0.145 pd=1.58 as=0.145 ps=1.58 w=0.5 l=0.5
X1969 VDPWR a_6169_26758# a_6059_26882# VDPWR sky130_fd_pr__pfet_01v8_hvt ad=0.07035 pd=0.755 as=0.1155 ps=0.97 w=0.42 l=0.15
X1970 a_12198_21442# a_11121_21076# a_12036_21076# VDPWR sky130_fd_pr__pfet_01v8_hvt ad=0.0567 pd=0.69 as=0.0588 ps=0.7 w=0.42 l=0.15
X1971 VDPWR single_9b_cdac_1.cdac_sw_9b_0.cdac_sw_3_5.nooverlap_clk_0.sky130_fd_sc_hs__inv_8_0.A single_9b_cdac_1.cdac_sw_9b_0.cdac_sw_3_5.nooverlap_clk_0.CLKB0 VDPWR sky130_fd_pr__pfet_01v8 ad=0.196 pd=1.47 as=0.168 ps=1.42 w=1.12 l=0.15
X1972 th_dif_sw_0.VCN single_9b_cdac_0.cdac_sw_9b_0.S[0] sky130_fd_pr__cap_mim_m3_1 l=2 w=2
X1973 single_9b_cdac_1.cdac_sw_9b_0.S[0] single_9b_cdac_1.cdac_sw_9b_0.cdac_sw_3_2.tg_sw_3_3.SWN single_9b_cdac_1.cdac_sw_9b_0.S[0] VGND sky130_fd_pr__nfet_01v8 ad=0.145 pd=1.58 as=2.32 ps=25.28 w=0.5 l=0.5
X1974 VDPWR a_7795_26276# a_7782_25972# VDPWR sky130_fd_pr__pfet_01v8_hvt ad=0.0819 pd=0.81 as=0.0567 ps=0.69 w=0.42 l=0.15
X1975 VDPWR single_9b_cdac_1.cdac_sw_9b_0.cdac_sw_3_0.nooverlap_clk_0.sky130_fd_sc_hs__inv_8_0.A single_9b_cdac_1.cdac_sw_9b_0.cdac_sw_3_0.nooverlap_clk_0.CLKB0 VDPWR sky130_fd_pr__pfet_01v8 ad=0.196 pd=1.47 as=0.168 ps=1.42 w=1.12 l=0.15
X1976 th_dif_sw_0.VCP single_9b_cdac_1.cdac_sw_9b_0.S[2] sky130_fd_pr__cap_mim_m3_1 l=2 w=2
X1977 VDPWR a_21177_7457# th_dif_sw_0.th_sw_1.CKB VDPWR sky130_fd_pr__pfet_01v8 ad=0.168 pd=1.42 as=0.168 ps=1.42 w=1.12 l=0.15
X1978 single_9b_cdac_1.cdac_sw_9b_0.cdac_sw_3_7.tg_sw_3_3.SWP single_9b_cdac_1.cdac_sw_9b_0.cdac_sw_3_7.tg_sw_3_3.SWN VGND VGND sky130_fd_pr__nfet_01v8_lvt ad=0.1036 pd=1.02 as=0.1554 ps=1.16 w=0.74 l=0.15
X1979 single_9b_cdac_1.cdac_sw_9b_0.cdac_sw_3_5.nooverlap_clk_0.CLKB0 single_9b_cdac_1.cdac_sw_9b_0.cdac_sw_3_5.nooverlap_clk_0.sky130_fd_sc_hs__inv_8_0.A VGND VGND sky130_fd_pr__nfet_01v8_lvt ad=0.1036 pd=1.02 as=0.1036 ps=1.02 w=0.74 l=0.15
X1980 th_dif_sw_0.VCN single_9b_cdac_0.cdac_sw_9b_0.S[1] sky130_fd_pr__cap_mim_m3_1 l=2 w=2
X1981 single_9b_cdac_0.cdac_sw_9b_0.cdac_sw_3_4.nooverlap_clk_0.CLK0 single_9b_cdac_0.cdac_sw_9b_0.cdac_sw_3_4.nooverlap_clk_0.CLKB0 VGND VGND sky130_fd_pr__nfet_01v8_lvt ad=0.1036 pd=1.02 as=0.1295 ps=1.09 w=0.74 l=0.15
X1982 ua[0] single_9b_cdac_0.cdac_sw_9b_0.cdac_sw_3_8.tg_sw_3_3.SWP ua[0] VDPWR sky130_fd_pr__pfet_01v8 ad=0.435 pd=3.58 as=0 ps=0 w=1.5 l=0.5
X1983 single_9b_cdac_0.cdac_sw_9b_0.cdac_sw_3_6.tg_sw_3_3.SWN single_9b_cdac_0.cdac_sw_9b_0.cdac_sw_3_6.nooverlap_clk_0.x10.A VDPWR VDPWR sky130_fd_pr__pfet_01v8 ad=0.168 pd=1.42 as=0.196 ps=1.47 w=1.12 l=0.15
X1984 single_9b_cdac_1.cdac_sw_9b_0.cdac_sw_3_5.nooverlap_clk_0.CLKB0 single_9b_cdac_1.cdac_sw_9b_0.cdac_sw_3_5.nooverlap_clk_0.sky130_fd_sc_hs__inv_8_0.A VDPWR VDPWR sky130_fd_pr__pfet_01v8 ad=0.168 pd=1.42 as=0.168 ps=1.42 w=1.12 l=0.15
X1985 VGND th_dif_sw_0.CK a_9132_7271# VGND sky130_fd_pr__nfet_01v8_lvt ad=0.1036 pd=1.02 as=0.1036 ps=1.02 w=0.74 l=0.15
X1986 a_10477_24890# a_10311_24890# VDPWR VDPWR sky130_fd_pr__pfet_01v8_hvt ad=0.1664 pd=1.8 as=0.0864 ps=0.91 w=0.64 l=0.15
X1987 single_9b_cdac_0.cdac_sw_9b_0.cdac_sw_3_4.tg_sw_3_3.SWN single_9b_cdac_0.cdac_sw_9b_0.cdac_sw_3_4.nooverlap_clk_0.x10.A VGND VGND sky130_fd_pr__nfet_01v8_lvt ad=0.1036 pd=1.02 as=0.2146 ps=2.06 w=0.74 l=0.15
X1988 a_13403_18900# a_13053_18900# a_13308_18900# VDPWR sky130_fd_pr__pfet_01v8_hvt ad=0.07245 pd=0.765 as=0.0651 ps=0.73 w=0.42 l=0.15
X1989 ua[0] single_9b_cdac_1.cdac_sw_9b_0.cdac_sw_3_8.tg_sw_3_3.SWN ua[0] VGND sky130_fd_pr__nfet_01v8 ad=0.145 pd=1.58 as=0 ps=0 w=0.5 l=0.5
X1990 th_dif_sw_0.VCN single_9b_cdac_0.cdac_sw_9b_0.S[3] sky130_fd_pr__cap_mim_m3_1 l=2 w=2
X1991 th_dif_sw_0.VCN single_9b_cdac_0.cdac_sw_9b_0.S[1] sky130_fd_pr__cap_mim_m3_1 l=2 w=2
X1992 VDPWR single_9b_cdac_1.cdac_sw_9b_0.cdac_sw_3_5.nooverlap_clk_0.sky130_fd_sc_hs__inv_8_0.A single_9b_cdac_1.cdac_sw_9b_0.cdac_sw_3_5.nooverlap_clk_0.CLKB0 VDPWR sky130_fd_pr__pfet_01v8 ad=0.168 pd=1.42 as=0.168 ps=1.42 w=1.12 l=0.15
X1993 th_dif_sw_0.VCP single_9b_cdac_1.cdac_sw_9b_0.S[0] sky130_fd_pr__cap_mim_m3_1 l=2 w=2
X1994 th_dif_sw_0.VCN single_9b_cdac_0.cdac_sw_9b_0.S[0] sky130_fd_pr__cap_mim_m3_1 l=2 w=2
X1995 ua[0] single_9b_cdac_0.cdac_sw_9b_0.cdac_sw_3_8.tg_sw_3_3.SWN ua[0] VGND sky130_fd_pr__nfet_01v8 ad=0.145 pd=1.58 as=0 ps=0 w=0.5 l=0.5
X1996 VGND single_9b_cdac_1.cdac_sw_9b_0.cdac_sw_3_3.nooverlap_clk_0.CLKB0 single_9b_cdac_1.cdac_sw_9b_0.cdac_sw_3_3.nooverlap_clk_0.CLK0 VGND sky130_fd_pr__nfet_01v8_lvt ad=0.1554 pd=1.16 as=0.1036 ps=1.02 w=0.74 l=0.15
X1997 th_dif_sw_0.VCP single_9b_cdac_1.cdac_sw_9b_0.S[0] sky130_fd_pr__cap_mim_m3_1 l=2 w=2
X1998 VGND single_9b_cdac_0.cdac_sw_9b_0.cdac_sw_3_2.nooverlap_clk_0.CLKB0 single_9b_cdac_0.cdac_sw_9b_0.cdac_sw_3_2.nooverlap_clk_0.CLK0 VGND sky130_fd_pr__nfet_01v8_lvt ad=0.2109 pd=2.05 as=0.1036 ps=1.02 w=0.74 l=0.15
X1999 VGND VDPWR VGND VGND sky130_fd_pr__nfet_01v8 ad=0.143 pd=1.62 as=0 ps=0 w=0.55 l=0.59
X2000 single_9b_cdac_1.cdac_sw_9b_0.cdac_sw_3_5.nooverlap_clk_0.CLKB0 single_9b_cdac_1.cdac_sw_9b_0.cdac_sw_3_5.nooverlap_clk_0.sky130_fd_sc_hs__inv_8_0.A VDPWR VDPWR sky130_fd_pr__pfet_01v8 ad=0.168 pd=1.42 as=0.196 ps=1.47 w=1.12 l=0.15
X2001 th_dif_sw_0.VCN single_9b_cdac_0.cdac_sw_9b_0.S[0] sky130_fd_pr__cap_mim_m3_1 l=2 w=2
X2002 th_dif_sw_0.VCN single_9b_cdac_0.cdac_sw_9b_0.S[0] sky130_fd_pr__cap_mim_m3_1 l=2 w=2
X2003 single_9b_cdac_1.cdac_sw_9b_0.cdac_sw_3_1.nooverlap_clk_0.x10.A single_9b_cdac_1.cdac_sw_9b_0.cdac_sw_3_1.nooverlap_clk_0.x8.A VGND VGND sky130_fd_pr__nfet_01v8_lvt ad=0.1036 pd=1.02 as=0.1221 ps=1.07 w=0.74 l=0.15
X2004 VDPWR single_9b_cdac_0.cdac_sw_9b_0.cdac_sw_3_1.nooverlap_clk_0.x6.A single_9b_cdac_0.cdac_sw_9b_0.cdac_sw_3_1.nooverlap_clk_0.x8.A VDPWR sky130_fd_pr__pfet_01v8 ad=0.3864 pd=2.93 as=0.3304 ps=2.83 w=1.12 l=0.15
X2005 a_13968_25262# a_13053_24890# a_13621_24858# VGND sky130_fd_pr__special_nfet_01v8 ad=0.0711 pd=0.755 as=0.0999 ps=0.985 w=0.36 l=0.15
X2006 a_11501_23252# a_10311_23252# a_11392_23252# VGND sky130_fd_pr__special_nfet_01v8 ad=0.0669 pd=0.75 as=0.0711 ps=0.755 w=0.36 l=0.15
X2007 a_13403_26516# a_12887_26516# a_13308_26516# VGND sky130_fd_pr__special_nfet_01v8 ad=0.0594 pd=0.69 as=0.066 ps=0.745 w=0.36 l=0.15
X2008 VGND single_9b_cdac_0.cdac_sw_9b_0.cdac_sw_3_7.nooverlap_clk_0.CLKB0 single_9b_cdac_0.cdac_sw_9b_0.cdac_sw_3_7.nooverlap_clk_0.CLK0 VGND sky130_fd_pr__nfet_01v8_lvt ad=0.1295 pd=1.09 as=0.1036 ps=1.02 w=0.74 l=0.15
X2009 VGND single_9b_cdac_0.SW[2] a_54032_26990# VGND sky130_fd_pr__nfet_01v8 ad=0.145 pd=1.58 as=0.145 ps=1.58 w=0.5 l=0.5
X2010 a_13511_26882# sar9b_0.net15 VDPWR VDPWR sky130_fd_pr__pfet_01v8_hvt ad=0.1092 pd=1.36 as=0.07035 ps=0.755 w=0.42 l=0.15
X2011 a_14143_25402# sar9b_0.net15 VDPWR VDPWR sky130_fd_pr__pfet_01v8_hvt ad=0.0567 pd=0.69 as=0.0819 ps=0.81 w=0.42 l=0.15
X2012 th_dif_sw_0.VCP single_9b_cdac_1.cdac_sw_9b_0.S[2] sky130_fd_pr__cap_mim_m3_1 l=2 w=2
X2013 single_9b_cdac_0.cdac_sw_9b_0.cdac_sw_3_1.tg_sw_3_3.SWP single_9b_cdac_0.cdac_sw_9b_0.cdac_sw_3_1.tg_sw_3_3.SWN VGND VGND sky130_fd_pr__nfet_01v8_lvt ad=0.1036 pd=1.02 as=0.1554 ps=1.16 w=0.74 l=0.15
X2014 sar9b_0.net25 a_12947_26276# VGND VGND sky130_fd_pr__nfet_01v8 ad=0.169 pd=1.82 as=0.2087 ps=2.02 w=0.65 l=0.15
X2015 a_54032_17740# single_9b_cdac_1.cdac_sw_9b_0.cdac_sw_3_0.nooverlap_clk_0.CLK0 single_9b_cdac_1.cdac_sw_9b_0.S[2] VGND sky130_fd_pr__nfet_01v8 ad=0.145 pd=1.58 as=0.145 ps=1.58 w=0.5 l=0.5
X2016 th_dif_sw_0.VCN single_9b_cdac_0.cdac_sw_9b_0.S[0] sky130_fd_pr__cap_mim_m3_1 l=2 w=2
X2017 single_9b_cdac_1.cdac_sw_9b_0.cdac_sw_3_1.tg_sw_3_3.SWN single_9b_cdac_1.cdac_sw_9b_0.cdac_sw_3_1.nooverlap_clk_0.x10.A VGND VGND sky130_fd_pr__nfet_01v8_lvt ad=0.1036 pd=1.02 as=0.1295 ps=1.09 w=0.74 l=0.15
X2018 a_12575_18734# a_12225_18362# a_12480_18722# VDPWR sky130_fd_pr__pfet_01v8_hvt ad=0.07245 pd=0.765 as=0.0651 ps=0.73 w=0.42 l=0.15
X2019 th_dif_sw_0.VCN single_9b_cdac_0.cdac_sw_9b_0.S[2] sky130_fd_pr__cap_mim_m3_1 l=2 w=2
X2020 VDPWR VGND VDPWR VDPWR sky130_fd_pr__pfet_01v8_hvt ad=0.2262 pd=2.26 as=0 ps=0 w=0.87 l=0.59
X2021 VGND VDPWR VGND VGND sky130_fd_pr__nfet_01v8 ad=0.143 pd=1.62 as=0 ps=0 w=0.55 l=0.59
X2022 a_10174_22530# a_9097_22164# a_10012_22164# VDPWR sky130_fd_pr__pfet_01v8_hvt ad=0.0567 pd=0.69 as=0.0588 ps=0.7 w=0.42 l=0.15
X2023 single_9b_cdac_1.cdac_sw_9b_0.S[4] single_9b_cdac_1.cdac_sw_9b_0.cdac_sw_3_3.nooverlap_clk_0.CLKB0 a_43540_16877# VDPWR sky130_fd_pr__pfet_01v8 ad=0.435 pd=3.58 as=0.435 ps=3.58 w=1.5 l=0.5
X2024 th_dif_sw_0.VCP single_9b_cdac_1.cdac_sw_9b_0.S[0] sky130_fd_pr__cap_mim_m3_1 l=2 w=2
X2025 single_9b_cdac_0.cdac_sw_9b_0.cdac_sw_3_5.tg_sw_3_3.SWN single_9b_cdac_0.cdac_sw_9b_0.cdac_sw_3_5.nooverlap_clk_0.x10.A VGND VGND sky130_fd_pr__nfet_01v8_lvt ad=0.1036 pd=1.02 as=0.1295 ps=1.09 w=0.74 l=0.15
X2026 a_12881_26350# a_11691_25978# a_12772_26350# VGND sky130_fd_pr__special_nfet_01v8 ad=0.0669 pd=0.75 as=0.0711 ps=0.755 w=0.36 l=0.15
X2027 th_dif_sw_0.VCN single_9b_cdac_0.cdac_sw_9b_0.S[1] sky130_fd_pr__cap_mim_m3_1 l=2 w=2
X2028 VDPWR a_13857_27279# uo_out[1] VDPWR sky130_fd_pr__pfet_01v8_hvt ad=0.11455 pd=1.08 as=0.2054 ps=2.1 w=0.79 l=0.15
X2029 a_9281_26516# a_9115_26516# VDPWR VDPWR sky130_fd_pr__pfet_01v8_hvt ad=0.1664 pd=1.8 as=0.0864 ps=0.91 w=0.64 l=0.15
X2030 VGND single_9b_cdac_0.cdac_sw_9b_0.cdac_sw_3_3.tg_sw_3_3.SWN single_9b_cdac_0.cdac_sw_9b_0.cdac_sw_3_3.tg_sw_3_3.SWP VGND sky130_fd_pr__nfet_01v8_lvt ad=0.1554 pd=1.16 as=0.1036 ps=1.02 w=0.74 l=0.15
X2031 ua[0] single_9b_cdac_1.cdac_sw_9b_0.cdac_sw_3_0.tg_sw_3_3.SWN ua[0] VGND sky130_fd_pr__nfet_01v8 ad=0.145 pd=1.58 as=0 ps=0 w=0.5 l=0.5
X2032 VDPWR sar9b_0.net4 a_11231_20538# VDPWR sky130_fd_pr__pfet_01v8_hvt ad=0.0864 pd=0.91 as=0.1664 ps=1.8 w=0.64 l=0.15
X2033 VGND single_9b_cdac_0.SW[3] a_49221_26990# VGND sky130_fd_pr__nfet_01v8 ad=0.145 pd=1.58 as=0.145 ps=1.58 w=0.5 l=0.5
X2034 a_12112_26338# sar9b_0.net43 VGND VGND sky130_fd_pr__nfet_01v8 ad=0.066 pd=0.745 as=0.2205 ps=1.89 w=0.42 l=0.15
X2035 single_9b_cdac_1.SW[7] a_14451_20532# VGND VGND sky130_fd_pr__nfet_01v8 ad=0.1352 pd=1.56 as=0.0754 ps=0.81 w=0.52 l=0.15
X2036 sar9b_0.clkload0.X a_6907_19444# VDPWR VDPWR sky130_fd_pr__pfet_01v8_hvt ad=0.14 pd=1.28 as=0.14 ps=1.28 w=1 l=0.15
X2037 VGND single_9b_cdac_0.cdac_sw_9b_0.cdac_sw_3_8.nooverlap_clk_0.x8.A single_9b_cdac_0.cdac_sw_9b_0.cdac_sw_3_8.nooverlap_clk_0.x10.A VGND sky130_fd_pr__nfet_01v8_lvt ad=0.1221 pd=1.07 as=0.1036 ps=1.02 w=0.74 l=0.15
X2038 single_9b_cdac_0.cdac_sw_9b_0.cdac_sw_3_7.nooverlap_clk_0.sky130_fd_sc_hs__inv_8_0.A single_9b_cdac_0.cdac_sw_9b_0.cdac_sw_3_7.nooverlap_clk_0.x1.A VDPWR VDPWR sky130_fd_pr__pfet_01v8 ad=0.168 pd=1.42 as=0.168 ps=1.42 w=1.12 l=0.15
X2039 VGND single_9b_cdac_1.cdac_sw_9b_0.cdac_sw_3_5.tg_sw_3_3.SWN single_9b_cdac_1.cdac_sw_9b_0.cdac_sw_3_5.tg_sw_3_3.SWP VGND sky130_fd_pr__nfet_01v8_lvt ad=0.1036 pd=1.02 as=0.1036 ps=1.02 w=0.74 l=0.15
X2040 th_dif_sw_0.VCN single_9b_cdac_0.cdac_sw_9b_0.S[0] sky130_fd_pr__cap_mim_m3_1 l=2 w=2
X2041 VGND single_9b_cdac_1.cdac_sw_9b_0.cdac_sw_3_3.nooverlap_clk_0.x8.A single_9b_cdac_1.cdac_sw_9b_0.cdac_sw_3_3.nooverlap_clk_0.x10.A VGND sky130_fd_pr__nfet_01v8_lvt ad=0.1221 pd=1.07 as=0.1184 ps=1.06 w=0.74 l=0.15
X2042 VDPWR single_9b_cdac_0.cdac_sw_9b_0.cdac_sw_3_7.nooverlap_clk_0.x1.A single_9b_cdac_0.cdac_sw_9b_0.cdac_sw_3_7.nooverlap_clk_0.sky130_fd_sc_hs__inv_8_0.A VDPWR sky130_fd_pr__pfet_01v8 ad=0.168 pd=1.42 as=0.168 ps=1.42 w=1.12 l=0.15
X2043 single_9b_cdac_0.cdac_sw_9b_0.cdac_sw_3_0.nooverlap_clk_0.CLKB0 single_9b_cdac_0.cdac_sw_9b_0.cdac_sw_3_0.nooverlap_clk_0.sky130_fd_sc_hs__inv_8_0.A VDPWR VDPWR sky130_fd_pr__pfet_01v8 ad=0.168 pd=1.42 as=0.196 ps=1.47 w=1.12 l=0.15
X2044 th_dif_sw_0.VCN single_9b_cdac_0.cdac_sw_9b_0.S[0] sky130_fd_pr__cap_mim_m3_1 l=2 w=2
X2045 a_24332_26999# single_9b_cdac_0.SW[8] VDPWR VDPWR sky130_fd_pr__pfet_01v8 ad=0.435 pd=3.58 as=0.435 ps=3.58 w=1.5 l=0.5
X2046 single_9b_cdac_0.cdac_sw_9b_0.cdac_sw_3_4.nooverlap_clk_0.CLKB0 single_9b_cdac_0.cdac_sw_9b_0.cdac_sw_3_4.nooverlap_clk_0.sky130_fd_sc_hs__inv_8_0.A VGND VGND sky130_fd_pr__nfet_01v8_lvt ad=0.1036 pd=1.02 as=0.1554 ps=1.16 w=0.74 l=0.15
X2047 a_5999_19822# a_5870_19566# a_5579_19676# VGND sky130_fd_pr__special_nfet_01v8 ad=0.0989 pd=0.995 as=0.0684 ps=0.74 w=0.36 l=0.15
X2048 sar9b_0.net3 a_5343_25972# VGND VGND sky130_fd_pr__nfet_01v8 ad=0.0588 pd=0.7 as=0.0588 ps=0.7 w=0.42 l=0.15
X2049 a_6631_24590# sar9b_0.clk_div_0.COUNT\[0\] VDPWR VDPWR sky130_fd_pr__pfet_01v8_hvt ad=0.14 pd=1.28 as=0.1475 ps=1.295 w=1 l=0.15
X2050 single_9b_cdac_1.cdac_sw_9b_0.cdac_sw_3_0.nooverlap_clk_0.x4.A single_9b_cdac_1.cdac_sw_9b_0.cdac_sw_3_0.nooverlap_clk_0.x1.A a_54737_15495# VGND sky130_fd_pr__nfet_01v8_lvt ad=0.2109 pd=2.05 as=0.0888 ps=0.98 w=0.74 l=0.15
X2051 single_9b_cdac_0.cdac_sw_9b_0.cdac_sw_3_7.nooverlap_clk_0.sky130_fd_sc_hs__inv_8_0.A single_9b_cdac_0.cdac_sw_9b_0.cdac_sw_3_7.nooverlap_clk_0.x1.A VDPWR VDPWR sky130_fd_pr__pfet_01v8 ad=0.168 pd=1.42 as=0.3304 ps=2.83 w=1.12 l=0.15
X2052 a_12961_23802# a_12795_23802# VDPWR VDPWR sky130_fd_pr__pfet_01v8_hvt ad=0.1664 pd=1.8 as=0.0864 ps=0.91 w=0.64 l=0.15
X2053 VGND single_9b_cdac_1.cdac_sw_9b_0.cdac_sw_3_6.nooverlap_clk_0.CLKB0 single_9b_cdac_1.cdac_sw_9b_0.cdac_sw_3_6.nooverlap_clk_0.CLK0 VGND sky130_fd_pr__nfet_01v8_lvt ad=0.2146 pd=2.06 as=0.1036 ps=1.02 w=0.74 l=0.15
X2054 th_dif_sw_0.VCP single_9b_cdac_1.cdac_sw_9b_0.S[1] sky130_fd_pr__cap_mim_m3_1 l=2 w=2
X2055 th_dif_sw_0.th_sw_1.CKB a_21177_7457# VDPWR VDPWR sky130_fd_pr__pfet_01v8 ad=0.168 pd=1.42 as=0.168 ps=1.42 w=1.12 l=0.15
X2056 a_45123_29917# single_9b_cdac_0.cdac_sw_9b_0.cdac_sw_3_3.nooverlap_clk_0.x1.A single_9b_cdac_0.cdac_sw_9b_0.cdac_sw_3_3.nooverlap_clk_0.x4.A VGND sky130_fd_pr__nfet_01v8_lvt ad=0.0888 pd=0.98 as=0.2109 ps=2.05 w=0.74 l=0.15
X2057 VGND single_9b_cdac_0.SW[5] a_39616_26990# VGND sky130_fd_pr__nfet_01v8 ad=0.145 pd=1.58 as=0.145 ps=1.58 w=0.5 l=0.5
X2058 a_9543_19748# a_9368_19822# a_9722_19810# VGND sky130_fd_pr__nfet_01v8 ad=0.1092 pd=1.36 as=0.06405 ps=0.725 w=0.42 l=0.15
X2059 a_9021_19418# a_8803_19822# VDPWR VDPWR sky130_fd_pr__pfet_01v8_hvt ad=0.12915 pd=1.185 as=0.2184 ps=2.2 w=0.84 l=0.15
X2060 th_dif_sw_0.VCN single_9b_cdac_0.cdac_sw_9b_0.S[0] sky130_fd_pr__cap_mim_m3_1 l=2 w=2
X2061 sar9b_0.net6 a_11567_19748# VGND VGND sky130_fd_pr__nfet_01v8 ad=0.169 pd=1.82 as=0.2087 ps=2.02 w=0.65 l=0.15
X2062 a_10406_19266# a_9687_19042# a_9843_19137# VGND sky130_fd_pr__special_nfet_01v8 ad=0.066 pd=0.745 as=0.0594 ps=0.69 w=0.36 l=0.15
X2063 a_44418_17740# single_9b_cdac_1.cdac_sw_9b_0.cdac_sw_3_3.nooverlap_clk_0.CLK0 single_9b_cdac_1.cdac_sw_9b_0.S[4] VGND sky130_fd_pr__nfet_01v8 ad=0.145 pd=1.58 as=0.145 ps=1.58 w=0.5 l=0.5
X2064 VGND single_9b_cdac_1.SW[4] a_44418_17740# VGND sky130_fd_pr__nfet_01v8 ad=0.145 pd=1.58 as=0.145 ps=1.58 w=0.5 l=0.5
X2065 th_dif_sw_0.VCN single_9b_cdac_0.cdac_sw_9b_0.S[2] sky130_fd_pr__cap_mim_m3_1 l=2 w=2
X2066 VGND VDPWR VGND VGND sky130_fd_pr__nfet_01v8 ad=0.143 pd=1.62 as=0 ps=0 w=0.55 l=0.59
X2067 a_13403_19988# a_12887_19988# a_13308_19988# VGND sky130_fd_pr__special_nfet_01v8 ad=0.0594 pd=0.69 as=0.066 ps=0.745 w=0.36 l=0.15
X2068 th_dif_sw_0.VCP single_9b_cdac_1.cdac_sw_9b_0.S[0] sky130_fd_pr__cap_mim_m3_1 l=2 w=2
X2069 single_9b_cdac_1.cdac_sw_9b_0.cdac_sw_3_3.tg_sw_3_3.SWN single_9b_cdac_1.cdac_sw_9b_0.cdac_sw_3_3.nooverlap_clk_0.x10.A VGND VGND sky130_fd_pr__nfet_01v8_lvt ad=0.1036 pd=1.02 as=0.1036 ps=1.02 w=0.74 l=0.15
X2070 sar9b_0._00_ a_5884_21326# VGND VGND sky130_fd_pr__nfet_01v8 ad=0.169 pd=1.82 as=0.169 ps=1.82 w=0.65 l=0.15
X2071 VDPWR single_9b_cdac_1.cdac_sw_9b_0.cdac_sw_3_3.nooverlap_clk_0.CLKB0 single_9b_cdac_1.cdac_sw_9b_0.cdac_sw_3_3.nooverlap_clk_0.CLK0 VDPWR sky130_fd_pr__pfet_01v8 ad=0.3864 pd=2.93 as=0.168 ps=1.42 w=1.12 l=0.15
X2072 VGND single_9b_cdac_1.SW[2] a_54032_17740# VGND sky130_fd_pr__nfet_01v8 ad=0.145 pd=1.58 as=0.145 ps=1.58 w=0.5 l=0.5
X2073 th_dif_sw_0.VCP single_9b_cdac_1.cdac_sw_9b_0.S[0] sky130_fd_pr__cap_mim_m3_1 l=2 w=2
X2074 th_dif_sw_0.VCN single_9b_cdac_0.cdac_sw_9b_0.S[0] sky130_fd_pr__cap_mim_m3_1 l=2 w=2
X2075 VDPWR single_9b_cdac_0.cdac_sw_9b_0.cdac_sw_3_2.nooverlap_clk_0.x10.A single_9b_cdac_0.cdac_sw_9b_0.cdac_sw_3_2.tg_sw_3_3.SWN VDPWR sky130_fd_pr__pfet_01v8 ad=0.196 pd=1.47 as=0.168 ps=1.42 w=1.12 l=0.15
X2076 VDPWR VGND VDPWR VDPWR sky130_fd_pr__pfet_01v8_hvt ad=0.2262 pd=2.26 as=0 ps=0 w=0.87 l=0.59
X2077 single_9b_cdac_1.cdac_sw_9b_0.cdac_sw_3_1.nooverlap_clk_0.CLKB0 single_9b_cdac_1.cdac_sw_9b_0.cdac_sw_3_1.nooverlap_clk_0.sky130_fd_sc_hs__inv_8_0.A VGND VGND sky130_fd_pr__nfet_01v8_lvt ad=0.1036 pd=1.02 as=0.1554 ps=1.16 w=0.74 l=0.15
X2078 single_9b_cdac_0.cdac_sw_9b_0.cdac_sw_3_8.nooverlap_clk_0.sky130_fd_sc_hs__nand2_1_0.Y single_9b_cdac_1.CF[8] a_26951_29911# VGND sky130_fd_pr__nfet_01v8_lvt ad=0.2109 pd=2.05 as=0.0888 ps=0.98 w=0.74 l=0.15
X2079 single_9b_cdac_0.cdac_sw_9b_0.cdac_sw_3_8.nooverlap_clk_0.CLK0 single_9b_cdac_0.cdac_sw_9b_0.cdac_sw_3_8.nooverlap_clk_0.CLKB0 VGND VGND sky130_fd_pr__nfet_01v8_lvt ad=0.1036 pd=1.02 as=0.1036 ps=1.02 w=0.74 l=0.15
X2080 a_10732_25250# sar9b_0.net12 VDPWR VDPWR sky130_fd_pr__pfet_01v8_hvt ad=0.0651 pd=0.73 as=0.1092 ps=1.36 w=0.42 l=0.15
X2081 a_11395_22530# a_10771_22164# a_11287_22164# VDPWR sky130_fd_pr__pfet_01v8_hvt ad=0.1155 pd=0.97 as=0.07245 ps=0.765 w=0.42 l=0.15
X2082 a_8085_27066# a_7919_27066# VGND VGND sky130_fd_pr__nfet_01v8 ad=0.1092 pd=1.36 as=0.0567 ps=0.69 w=0.42 l=0.15
X2083 VGND single_9b_cdac_0.cdac_sw_9b_0.cdac_sw_3_6.nooverlap_clk_0.sky130_fd_sc_hs__nand2_1_0.Y single_9b_cdac_0.cdac_sw_9b_0.cdac_sw_3_6.nooverlap_clk_0.sky130_fd_sc_hs__inv_1_1.A VGND sky130_fd_pr__nfet_01v8_lvt ad=0.2627 pd=2.19 as=0.2109 ps=2.05 w=0.74 l=0.15
X2084 ua[0] single_9b_cdac_0.cdac_sw_9b_0.cdac_sw_3_2.tg_sw_3_3.SWN ua[0] VGND sky130_fd_pr__nfet_01v8 ad=0.145 pd=1.58 as=0 ps=0 w=0.5 l=0.5
X2085 VDPWR VGND VDPWR VDPWR sky130_fd_pr__pfet_01v8_hvt ad=0.2262 pd=2.26 as=0 ps=0 w=0.87 l=0.59
X2086 a_12390_21076# sar9b_0.net15 VGND VGND sky130_fd_pr__nfet_01v8 ad=0.06405 pd=0.725 as=0.12495 ps=1.015 w=0.42 l=0.15
X2087 single_9b_cdac_1.cdac_sw_9b_0.cdac_sw_3_3.nooverlap_clk_0.CLK0 single_9b_cdac_1.cdac_sw_9b_0.cdac_sw_3_3.nooverlap_clk_0.CLKB0 VDPWR VDPWR sky130_fd_pr__pfet_01v8 ad=0.168 pd=1.42 as=0.196 ps=1.47 w=1.12 l=0.15
X2088 single_9b_cdac_0.cdac_sw_9b_0.cdac_sw_3_2.tg_sw_3_3.SWN single_9b_cdac_0.cdac_sw_9b_0.cdac_sw_3_2.nooverlap_clk_0.x10.A VDPWR VDPWR sky130_fd_pr__pfet_01v8 ad=0.168 pd=1.42 as=0.168 ps=1.42 w=1.12 l=0.15
X2089 a_14130_19444# a_13053_19450# a_13968_19822# VDPWR sky130_fd_pr__pfet_01v8_hvt ad=0.0567 pd=0.69 as=0.0588 ps=0.7 w=0.42 l=0.15
X2090 a_13140_18734# a_12059_18362# a_12793_18330# VDPWR sky130_fd_pr__pfet_01v8_hvt ad=0.0588 pd=0.7 as=0.12915 ps=1.185 w=0.42 l=0.15
X2091 ua[0] single_9b_cdac_1.cdac_sw_9b_0.cdac_sw_3_7.tg_sw_3_3.SWP ua[0] VDPWR sky130_fd_pr__pfet_01v8 ad=0.435 pd=3.58 as=0 ps=0 w=1.5 l=0.5
X2092 th_dif_sw_0.VCN single_9b_cdac_0.cdac_sw_9b_0.S[2] sky130_fd_pr__cap_mim_m3_1 l=2 w=2
X2093 single_9b_cdac_0.cdac_sw_9b_0.S[0] single_9b_cdac_0.cdac_sw_9b_0.cdac_sw_3_2.tg_sw_3_3.SWP single_9b_cdac_0.cdac_sw_9b_0.S[0] VDPWR sky130_fd_pr__pfet_01v8 ad=0.435 pd=3.58 as=0 ps=0 w=1.5 l=0.5
X2094 VGND VDPWR VGND VGND sky130_fd_pr__nfet_01v8 ad=0.143 pd=1.62 as=0 ps=0 w=0.55 l=0.59
X2095 VGND th_dif_sw_0.th_sw_1.CK a_10166_3438# VGND sky130_fd_pr__nfet_01v8 ad=0.58 pd=4.58 as=0.58 ps=4.58 w=2 l=0.15
X2096 VGND single_9b_cdac_0.cdac_sw_9b_0.cdac_sw_3_2.nooverlap_clk_0.CLKB0 single_9b_cdac_0.cdac_sw_9b_0.cdac_sw_3_2.nooverlap_clk_0.CLK0 VGND sky130_fd_pr__nfet_01v8_lvt ad=0.1036 pd=1.02 as=0.1036 ps=1.02 w=0.74 l=0.15
X2097 VGND sar9b_0.clknet_0_CLK a_6149_23770# VGND sky130_fd_pr__nfet_01v8 ad=0.1113 pd=1.37 as=0.0588 ps=0.7 w=0.42 l=0.15
X2098 VDPWR single_9b_cdac_0.cdac_sw_9b_0.cdac_sw_3_2.nooverlap_clk_0.x10.A single_9b_cdac_0.cdac_sw_9b_0.cdac_sw_3_2.tg_sw_3_3.SWN VDPWR sky130_fd_pr__pfet_01v8 ad=0.168 pd=1.42 as=0.168 ps=1.42 w=1.12 l=0.15
X2099 single_9b_cdac_1.cdac_sw_9b_0.cdac_sw_3_6.nooverlap_clk_0.x1.A single_9b_cdac_1.cdac_sw_9b_0.cdac_sw_3_6.nooverlap_clk_0.sky130_fd_sc_hs__inv_1_1.A VGND VGND sky130_fd_pr__nfet_01v8_lvt ad=0.2109 pd=2.05 as=0.2627 ps=2.19 w=0.74 l=0.15
X2100 a_14322_22164# sar9b_0.net15 VGND VGND sky130_fd_pr__nfet_01v8 ad=0.06405 pd=0.725 as=0.12495 ps=1.015 w=0.42 l=0.15
X2101 a_9631_21076# a_9281_21076# a_9536_21076# VDPWR sky130_fd_pr__pfet_01v8_hvt ad=0.07245 pd=0.765 as=0.0651 ps=0.73 w=0.42 l=0.15
X2102 single_9b_cdac_0.cdac_sw_9b_0.S[6] single_9b_cdac_0.cdac_sw_9b_0.cdac_sw_3_6.tg_sw_3_3.SWP single_9b_cdac_0.cdac_sw_9b_0.S[6] VDPWR sky130_fd_pr__pfet_01v8 ad=0.435 pd=3.58 as=0 ps=0 w=1.5 l=0.5
X2103 single_9b_cdac_0.cdac_sw_9b_0.S[0] single_9b_cdac_0.cdac_sw_9b_0.cdac_sw_3_2.tg_sw_3_3.SWN single_9b_cdac_0.cdac_sw_9b_0.S[0] VGND sky130_fd_pr__nfet_01v8 ad=0.145 pd=1.58 as=0 ps=0 w=0.5 l=0.5
X2104 th_dif_sw_0.VCN single_9b_cdac_0.cdac_sw_9b_0.S[2] sky130_fd_pr__cap_mim_m3_1 l=2 w=2
X2105 VGND a_21177_7457# th_dif_sw_0.th_sw_1.CKB VGND sky130_fd_pr__nfet_01v8_lvt ad=0.1554 pd=1.16 as=0.1036 ps=1.02 w=0.74 l=0.15
X2106 a_15400_11316# tdc_0.phase_detector_0.INP VDPWR VDPWR sky130_fd_pr__pfet_01v8 ad=0.435 pd=3.29 as=0.87 ps=6.58 w=3 l=0.15
X2107 single_9b_cdac_1.cdac_sw_9b_0.S[8] single_9b_cdac_1.cdac_sw_9b_0.cdac_sw_3_8.nooverlap_clk_0.CLKB0 a_24332_16877# VDPWR sky130_fd_pr__pfet_01v8 ad=0.435 pd=3.58 as=0.435 ps=3.58 w=1.5 l=0.5
X2108 VDPWR a_14143_26490# a_14130_26882# VDPWR sky130_fd_pr__pfet_01v8_hvt ad=0.0819 pd=0.81 as=0.0567 ps=0.69 w=0.42 l=0.15
X2109 single_9b_cdac_0.cdac_sw_9b_0.cdac_sw_3_3.tg_sw_3_3.SWP single_9b_cdac_0.cdac_sw_9b_0.cdac_sw_3_3.tg_sw_3_3.SWN VDPWR VDPWR sky130_fd_pr__pfet_01v8 ad=0.168 pd=1.42 as=0.196 ps=1.47 w=1.12 l=0.15
X2110 VDPWR a_13968_18900# a_14143_18874# VDPWR sky130_fd_pr__pfet_01v8_hvt ad=0.1134 pd=1.38 as=0.0567 ps=0.69 w=0.42 l=0.15
X2111 th_dif_sw_0.VCP single_9b_cdac_1.cdac_sw_9b_0.S[4] sky130_fd_pr__cap_mim_m3_1 l=2 w=2
X2112 th_dif_sw_0.VCN single_9b_cdac_0.cdac_sw_9b_0.S[0] sky130_fd_pr__cap_mim_m3_1 l=2 w=2
X2113 single_9b_cdac_1.cdac_sw_9b_0.S[6] single_9b_cdac_1.cdac_sw_9b_0.cdac_sw_3_6.tg_sw_3_3.SWN single_9b_cdac_1.cdac_sw_9b_0.S[6] VGND sky130_fd_pr__nfet_01v8 ad=0.145 pd=1.58 as=2.32 ps=25.28 w=0.5 l=0.5
X2114 VGND single_9b_cdac_1.cdac_sw_9b_0.cdac_sw_3_8.tg_sw_3_3.SWN single_9b_cdac_1.cdac_sw_9b_0.cdac_sw_3_8.tg_sw_3_3.SWP VGND sky130_fd_pr__nfet_01v8_lvt ad=0.1295 pd=1.09 as=0.1036 ps=1.02 w=0.74 l=0.15
X2115 th_dif_sw_0.VCN single_9b_cdac_0.cdac_sw_9b_0.S[0] sky130_fd_pr__cap_mim_m3_1 l=2 w=2
X2116 th_dif_sw_0.VCP single_9b_cdac_1.cdac_sw_9b_0.S[3] sky130_fd_pr__cap_mim_m3_1 l=2 w=2
X2117 single_9b_cdac_0.cdac_sw_9b_0.cdac_sw_3_7.tg_sw_3_3.SWP single_9b_cdac_0.cdac_sw_9b_0.cdac_sw_3_7.tg_sw_3_3.SWN VGND VGND sky130_fd_pr__nfet_01v8_lvt ad=0.1036 pd=1.02 as=0.2146 ps=2.06 w=0.74 l=0.15
X2118 VDPWR single_9b_cdac_0.cdac_sw_9b_0.cdac_sw_3_1.nooverlap_clk_0.x3.Y single_9b_cdac_0.cdac_sw_9b_0.cdac_sw_3_1.nooverlap_clk_0.x4.A VDPWR sky130_fd_pr__pfet_01v8 ad=0.3192 pd=2.81 as=0.168 ps=1.42 w=1.12 l=0.15
X2119 VGND a_12211_21050# a_12145_21076# VGND sky130_fd_pr__nfet_01v8 ad=0.12495 pd=1.015 as=0.0669 ps=0.75 w=0.42 l=0.15
X2120 a_13511_20354# a_12887_19988# a_13403_19988# VDPWR sky130_fd_pr__pfet_01v8_hvt ad=0.1155 pd=0.97 as=0.07245 ps=0.765 w=0.42 l=0.15
X2121 th_dif_sw_0.VCP single_9b_cdac_1.cdac_sw_9b_0.S[0] sky130_fd_pr__cap_mim_m3_1 l=2 w=2
X2122 th_dif_sw_0.VCN single_9b_cdac_0.cdac_sw_9b_0.S[2] sky130_fd_pr__cap_mim_m3_1 l=2 w=2
X2123 th_dif_sw_0.VCN single_9b_cdac_0.cdac_sw_9b_0.S[0] sky130_fd_pr__cap_mim_m3_1 l=2 w=2
X2124 VDPWR single_9b_cdac_0.cdac_sw_9b_0.cdac_sw_3_4.nooverlap_clk_0.x10.A single_9b_cdac_0.cdac_sw_9b_0.cdac_sw_3_4.tg_sw_3_3.SWN VDPWR sky130_fd_pr__pfet_01v8 ad=0.196 pd=1.47 as=0.168 ps=1.42 w=1.12 l=0.15
X2125 single_9b_cdac_0.cdac_sw_9b_0.cdac_sw_3_1.nooverlap_clk_0.x4.A single_9b_cdac_0.cdac_sw_9b_0.cdac_sw_3_1.nooverlap_clk_0.x1.A VDPWR VDPWR sky130_fd_pr__pfet_01v8 ad=0.168 pd=1.42 as=0.3192 ps=2.81 w=1.12 l=0.15
X2126 VDPWR a_7813_22316# sar9b_0._14_ VDPWR sky130_fd_pr__pfet_01v8_hvt ad=0.14575 pd=1.335 as=0.34 ps=2.68 w=1 l=0.15
X2127 th_dif_sw_0.VCP single_9b_cdac_1.cdac_sw_9b_0.S[1] sky130_fd_pr__cap_mim_m3_1 l=2 w=2
X2128 VGND sar9b_0.clk_div_0.COUNT\[3\] sar9b_0._06_ VGND sky130_fd_pr__nfet_01v8 ad=0.169 pd=1.82 as=0.08775 ps=0.92 w=0.65 l=0.15
X2129 a_7345_21594# clk VDPWR VDPWR sky130_fd_pr__pfet_01v8_hvt ad=0.14 pd=1.28 as=0.14 ps=1.28 w=1 l=0.15
X2130 VGND single_9b_cdac_1.cdac_sw_9b_0.cdac_sw_3_1.nooverlap_clk_0.x10.A single_9b_cdac_1.cdac_sw_9b_0.cdac_sw_3_1.tg_sw_3_3.SWN VGND sky130_fd_pr__nfet_01v8_lvt ad=0.2146 pd=2.06 as=0.1036 ps=1.02 w=0.74 l=0.15
X2131 VGND a_14143_22138# a_14077_22164# VGND sky130_fd_pr__nfet_01v8 ad=0.12495 pd=1.015 as=0.0669 ps=0.75 w=0.42 l=0.15
X2132 a_35519_15495# single_9b_cdac_1.cdac_sw_9b_0.cdac_sw_3_6.nooverlap_clk_0.x3.Y VGND VGND sky130_fd_pr__nfet_01v8_lvt ad=0.0888 pd=0.98 as=0.2109 ps=2.05 w=0.74 l=0.15
X2133 th_dif_sw_0.VCP single_9b_cdac_1.cdac_sw_9b_0.S[0] sky130_fd_pr__cap_mim_m3_1 l=2 w=2
X2134 VGND single_9b_cdac_0.cdac_sw_9b_0.cdac_sw_3_0.nooverlap_clk_0.x10.A single_9b_cdac_0.cdac_sw_9b_0.cdac_sw_3_0.tg_sw_3_3.SWN VGND sky130_fd_pr__nfet_01v8_lvt ad=0.1295 pd=1.09 as=0.1036 ps=1.02 w=0.74 l=0.15
X2135 a_9460_26350# a_8545_25978# a_9113_25946# VGND sky130_fd_pr__special_nfet_01v8 ad=0.0711 pd=0.755 as=0.0999 ps=0.985 w=0.36 l=0.15
X2136 VDPWR a_13140_18734# a_13315_18660# VDPWR sky130_fd_pr__pfet_01v8_hvt ad=0.1134 pd=1.38 as=0.0567 ps=0.69 w=0.42 l=0.15
X2137 th_dif_sw_0.VCN single_9b_cdac_0.cdac_sw_9b_0.S[0] sky130_fd_pr__cap_mim_m3_1 l=2 w=2
X2138 th_dif_sw_0.th_sw_1.CK a_9132_7271# VDPWR VDPWR sky130_fd_pr__pfet_01v8 ad=0.168 pd=1.42 as=0.196 ps=1.47 w=1.12 l=0.15
X2139 VGND single_9b_cdac_0.cdac_sw_9b_0.cdac_sw_3_6.nooverlap_clk_0.CLKB0 single_9b_cdac_0.cdac_sw_9b_0.cdac_sw_3_6.nooverlap_clk_0.CLK0 VGND sky130_fd_pr__nfet_01v8_lvt ad=0.2109 pd=2.05 as=0.1036 ps=1.02 w=0.74 l=0.15
X2140 VGND single_9b_cdac_0.cdac_sw_9b_0.cdac_sw_3_5.nooverlap_clk_0.x8.A single_9b_cdac_0.cdac_sw_9b_0.cdac_sw_3_5.nooverlap_clk_0.x10.A VGND sky130_fd_pr__nfet_01v8_lvt ad=0.1221 pd=1.07 as=0.1036 ps=1.02 w=0.74 l=0.15
X2141 single_9b_cdac_0.cdac_sw_9b_0.cdac_sw_3_4.tg_sw_3_3.SWN single_9b_cdac_0.cdac_sw_9b_0.cdac_sw_3_4.nooverlap_clk_0.x10.A VDPWR VDPWR sky130_fd_pr__pfet_01v8 ad=0.168 pd=1.42 as=0.3864 ps=2.93 w=1.12 l=0.15
X2142 VGND VDPWR VGND VGND sky130_fd_pr__nfet_01v8 ad=0.143 pd=1.62 as=0 ps=0 w=0.55 l=0.59
X2143 single_9b_cdac_1.cdac_sw_9b_0.cdac_sw_3_5.nooverlap_clk_0.sky130_fd_sc_hs__inv_8_0.A single_9b_cdac_1.cdac_sw_9b_0.cdac_sw_3_5.nooverlap_clk_0.x1.A VGND VGND sky130_fd_pr__nfet_01v8_lvt ad=0.1036 pd=1.02 as=0.1221 ps=1.07 w=0.74 l=0.15
X2144 single_9b_cdac_1.cdac_sw_9b_0.S[1] single_9b_cdac_1.cdac_sw_9b_0.cdac_sw_3_1.tg_sw_3_3.SWN ua[0] VDPWR sky130_fd_pr__pfet_01v8 ad=0.435 pd=3.58 as=0.435 ps=3.58 w=1.5 l=0.5
X2145 th_dif_sw_0.VCP single_9b_cdac_1.cdac_sw_9b_0.S[0] sky130_fd_pr__cap_mim_m3_1 l=2 w=2
X2146 a_8987_23252# a_8637_23252# a_8892_23252# VDPWR sky130_fd_pr__pfet_01v8_hvt ad=0.07245 pd=0.765 as=0.0651 ps=0.73 w=0.42 l=0.15
X2147 a_7889_21076# sar9b_0._14_ a_7817_21076# VGND sky130_fd_pr__nfet_01v8 ad=0.0441 pd=0.63 as=0.0441 ps=0.63 w=0.42 l=0.15
X2148 th_dif_sw_0.VCN single_9b_cdac_0.cdac_sw_9b_0.S[3] sky130_fd_pr__cap_mim_m3_1 l=2 w=2
X2149 single_9b_cdac_1.cdac_sw_9b_0.cdac_sw_3_4.nooverlap_clk_0.x3.Y single_9b_cdac_1.CF[3] VGND VGND sky130_fd_pr__nfet_01v8_lvt ad=0.2109 pd=2.05 as=0.2627 ps=2.19 w=0.74 l=0.15
X2150 single_9b_cdac_0.cdac_sw_9b_0.cdac_sw_3_5.nooverlap_clk_0.CLK0 single_9b_cdac_0.cdac_sw_9b_0.cdac_sw_3_5.nooverlap_clk_0.CLKB0 VGND VGND sky130_fd_pr__nfet_01v8_lvt ad=0.1036 pd=1.02 as=0.1554 ps=1.16 w=0.74 l=0.15
X2151 VGND VDPWR VGND VGND sky130_fd_pr__nfet_01v8 ad=0.143 pd=1.62 as=0 ps=0 w=0.55 l=0.59
X2152 single_9b_cdac_1.cdac_sw_9b_0.cdac_sw_3_5.nooverlap_clk_0.CLKB0 single_9b_cdac_1.cdac_sw_9b_0.cdac_sw_3_5.nooverlap_clk_0.sky130_fd_sc_hs__inv_8_0.A VGND VGND sky130_fd_pr__nfet_01v8_lvt ad=0.1036 pd=1.02 as=0.1295 ps=1.09 w=0.74 l=0.15
X2153 single_9b_cdac_1.cdac_sw_9b_0.cdac_sw_3_0.nooverlap_clk_0.CLK0 single_9b_cdac_1.cdac_sw_9b_0.cdac_sw_3_0.nooverlap_clk_0.CLKB0 VGND VGND sky130_fd_pr__nfet_01v8_lvt ad=0.1036 pd=1.02 as=0.1554 ps=1.16 w=0.74 l=0.15
X2154 th_dif_sw_0.VCN single_9b_cdac_0.cdac_sw_9b_0.S[0] sky130_fd_pr__cap_mim_m3_1 l=2 w=2
X2155 VDPWR VGND VDPWR VDPWR sky130_fd_pr__pfet_01v8_hvt ad=0.2262 pd=2.26 as=0 ps=0 w=0.87 l=0.59
X2156 th_dif_sw_0.VCN single_9b_cdac_0.cdac_sw_9b_0.S[1] sky130_fd_pr__cap_mim_m3_1 l=2 w=2
X2157 VDPWR a_21177_7457# th_dif_sw_0.th_sw_1.CKB VDPWR sky130_fd_pr__pfet_01v8 ad=0.168 pd=1.42 as=0.168 ps=1.42 w=1.12 l=0.15
X2158 a_38738_16877# single_9b_cdac_1.SW[5] VDPWR VDPWR sky130_fd_pr__pfet_01v8 ad=0.435 pd=3.58 as=0.435 ps=3.58 w=1.5 l=0.5
X2159 dw_12589_1395# a_10166_3438# sky130_fd_pr__cap_mim_m3_1 l=2 w=2
X2160 th_dif_sw_0.VCP single_9b_cdac_1.cdac_sw_9b_0.S[2] sky130_fd_pr__cap_mim_m3_1 l=2 w=2
X2161 th_dif_sw_0.VCN single_9b_cdac_0.cdac_sw_9b_0.S[1] sky130_fd_pr__cap_mim_m3_1 l=2 w=2
X2162 a_7417_27279# sar9b_0.net19 VDPWR VDPWR sky130_fd_pr__pfet_01v8_hvt ad=0.2054 pd=2.1 as=0.11455 ps=1.08 w=0.79 l=0.15
X2163 a_65367_29911# single_9b_cdac_0.cdac_sw_9b_0.cdac_sw_3_2.nooverlap_clk_0.x8.A VGND VGND sky130_fd_pr__nfet_01v8_lvt ad=0.0888 pd=0.98 as=0.2109 ps=2.05 w=0.74 l=0.15
X2164 single_9b_cdac_1.cdac_sw_9b_0.cdac_sw_3_0.tg_sw_3_3.SWN single_9b_cdac_1.cdac_sw_9b_0.cdac_sw_3_0.nooverlap_clk_0.x10.A VGND VGND sky130_fd_pr__nfet_01v8_lvt ad=0.1036 pd=1.02 as=0.2109 ps=2.05 w=0.74 l=0.15
X2165 VDPWR VGND VDPWR VDPWR sky130_fd_pr__pfet_01v8_hvt ad=0.2262 pd=2.26 as=0 ps=0 w=0.87 l=0.59
X2166 th_dif_sw_0.VCP single_9b_cdac_1.cdac_sw_9b_0.S[0] sky130_fd_pr__cap_mim_m3_1 l=2 w=2
X2167 th_dif_sw_0.VCN single_9b_cdac_0.cdac_sw_9b_0.S[0] sky130_fd_pr__cap_mim_m3_1 l=2 w=2
X2168 VDPWR single_9b_cdac_0.cdac_sw_9b_0.cdac_sw_3_4.nooverlap_clk_0.CLKB0 single_9b_cdac_0.cdac_sw_9b_0.cdac_sw_3_4.nooverlap_clk_0.CLK0 VDPWR sky130_fd_pr__pfet_01v8 ad=0.196 pd=1.47 as=0.168 ps=1.42 w=1.12 l=0.15
X2169 a_11413_25670# a_11195_25428# VGND VGND sky130_fd_pr__nfet_01v8 ad=0.0999 pd=0.985 as=0.1346 ps=1.15 w=0.64 l=0.15
X2170 VGND VDPWR VGND VGND sky130_fd_pr__nfet_01v8 ad=0.143 pd=1.62 as=0 ps=0 w=0.55 l=0.59
X2171 th_dif_sw_0.VCP single_9b_cdac_1.cdac_sw_9b_0.S[2] sky130_fd_pr__cap_mim_m3_1 l=2 w=2
X2172 a_12211_24100# sar9b_0.net15 VDPWR VDPWR sky130_fd_pr__pfet_01v8_hvt ad=0.0567 pd=0.69 as=0.0819 ps=0.81 w=0.42 l=0.15
X2173 a_11505_22406# a_11287_22164# VGND VGND sky130_fd_pr__nfet_01v8 ad=0.0999 pd=0.985 as=0.1346 ps=1.15 w=0.64 l=0.15
X2174 VDPWR single_9b_cdac_1.cdac_sw_9b_0.cdac_sw_3_1.nooverlap_clk_0.x8.A single_9b_cdac_1.cdac_sw_9b_0.cdac_sw_3_1.nooverlap_clk_0.x10.A VDPWR sky130_fd_pr__pfet_01v8 ad=0.3304 pd=2.83 as=0.168 ps=1.42 w=1.12 l=0.15
X2175 VGND single_9b_cdac_1.CF[7] single_9b_cdac_0.cdac_sw_9b_0.cdac_sw_3_7.nooverlap_clk_0.x3.Y VGND sky130_fd_pr__nfet_01v8_lvt ad=0.2627 pd=2.19 as=0.2109 ps=2.05 w=0.74 l=0.15
X2176 VGND VDPWR VGND VGND sky130_fd_pr__nfet_01v8 ad=0.143 pd=1.62 as=0 ps=0 w=0.55 l=0.59
X2177 VDPWR single_9b_cdac_0.cdac_sw_9b_0.cdac_sw_3_1.tg_sw_3_3.SWN single_9b_cdac_0.cdac_sw_9b_0.cdac_sw_3_1.tg_sw_3_3.SWP VDPWR sky130_fd_pr__pfet_01v8 ad=0.196 pd=1.47 as=0.168 ps=1.42 w=1.12 l=0.15
X2178 VGND VDPWR VGND VGND sky130_fd_pr__nfet_01v8 ad=0.143 pd=1.62 as=0 ps=0 w=0.55 l=0.59
X2179 VDPWR th_dif_sw_0.CKB a_21177_7457# VDPWR sky130_fd_pr__pfet_01v8 ad=0.168 pd=1.42 as=0.168 ps=1.42 w=1.12 l=0.15
X2180 single_9b_cdac_1.cdac_sw_9b_0.cdac_sw_3_2.tg_sw_3_3.SWN single_9b_cdac_1.cdac_sw_9b_0.cdac_sw_3_2.nooverlap_clk_0.x10.A VGND VGND sky130_fd_pr__nfet_01v8_lvt ad=0.1036 pd=1.02 as=0.1554 ps=1.16 w=0.74 l=0.15
X2181 VDPWR single_9b_cdac_1.cdac_sw_9b_0.cdac_sw_3_1.nooverlap_clk_0.CLKB0 single_9b_cdac_1.cdac_sw_9b_0.cdac_sw_3_1.nooverlap_clk_0.CLK0 VDPWR sky130_fd_pr__pfet_01v8 ad=0.3864 pd=2.93 as=0.168 ps=1.42 w=1.12 l=0.15
X2182 single_9b_cdac_0.cdac_sw_9b_0.cdac_sw_3_4.nooverlap_clk_0.CLK0 single_9b_cdac_0.cdac_sw_9b_0.cdac_sw_3_4.nooverlap_clk_0.CLKB0 VDPWR VDPWR sky130_fd_pr__pfet_01v8 ad=0.168 pd=1.42 as=0.168 ps=1.42 w=1.12 l=0.15
X2183 VGND VDPWR VGND VGND sky130_fd_pr__nfet_01v8 ad=0.143 pd=1.62 as=0 ps=0 w=0.55 l=0.59
X2184 VGND clk a_7345_21594# VGND sky130_fd_pr__nfet_01v8 ad=0.0588 pd=0.7 as=0.0588 ps=0.7 w=0.42 l=0.15
X2185 a_6534_21076# sar9b_0._09_ VGND VGND sky130_fd_pr__nfet_01v8 ad=0.091 pd=0.93 as=0.25837 ps=1.445 w=0.65 l=0.15
X2186 VGND a_6701_20506# sar9b_0.clknet_1_0__leaf_CLK VGND sky130_fd_pr__nfet_01v8 ad=0.0588 pd=0.7 as=0.0588 ps=0.7 w=0.42 l=0.15
X2187 a_9687_19042# sar9b_0.net5 VGND VGND sky130_fd_pr__nfet_01v8 ad=0.1092 pd=1.36 as=0.0567 ps=0.69 w=0.42 l=0.15
X2188 single_9b_cdac_1.cdac_sw_9b_0.cdac_sw_3_1.nooverlap_clk_0.x10.A single_9b_cdac_1.cdac_sw_9b_0.cdac_sw_3_1.nooverlap_clk_0.x8.A VDPWR VDPWR sky130_fd_pr__pfet_01v8 ad=0.168 pd=1.42 as=0.168 ps=1.42 w=1.12 l=0.15
X2189 a_8899_19822# a_8453_19450# a_8803_19822# VGND sky130_fd_pr__special_nfet_01v8 ad=0.1401 pd=1.1 as=0.0594 ps=0.69 w=0.36 l=0.15
X2190 th_dif_sw_0.VCP single_9b_cdac_1.cdac_sw_9b_0.S[1] sky130_fd_pr__cap_mim_m3_1 l=2 w=2
X2191 th_dif_sw_0.VCP single_9b_cdac_1.cdac_sw_9b_0.S[0] sky130_fd_pr__cap_mim_m3_1 l=2 w=2
X2192 th_dif_sw_0.VCN single_9b_cdac_0.cdac_sw_9b_0.S[0] sky130_fd_pr__cap_mim_m3_1 l=2 w=2
X2193 single_9b_cdac_1.cdac_sw_9b_0.cdac_sw_3_1.nooverlap_clk_0.CLK0 single_9b_cdac_1.cdac_sw_9b_0.cdac_sw_3_1.nooverlap_clk_0.CLKB0 VDPWR VDPWR sky130_fd_pr__pfet_01v8 ad=0.168 pd=1.42 as=0.196 ps=1.47 w=1.12 l=0.15
X2194 a_14143_25188# sar9b_0.net15 VDPWR VDPWR sky130_fd_pr__pfet_01v8_hvt ad=0.0567 pd=0.69 as=0.0819 ps=0.81 w=0.42 l=0.15
X2195 a_11392_23252# a_10477_23252# a_11045_23494# VGND sky130_fd_pr__special_nfet_01v8 ad=0.0711 pd=0.755 as=0.0999 ps=0.985 w=0.36 l=0.15
X2196 VDPWR single_9b_cdac_0.cdac_sw_9b_0.cdac_sw_3_4.nooverlap_clk_0.CLKB0 single_9b_cdac_0.cdac_sw_9b_0.cdac_sw_3_4.nooverlap_clk_0.CLK0 VDPWR sky130_fd_pr__pfet_01v8 ad=0.168 pd=1.42 as=0.168 ps=1.42 w=1.12 l=0.15
X2197 single_9b_cdac_0.cdac_sw_9b_0.cdac_sw_3_1.tg_sw_3_3.SWP single_9b_cdac_0.cdac_sw_9b_0.cdac_sw_3_1.tg_sw_3_3.SWN VGND VGND sky130_fd_pr__nfet_01v8_lvt ad=0.1036 pd=1.02 as=0.1295 ps=1.09 w=0.74 l=0.15
X2198 VDPWR sar9b_0.net11 a_8471_23252# VDPWR sky130_fd_pr__pfet_01v8_hvt ad=0.0864 pd=0.91 as=0.1664 ps=1.8 w=0.64 l=0.15
X2199 VGND VDPWR VGND VGND sky130_fd_pr__nfet_01v8 ad=0.143 pd=1.62 as=0 ps=0 w=0.55 l=0.59
X2200 VGND sar9b_0.net4 a_10311_19450# VGND sky130_fd_pr__nfet_01v8 ad=0.0567 pd=0.69 as=0.1092 ps=1.36 w=0.42 l=0.15
X2201 VDPWR VGND VDPWR VDPWR sky130_fd_pr__pfet_01v8_hvt ad=0.2262 pd=2.26 as=0 ps=0 w=0.87 l=0.59
X2202 th_dif_sw_0.VCP single_9b_cdac_1.cdac_sw_9b_0.S[0] sky130_fd_pr__cap_mim_m3_1 l=2 w=2
X2203 VDPWR single_9b_cdac_1.cdac_sw_9b_0.cdac_sw_3_1.nooverlap_clk_0.x8.A single_9b_cdac_1.cdac_sw_9b_0.cdac_sw_3_1.nooverlap_clk_0.x10.A VDPWR sky130_fd_pr__pfet_01v8 ad=0.168 pd=1.42 as=0.168 ps=1.42 w=1.12 l=0.15
X2204 ua[0] single_9b_cdac_0.cdac_sw_9b_0.cdac_sw_3_8.tg_sw_3_3.SWN ua[0] VGND sky130_fd_pr__nfet_01v8 ad=0.145 pd=1.58 as=0 ps=0 w=0.5 l=0.5
X2205 VDPWR ui_in[0] a_5343_25972# VDPWR sky130_fd_pr__pfet_01v8_hvt ad=0.165 pd=1.33 as=0.265 ps=2.53 w=1 l=0.15
X2206 a_11554_19444# a_10477_19450# a_11392_19822# VDPWR sky130_fd_pr__pfet_01v8_hvt ad=0.0567 pd=0.69 as=0.0588 ps=0.7 w=0.42 l=0.15
X2207 VDPWR single_9b_cdac_1.cdac_sw_9b_0.cdac_sw_3_0.tg_sw_3_3.SWN single_9b_cdac_1.cdac_sw_9b_0.cdac_sw_3_0.tg_sw_3_3.SWP VDPWR sky130_fd_pr__pfet_01v8 ad=0.196 pd=1.47 as=0.168 ps=1.42 w=1.12 l=0.15
X2208 th_dif_sw_0.VCP single_9b_cdac_1.cdac_sw_9b_0.S[0] sky130_fd_pr__cap_mim_m3_1 l=2 w=2
X2209 a_39616_17740# single_9b_cdac_1.cdac_sw_9b_0.cdac_sw_3_5.nooverlap_clk_0.CLK0 single_9b_cdac_1.cdac_sw_9b_0.S[5] VGND sky130_fd_pr__nfet_01v8 ad=0.145 pd=1.58 as=0.145 ps=1.58 w=0.5 l=0.5
X2210 single_9b_cdac_1.cdac_sw_9b_0.cdac_sw_3_1.nooverlap_clk_0.x10.A single_9b_cdac_1.cdac_sw_9b_0.cdac_sw_3_1.nooverlap_clk_0.x8.A VDPWR VDPWR sky130_fd_pr__pfet_01v8 ad=0.168 pd=1.42 as=0.3304 ps=2.83 w=1.12 l=0.15
X2211 single_9b_cdac_0.cdac_sw_9b_0.S[5] single_9b_cdac_0.cdac_sw_9b_0.cdac_sw_3_5.tg_sw_3_3.SWN ua[0] VDPWR sky130_fd_pr__pfet_01v8 ad=0.435 pd=3.58 as=0.435 ps=3.58 w=1.5 l=0.5
X2212 VGND a_6007_27302# a_5968_27176# VGND sky130_fd_pr__nfet_01v8 ad=0.0567 pd=0.69 as=0.1092 ps=1.36 w=0.42 l=0.15
X2213 VGND single_9b_cdac_0.SW[2] a_54032_26990# VGND sky130_fd_pr__nfet_01v8 ad=0.145 pd=1.58 as=0.145 ps=1.58 w=0.5 l=0.5
X2214 a_5884_21326# sar9b_0._10_ a_5793_21326# VDPWR sky130_fd_pr__pfet_01v8_hvt ad=0.195 pd=1.39 as=0.1525 ps=1.305 w=1 l=0.15
X2215 VDPWR single_9b_cdac_1.cdac_sw_9b_0.cdac_sw_3_3.nooverlap_clk_0.x10.A single_9b_cdac_1.cdac_sw_9b_0.cdac_sw_3_3.tg_sw_3_3.SWN VDPWR sky130_fd_pr__pfet_01v8 ad=0.196 pd=1.47 as=0.168 ps=1.42 w=1.12 l=0.15
X2216 a_6726_27060# a_6007_27302# a_6163_27034# VGND sky130_fd_pr__special_nfet_01v8 ad=0.066 pd=0.745 as=0.0594 ps=0.69 w=0.36 l=0.15
X2217 single_9b_cdac_1.cdac_sw_9b_0.cdac_sw_3_0.tg_sw_3_3.SWP single_9b_cdac_1.cdac_sw_9b_0.cdac_sw_3_0.tg_sw_3_3.SWN VDPWR VDPWR sky130_fd_pr__pfet_01v8 ad=0.168 pd=1.42 as=0.3304 ps=2.83 w=1.12 l=0.15
X2218 th_dif_sw_0.VCN single_9b_cdac_0.cdac_sw_9b_0.S[2] sky130_fd_pr__cap_mim_m3_1 l=2 w=2
X2219 VGND clk a_15197_10290# VGND sky130_fd_pr__nfet_01v8_lvt ad=0.15535 pd=1.17 as=0.1376 ps=1.14 w=0.64 l=0.15
X2220 single_9b_cdac_1.cdac_sw_9b_0.cdac_sw_3_3.nooverlap_clk_0.CLK0 single_9b_cdac_1.cdac_sw_9b_0.cdac_sw_3_3.nooverlap_clk_0.CLKB0 VGND VGND sky130_fd_pr__nfet_01v8_lvt ad=0.1036 pd=1.02 as=0.1554 ps=1.16 w=0.74 l=0.15
X2221 th_dif_sw_0.VCN single_9b_cdac_0.cdac_sw_9b_0.S[0] sky130_fd_pr__cap_mim_m3_1 l=2 w=2
X2222 VDPWR sar9b_0._07_ sar9b_0._10_ VDPWR sky130_fd_pr__pfet_01v8_hvt ad=0.26 pd=2.52 as=0.135 ps=1.27 w=1 l=0.15
X2223 single_9b_cdac_1.cdac_sw_9b_0.cdac_sw_3_3.tg_sw_3_3.SWN single_9b_cdac_1.cdac_sw_9b_0.cdac_sw_3_3.nooverlap_clk_0.x10.A VDPWR VDPWR sky130_fd_pr__pfet_01v8 ad=0.168 pd=1.42 as=0.168 ps=1.42 w=1.12 l=0.15
X2224 th_dif_sw_0.th_sw_1.CKB a_21177_7457# VGND VGND sky130_fd_pr__nfet_01v8_lvt ad=0.1036 pd=1.02 as=0.1036 ps=1.02 w=0.74 l=0.15
X2225 a_12772_26350# a_11857_25978# a_12425_25946# VGND sky130_fd_pr__special_nfet_01v8 ad=0.0711 pd=0.755 as=0.0999 ps=0.985 w=0.36 l=0.15
X2226 a_10371_21050# sar9b_0.net15 VDPWR VDPWR sky130_fd_pr__pfet_01v8_hvt ad=0.0567 pd=0.69 as=0.0819 ps=0.81 w=0.42 l=0.15
X2227 VGND single_9b_cdac_1.cdac_sw_9b_0.cdac_sw_3_5.tg_sw_3_3.SWN single_9b_cdac_1.cdac_sw_9b_0.cdac_sw_3_5.tg_sw_3_3.SWP VGND sky130_fd_pr__nfet_01v8_lvt ad=0.1295 pd=1.09 as=0.1036 ps=1.02 w=0.74 l=0.15
X2228 th_dif_sw_0.VCN single_9b_cdac_0.cdac_sw_9b_0.S[1] sky130_fd_pr__cap_mim_m3_1 l=2 w=2
X2229 th_dif_sw_0.VCP single_9b_cdac_1.cdac_sw_9b_0.S[2] sky130_fd_pr__cap_mim_m3_1 l=2 w=2
X2230 th_dif_sw_0.VCP single_9b_cdac_1.cdac_sw_9b_0.S[1] sky130_fd_pr__cap_mim_m3_1 l=2 w=2
X2231 VDPWR single_9b_cdac_0.cdac_sw_9b_0.cdac_sw_3_6.nooverlap_clk_0.x10.A single_9b_cdac_0.cdac_sw_9b_0.cdac_sw_3_6.tg_sw_3_3.SWN VDPWR sky130_fd_pr__pfet_01v8 ad=0.196 pd=1.47 as=0.168 ps=1.42 w=1.12 l=0.15
X2232 a_8085_23802# a_7919_23802# VDPWR VDPWR sky130_fd_pr__pfet_01v8_hvt ad=0.1664 pd=1.8 as=0.0864 ps=0.91 w=0.64 l=0.15
X2233 single_9b_cdac_1.cdac_sw_9b_0.cdac_sw_3_7.nooverlap_clk_0.CLKB0 single_9b_cdac_1.cdac_sw_9b_0.cdac_sw_3_7.nooverlap_clk_0.sky130_fd_sc_hs__inv_8_0.A VGND VGND sky130_fd_pr__nfet_01v8_lvt ad=0.1036 pd=1.02 as=0.1554 ps=1.16 w=0.74 l=0.15
X2234 single_9b_cdac_1.cdac_sw_9b_0.S[5] single_9b_cdac_1.cdac_sw_9b_0.cdac_sw_3_5.tg_sw_3_3.SWN ua[0] VDPWR sky130_fd_pr__pfet_01v8 ad=0.435 pd=3.58 as=0.435 ps=3.58 w=1.5 l=0.5
X2235 th_dif_sw_0.VCN single_9b_cdac_0.cdac_sw_9b_0.S[0] sky130_fd_pr__cap_mim_m3_1 l=2 w=2
X2236 a_9552_23252# a_8471_23252# a_9205_23494# VDPWR sky130_fd_pr__pfet_01v8_hvt ad=0.0588 pd=0.7 as=0.12915 ps=1.185 w=0.42 l=0.15
X2237 VDPWR single_9b_cdac_1.cdac_sw_9b_0.cdac_sw_3_3.nooverlap_clk_0.x10.A single_9b_cdac_1.cdac_sw_9b_0.cdac_sw_3_3.tg_sw_3_3.SWN VDPWR sky130_fd_pr__pfet_01v8 ad=0.168 pd=1.42 as=0.168 ps=1.42 w=1.12 l=0.15
X2238 th_dif_sw_0.VCP single_9b_cdac_1.cdac_sw_9b_0.S[0] sky130_fd_pr__cap_mim_m3_1 l=2 w=2
X2239 a_9281_26516# a_9115_26516# VGND VGND sky130_fd_pr__nfet_01v8 ad=0.1092 pd=1.36 as=0.0567 ps=0.69 w=0.42 l=0.15
X2240 ua[0] single_9b_cdac_0.cdac_sw_9b_0.cdac_sw_3_6.tg_sw_3_3.SWN ua[0] VGND sky130_fd_pr__nfet_01v8 ad=0.145 pd=1.58 as=0 ps=0 w=0.5 l=0.5
X2241 VGND single_9b_cdac_0.cdac_sw_9b_0.cdac_sw_3_0.nooverlap_clk_0.x10.A single_9b_cdac_0.cdac_sw_9b_0.cdac_sw_3_0.tg_sw_3_3.SWN VGND sky130_fd_pr__nfet_01v8_lvt ad=0.2109 pd=2.05 as=0.1036 ps=1.02 w=0.74 l=0.15
X2242 th_dif_sw_0.VCP single_9b_cdac_1.cdac_sw_9b_0.S[1] sky130_fd_pr__cap_mim_m3_1 l=2 w=2
X2243 single_9b_cdac_0.cdac_sw_9b_0.cdac_sw_3_6.tg_sw_3_3.SWN single_9b_cdac_0.cdac_sw_9b_0.cdac_sw_3_6.nooverlap_clk_0.x10.A VDPWR VDPWR sky130_fd_pr__pfet_01v8 ad=0.168 pd=1.42 as=0.168 ps=1.42 w=1.12 l=0.15
X2244 th_dif_sw_0.VCN single_9b_cdac_0.cdac_sw_9b_0.S[0] sky130_fd_pr__cap_mim_m3_1 l=2 w=2
X2245 single_9b_cdac_0.cdac_sw_9b_0.cdac_sw_3_8.nooverlap_clk_0.x10.A single_9b_cdac_0.cdac_sw_9b_0.cdac_sw_3_8.nooverlap_clk_0.x8.A VGND VGND sky130_fd_pr__nfet_01v8_lvt ad=0.1184 pd=1.06 as=0.1221 ps=1.07 w=0.74 l=0.15
X2246 single_9b_cdac_0.cdac_sw_9b_0.S[6] single_9b_cdac_0.cdac_sw_9b_0.cdac_sw_3_6.tg_sw_3_3.SWP single_9b_cdac_0.cdac_sw_9b_0.S[6] VDPWR sky130_fd_pr__pfet_01v8 ad=0.435 pd=3.58 as=0 ps=0 w=1.5 l=0.5
X2247 single_9b_cdac_1.cdac_sw_9b_0.cdac_sw_3_3.tg_sw_3_3.SWN single_9b_cdac_1.cdac_sw_9b_0.cdac_sw_3_3.nooverlap_clk_0.x10.A VDPWR VDPWR sky130_fd_pr__pfet_01v8 ad=0.168 pd=1.42 as=0.196 ps=1.47 w=1.12 l=0.15
X2248 th_dif_sw_0.VCP single_9b_cdac_1.cdac_sw_9b_0.S[0] sky130_fd_pr__cap_mim_m3_1 l=2 w=2
X2249 th_dif_sw_0.VCN single_9b_cdac_0.cdac_sw_9b_0.S[1] sky130_fd_pr__cap_mim_m3_1 l=2 w=2
X2250 VGND single_9b_cdac_0.cdac_sw_9b_0.cdac_sw_3_6.nooverlap_clk_0.CLKB0 single_9b_cdac_0.cdac_sw_9b_0.cdac_sw_3_6.nooverlap_clk_0.CLK0 VGND sky130_fd_pr__nfet_01v8_lvt ad=0.1036 pd=1.02 as=0.1036 ps=1.02 w=0.74 l=0.15
X2251 VDPWR VGND VDPWR VDPWR sky130_fd_pr__pfet_01v8_hvt ad=0.2262 pd=2.26 as=0 ps=0 w=0.87 l=0.59
X2252 a_7345_21594# clk VGND VGND sky130_fd_pr__nfet_01v8 ad=0.0588 pd=0.7 as=0.0588 ps=0.7 w=0.42 l=0.15
X2253 a_6315_21050# sar9b_0.net15 a_6534_21076# VGND sky130_fd_pr__nfet_01v8 ad=0.08775 pd=0.92 as=0.091 ps=0.93 w=0.65 l=0.15
X2254 VDPWR a_6930_20241# a_6843_20354# VDPWR sky130_fd_pr__pfet_01v8_hvt ad=0.1218 pd=1.42 as=0.09135 ps=0.855 w=0.42 l=0.15
X2255 single_9b_cdac_1.cdac_sw_9b_0.S[8] single_9b_cdac_1.cdac_sw_9b_0.cdac_sw_3_8.nooverlap_clk_0.CLKB0 a_24332_16877# VDPWR sky130_fd_pr__pfet_01v8 ad=0.435 pd=3.58 as=0.435 ps=3.58 w=1.5 l=0.5
X2256 th_dif_sw_0.VCN single_9b_cdac_0.cdac_sw_9b_0.S[2] sky130_fd_pr__cap_mim_m3_1 l=2 w=2
X2257 VGND sar9b_0.net35 a_6726_27060# VGND sky130_fd_pr__nfet_01v8 ad=0.2205 pd=1.89 as=0.066 ps=0.745 w=0.42 l=0.15
X2258 single_9b_cdac_0.cdac_sw_9b_0.S[1] single_9b_cdac_0.cdac_sw_9b_0.cdac_sw_3_1.tg_sw_3_3.SWN single_9b_cdac_0.cdac_sw_9b_0.S[1] VGND sky130_fd_pr__nfet_01v8 ad=0.145 pd=1.58 as=2.32 ps=25.28 w=0.5 l=0.5
X2259 single_9b_cdac_0.cdac_sw_9b_0.cdac_sw_3_1.nooverlap_clk_0.CLKB0 single_9b_cdac_0.cdac_sw_9b_0.cdac_sw_3_1.nooverlap_clk_0.sky130_fd_sc_hs__inv_8_0.A VGND VGND sky130_fd_pr__nfet_01v8_lvt ad=0.1036 pd=1.02 as=0.1036 ps=1.02 w=0.74 l=0.15
X2260 a_5945_26191# sar9b_0.net17 VDPWR VDPWR sky130_fd_pr__pfet_01v8_hvt ad=0.2054 pd=2.1 as=0.11455 ps=1.08 w=0.79 l=0.15
X2261 VDPWR th_dif_sw_0.CK a_9132_7271# VDPWR sky130_fd_pr__pfet_01v8 ad=0.168 pd=1.42 as=0.168 ps=1.42 w=1.12 l=0.15
X2262 VDPWR single_9b_cdac_0.cdac_sw_9b_0.cdac_sw_3_6.nooverlap_clk_0.x10.A single_9b_cdac_0.cdac_sw_9b_0.cdac_sw_3_6.tg_sw_3_3.SWN VDPWR sky130_fd_pr__pfet_01v8 ad=0.168 pd=1.42 as=0.168 ps=1.42 w=1.12 l=0.15
X2263 sar9b_0.net29 a_14143_22138# VGND VGND sky130_fd_pr__nfet_01v8 ad=0.169 pd=1.82 as=0.2087 ps=2.02 w=0.65 l=0.15
X2264 single_9b_cdac_1.cdac_sw_9b_0.cdac_sw_3_3.nooverlap_clk_0.x10.A single_9b_cdac_1.cdac_sw_9b_0.cdac_sw_3_3.nooverlap_clk_0.x8.A VGND VGND sky130_fd_pr__nfet_01v8_lvt ad=0.1036 pd=1.02 as=0.1221 ps=1.07 w=0.74 l=0.15
X2265 th_dif_sw_0.VCP single_9b_cdac_1.cdac_sw_9b_0.S[0] sky130_fd_pr__cap_mim_m3_1 l=2 w=2
X2266 VGND single_9b_cdac_0.SW[3] a_49221_26990# VGND sky130_fd_pr__nfet_01v8 ad=0.145 pd=1.58 as=0.145 ps=1.58 w=0.5 l=0.5
X2267 a_8800_26338# sar9b_0.net40 VDPWR VDPWR sky130_fd_pr__pfet_01v8_hvt ad=0.0651 pd=0.73 as=0.1092 ps=1.36 w=0.42 l=0.15
X2268 sar9b_0.net42 a_11567_23226# VDPWR VDPWR sky130_fd_pr__pfet_01v8_hvt ad=0.26 pd=2.52 as=0.3012 ps=2.66 w=1 l=0.15
X2269 VDPWR a_9132_7271# th_dif_sw_0.th_sw_1.CK VDPWR sky130_fd_pr__pfet_01v8 ad=0.196 pd=1.47 as=0.168 ps=1.42 w=1.12 l=0.15
X2270 VDPWR single_9b_cdac_0.cdac_sw_9b_0.cdac_sw_3_6.nooverlap_clk_0.sky130_fd_sc_hs__inv_8_0.A single_9b_cdac_0.cdac_sw_9b_0.cdac_sw_3_6.nooverlap_clk_0.CLKB0 VDPWR sky130_fd_pr__pfet_01v8 ad=0.3304 pd=2.83 as=0.168 ps=1.42 w=1.12 l=0.15
X2271 single_9b_cdac_0.cdac_sw_9b_0.S[6] single_9b_cdac_0.cdac_sw_9b_0.cdac_sw_3_6.tg_sw_3_3.SWN single_9b_cdac_0.cdac_sw_9b_0.S[6] VGND sky130_fd_pr__nfet_01v8 ad=0.145 pd=1.58 as=0 ps=0 w=0.5 l=0.5
X2272 VGND VDPWR VGND VGND sky130_fd_pr__nfet_01v8 ad=0.143 pd=1.62 as=0 ps=0 w=0.55 l=0.59
X2273 VGND single_9b_cdac_1.SW[7] a_30012_17740# VGND sky130_fd_pr__nfet_01v8 ad=0.145 pd=1.58 as=0.145 ps=1.58 w=0.5 l=0.5
X2274 VDPWR VGND VDPWR VDPWR sky130_fd_pr__pfet_01v8_hvt ad=0.2262 pd=2.26 as=0 ps=0 w=0.87 l=0.59
X2275 th_dif_sw_0.VCN single_9b_cdac_0.cdac_sw_9b_0.S[0] sky130_fd_pr__cap_mim_m3_1 l=2 w=2
X2276 single_9b_cdac_0.cdac_sw_9b_0.cdac_sw_3_3.tg_sw_3_3.SWP single_9b_cdac_0.cdac_sw_9b_0.cdac_sw_3_3.tg_sw_3_3.SWN VGND VGND sky130_fd_pr__nfet_01v8_lvt ad=0.1036 pd=1.02 as=0.1554 ps=1.16 w=0.74 l=0.15
X2277 a_11195_25428# a_10845_25428# a_11100_25428# VDPWR sky130_fd_pr__pfet_01v8_hvt ad=0.07245 pd=0.765 as=0.0651 ps=0.73 w=0.42 l=0.15
X2278 th_dif_sw_0.VCP single_9b_cdac_1.cdac_sw_9b_0.S[0] sky130_fd_pr__cap_mim_m3_1 l=2 w=2
X2279 VGND single_9b_cdac_0.cdac_sw_9b_0.cdac_sw_3_7.nooverlap_clk_0.x3.Y a_30717_29917# VGND sky130_fd_pr__nfet_01v8_lvt ad=0.2109 pd=2.05 as=0.0888 ps=0.98 w=0.74 l=0.15
X2280 single_9b_cdac_1.cdac_sw_9b_0.cdac_sw_3_3.tg_sw_3_3.SWN single_9b_cdac_1.cdac_sw_9b_0.cdac_sw_3_3.nooverlap_clk_0.x10.A VGND VGND sky130_fd_pr__nfet_01v8_lvt ad=0.1036 pd=1.02 as=0.1295 ps=1.09 w=0.74 l=0.15
X2281 single_9b_cdac_0.cdac_sw_9b_0.cdac_sw_3_6.nooverlap_clk_0.CLKB0 single_9b_cdac_0.cdac_sw_9b_0.cdac_sw_3_6.nooverlap_clk_0.sky130_fd_sc_hs__inv_8_0.A VDPWR VDPWR sky130_fd_pr__pfet_01v8 ad=0.168 pd=1.42 as=0.196 ps=1.47 w=1.12 l=0.15
X2282 a_6224_25428# sar9b_0.net37 VGND VGND sky130_fd_pr__nfet_01v8 ad=0.066 pd=0.745 as=0.2205 ps=1.89 w=0.42 l=0.15
X2283 VDPWR VGND VDPWR VDPWR sky130_fd_pr__pfet_01v8_hvt ad=0.2262 pd=2.26 as=0 ps=0 w=0.87 l=0.59
X2284 th_dif_sw_0.VCP single_9b_cdac_1.cdac_sw_9b_0.S[0] sky130_fd_pr__cap_mim_m3_1 l=2 w=2
X2285 VGND a_9809_27279# uo_out[5] VGND sky130_fd_pr__nfet_01v8 ad=0.0754 pd=0.81 as=0.1352 ps=1.56 w=0.52 l=0.15
X2286 single_9b_cdac_0.cdac_sw_9b_0.S[0] single_9b_cdac_0.cdac_sw_9b_0.cdac_sw_3_2.nooverlap_clk_0.CLKB0 a_62748_26999# VDPWR sky130_fd_pr__pfet_01v8 ad=0.435 pd=3.58 as=0.435 ps=3.58 w=1.5 l=0.5
X2287 a_15197_10290# tdc_0.delay_gate_ori_0.sky130_fd_sc_hs__and2_1_0.A a_15151_10456# VGND sky130_fd_pr__nfet_01v8_lvt ad=0.1376 pd=1.14 as=0.1824 ps=1.85 w=0.64 l=0.15
X2288 a_7363_23502# sar9b_0.clk_div_0.COUNT\[1\] VDPWR VDPWR sky130_fd_pr__pfet_01v8_hvt ad=0.265 pd=2.53 as=0.14 ps=1.28 w=1 l=0.15
X2289 th_dif_sw_0.VCP single_9b_cdac_1.cdac_sw_9b_0.S[1] sky130_fd_pr__cap_mim_m3_1 l=2 w=2
X2290 dw_12589_1395# a_10166_3438# sky130_fd_pr__cap_mim_m3_1 l=2 w=2
X2291 VGND sar9b_0.net34 a_14451_27060# VGND sky130_fd_pr__nfet_01v8 ad=0.0754 pd=0.81 as=0.1352 ps=1.56 w=0.52 l=0.15
X2292 single_9b_cdac_0.cdac_sw_9b_0.cdac_sw_3_1.tg_sw_3_3.SWN single_9b_cdac_0.cdac_sw_9b_0.cdac_sw_3_1.nooverlap_clk_0.x10.A VGND VGND sky130_fd_pr__nfet_01v8_lvt ad=0.1036 pd=1.02 as=0.1554 ps=1.16 w=0.74 l=0.15
X2293 VGND VDPWR VGND VGND sky130_fd_pr__nfet_01v8 ad=0.143 pd=1.62 as=0 ps=0 w=0.55 l=0.59
X2294 ua[0] single_9b_cdac_1.cdac_sw_9b_0.cdac_sw_3_4.tg_sw_3_3.SWN ua[0] VGND sky130_fd_pr__nfet_01v8 ad=0.145 pd=1.58 as=0 ps=0 w=0.5 l=0.5
X2295 th_dif_sw_0.VCP single_9b_cdac_1.cdac_sw_9b_0.S[1] sky130_fd_pr__cap_mim_m3_1 l=2 w=2
X2296 dw_12589_1395# a_10166_3438# sky130_fd_pr__cap_mim_m3_1 l=2 w=2
X2297 th_dif_sw_0.VCP single_9b_cdac_1.cdac_sw_9b_0.S[4] sky130_fd_pr__cap_mim_m3_1 l=2 w=2
X2298 VDPWR single_9b_cdac_0.cdac_sw_9b_0.cdac_sw_3_4.nooverlap_clk_0.sky130_fd_sc_hs__nand2_1_0.Y single_9b_cdac_0.cdac_sw_9b_0.cdac_sw_3_4.nooverlap_clk_0.sky130_fd_sc_hs__inv_1_1.A VDPWR sky130_fd_pr__pfet_01v8 ad=0.3864 pd=2.93 as=0.3304 ps=2.83 w=1.12 l=0.15
X2299 single_9b_cdac_0.cdac_sw_9b_0.cdac_sw_3_2.nooverlap_clk_0.CLK0 single_9b_cdac_0.cdac_sw_9b_0.cdac_sw_3_2.nooverlap_clk_0.CLKB0 VDPWR VDPWR sky130_fd_pr__pfet_01v8 ad=0.168 pd=1.42 as=0.196 ps=1.47 w=1.12 l=0.15
X2300 th_dif_sw_0.VCP single_9b_cdac_1.cdac_sw_9b_0.S[1] sky130_fd_pr__cap_mim_m3_1 l=2 w=2
X2301 th_dif_sw_0.th_sw_1.CKB a_21177_7457# VDPWR VDPWR sky130_fd_pr__pfet_01v8 ad=0.168 pd=1.42 as=0.168 ps=1.42 w=1.12 l=0.15
X2302 VGND sar9b_0.FINAL a_8379_25978# VGND sky130_fd_pr__nfet_01v8 ad=0.0567 pd=0.69 as=0.1092 ps=1.36 w=0.42 l=0.15
X2303 VGND sar9b_0.clk_div_0.COUNT\[3\] a_7039_22138# VGND sky130_fd_pr__nfet_01v8 ad=0.06195 pd=0.715 as=0.1092 ps=1.36 w=0.42 l=0.15
X2304 th_dif_sw_0.VCN single_9b_cdac_0.cdac_sw_9b_0.S[0] sky130_fd_pr__cap_mim_m3_1 l=2 w=2
X2305 VGND single_9b_cdac_1.cdac_sw_9b_0.cdac_sw_3_5.nooverlap_clk_0.sky130_fd_sc_hs__inv_8_0.A single_9b_cdac_1.cdac_sw_9b_0.cdac_sw_3_5.nooverlap_clk_0.CLKB0 VGND sky130_fd_pr__nfet_01v8_lvt ad=0.2146 pd=2.06 as=0.1036 ps=1.02 w=0.74 l=0.15
X2306 th_dif_sw_0.VCP single_9b_cdac_1.cdac_sw_9b_0.S[0] sky130_fd_pr__cap_mim_m3_1 l=2 w=2
X2307 th_dif_sw_0.VCP single_9b_cdac_1.cdac_sw_9b_0.S[3] sky130_fd_pr__cap_mim_m3_1 l=2 w=2
X2308 VDPWR VGND VDPWR VDPWR sky130_fd_pr__pfet_01v8_hvt ad=0.2262 pd=2.26 as=0 ps=0 w=0.87 l=0.59
X2309 single_9b_cdac_0.SW[1] a_13899_24340# VDPWR VDPWR sky130_fd_pr__pfet_01v8_hvt ad=0.2054 pd=2.1 as=0.11455 ps=1.08 w=0.79 l=0.15
X2310 th_dif_sw_0.VCP single_9b_cdac_1.cdac_sw_9b_0.S[0] sky130_fd_pr__cap_mim_m3_1 l=2 w=2
X2311 th_dif_sw_0.VCP single_9b_cdac_1.cdac_sw_9b_0.S[1] sky130_fd_pr__cap_mim_m3_1 l=2 w=2
X2312 dw_12589_1395# th_dif_sw_0.th_sw_1.th_sw_main_0.VGS VDPWR dw_12589_1395# sky130_fd_pr__pfet_01v8 ad=1.16 pd=8.58 as=1.16 ps=8.58 w=4 l=0.15
X2313 a_14230_24162# sar9b_0.net15 VGND VGND sky130_fd_pr__nfet_01v8 ad=0.06405 pd=0.725 as=0.12495 ps=1.015 w=0.42 l=0.15
X2314 th_dif_sw_0.VCN single_9b_cdac_0.cdac_sw_9b_0.S[2] sky130_fd_pr__cap_mim_m3_1 l=2 w=2
X2315 a_9405_18900# a_9370_19152# a_9167_18874# VGND sky130_fd_pr__nfet_01v8 ad=0.06405 pd=0.725 as=0.1092 ps=1.36 w=0.42 l=0.15
X2316 VDPWR VGND VDPWR VDPWR sky130_fd_pr__pfet_01v8_hvt ad=0.2262 pd=2.26 as=0 ps=0 w=0.87 l=0.59
X2317 th_dif_sw_0.VCN single_9b_cdac_0.cdac_sw_9b_0.S[0] sky130_fd_pr__cap_mim_m3_1 l=2 w=2
X2318 VDPWR single_9b_cdac_0.cdac_sw_9b_0.cdac_sw_3_0.nooverlap_clk_0.sky130_fd_sc_hs__inv_8_0.A single_9b_cdac_0.cdac_sw_9b_0.cdac_sw_3_0.nooverlap_clk_0.CLKB0 VDPWR sky130_fd_pr__pfet_01v8 ad=0.196 pd=1.47 as=0.168 ps=1.42 w=1.12 l=0.15
X2319 VGND VDPWR VGND VGND sky130_fd_pr__nfet_01v8 ad=0.143 pd=1.62 as=0 ps=0 w=0.55 l=0.59
X2320 a_13968_19822# a_13053_19450# a_13621_19418# VGND sky130_fd_pr__special_nfet_01v8 ad=0.0711 pd=0.755 as=0.0999 ps=0.985 w=0.36 l=0.15
X2321 VGND single_9b_cdac_1.cdac_sw_9b_0.cdac_sw_3_8.tg_sw_3_3.SWN single_9b_cdac_1.cdac_sw_9b_0.cdac_sw_3_8.tg_sw_3_3.SWP VGND sky130_fd_pr__nfet_01v8_lvt ad=0.1554 pd=1.16 as=0.1036 ps=1.02 w=0.74 l=0.15
X2322 VDPWR single_9b_cdac_1.cdac_sw_9b_0.cdac_sw_3_1.nooverlap_clk_0.x10.A single_9b_cdac_1.cdac_sw_9b_0.cdac_sw_3_1.tg_sw_3_3.SWN VDPWR sky130_fd_pr__pfet_01v8 ad=0.196 pd=1.47 as=0.168 ps=1.42 w=1.12 l=0.15
X2323 VGND sar9b_0.net3 a_11733_26516# VGND sky130_fd_pr__nfet_01v8 ad=0.1346 pd=1.15 as=0.0441 ps=0.63 w=0.42 l=0.15
X2324 single_9b_cdac_1.cdac_sw_9b_0.cdac_sw_3_4.nooverlap_clk_0.x4.A single_9b_cdac_1.cdac_sw_9b_0.cdac_sw_3_4.nooverlap_clk_0.x1.A a_49926_15495# VGND sky130_fd_pr__nfet_01v8_lvt ad=0.2109 pd=2.05 as=0.0888 ps=0.98 w=0.74 l=0.15
X2325 a_6059_26882# a_5435_26516# a_5951_26516# VDPWR sky130_fd_pr__pfet_01v8_hvt ad=0.1155 pd=0.97 as=0.07245 ps=0.765 w=0.42 l=0.15
X2326 single_9b_cdac_0.cdac_sw_9b_0.cdac_sw_3_0.nooverlap_clk_0.CLK0 single_9b_cdac_0.cdac_sw_9b_0.cdac_sw_3_0.nooverlap_clk_0.CLKB0 VGND VGND sky130_fd_pr__nfet_01v8_lvt ad=0.1036 pd=1.02 as=0.2146 ps=2.06 w=0.74 l=0.15
X2327 single_9b_cdac_0.cdac_sw_9b_0.cdac_sw_3_0.nooverlap_clk_0.CLKB0 single_9b_cdac_0.cdac_sw_9b_0.cdac_sw_3_0.nooverlap_clk_0.sky130_fd_sc_hs__inv_8_0.A VDPWR VDPWR sky130_fd_pr__pfet_01v8 ad=0.168 pd=1.42 as=0.168 ps=1.42 w=1.12 l=0.15
X2328 VGND VDPWR VGND VGND sky130_fd_pr__nfet_01v8 ad=0.143 pd=1.62 as=0 ps=0 w=0.55 l=0.59
X2329 th_dif_sw_0.VCP single_9b_cdac_1.cdac_sw_9b_0.S[0] sky130_fd_pr__cap_mim_m3_1 l=2 w=2
X2330 VGND th_dif_sw_0.th_sw_1.CK a_10482_3438# VGND sky130_fd_pr__nfet_01v8 ad=2.175 pd=15.58 as=2.175 ps=15.58 w=7.5 l=0.15
X2331 a_36555_29911# single_9b_cdac_0.cdac_sw_9b_0.cdac_sw_3_6.nooverlap_clk_0.x8.A VGND VGND sky130_fd_pr__nfet_01v8_lvt ad=0.0888 pd=0.98 as=0.2109 ps=2.05 w=0.74 l=0.15
X2332 single_9b_cdac_0.cdac_sw_9b_0.cdac_sw_3_4.nooverlap_clk_0.CLK0 single_9b_cdac_0.cdac_sw_9b_0.cdac_sw_3_4.nooverlap_clk_0.CLKB0 VDPWR VDPWR sky130_fd_pr__pfet_01v8 ad=0.168 pd=1.42 as=0.3864 ps=2.93 w=1.12 l=0.15
X2333 single_9b_cdac_0.cdac_sw_9b_0.S[0] single_9b_cdac_0.cdac_sw_9b_0.cdac_sw_3_2.tg_sw_3_3.SWN single_9b_cdac_0.cdac_sw_9b_0.S[0] VGND sky130_fd_pr__nfet_01v8 ad=0.145 pd=1.58 as=0 ps=0 w=0.5 l=0.5
X2334 a_9670_22708# a_8951_22950# a_9107_22682# VGND sky130_fd_pr__special_nfet_01v8 ad=0.066 pd=0.745 as=0.0594 ps=0.69 w=0.36 l=0.15
X2335 single_9b_cdac_1.cdac_sw_9b_0.S[3] single_9b_cdac_1.cdac_sw_9b_0.cdac_sw_3_4.tg_sw_3_3.SWP ua[0] VGND sky130_fd_pr__nfet_01v8 ad=0.145 pd=1.58 as=0.145 ps=1.58 w=0.5 l=0.5
X2336 VDPWR single_9b_cdac_0.cdac_sw_9b_0.cdac_sw_3_5.nooverlap_clk_0.sky130_fd_sc_hs__inv_8_0.A single_9b_cdac_0.cdac_sw_9b_0.cdac_sw_3_5.nooverlap_clk_0.CLKB0 VDPWR sky130_fd_pr__pfet_01v8 ad=0.3304 pd=2.83 as=0.168 ps=1.42 w=1.12 l=0.15
X2337 single_9b_cdac_1.cdac_sw_9b_0.cdac_sw_3_6.nooverlap_clk_0.CLKB0 single_9b_cdac_1.cdac_sw_9b_0.cdac_sw_3_6.nooverlap_clk_0.sky130_fd_sc_hs__inv_8_0.A VDPWR VDPWR sky130_fd_pr__pfet_01v8 ad=0.168 pd=1.42 as=0.3304 ps=2.83 w=1.12 l=0.15
X2338 VDPWR single_9b_cdac_0.cdac_sw_9b_0.cdac_sw_3_0.nooverlap_clk_0.sky130_fd_sc_hs__inv_8_0.A single_9b_cdac_0.cdac_sw_9b_0.cdac_sw_3_0.nooverlap_clk_0.CLKB0 VDPWR sky130_fd_pr__pfet_01v8 ad=0.168 pd=1.42 as=0.168 ps=1.42 w=1.12 l=0.15
X2339 sar9b_0.clkload0.X a_6907_19444# VDPWR VDPWR sky130_fd_pr__pfet_01v8_hvt ad=0.14 pd=1.28 as=0.165 ps=1.33 w=1 l=0.15
X2340 VGND VDPWR VGND VGND sky130_fd_pr__nfet_01v8 ad=0.143 pd=1.62 as=0 ps=0 w=0.55 l=0.59
X2341 VGND single_9b_cdac_1.SW[3] a_49221_17740# VGND sky130_fd_pr__nfet_01v8 ad=0.145 pd=1.58 as=0.145 ps=1.58 w=0.5 l=0.5
X2342 VDPWR sar9b_0.FINAL a_9115_26516# VDPWR sky130_fd_pr__pfet_01v8_hvt ad=0.0864 pd=0.91 as=0.1664 ps=1.8 w=0.64 l=0.15
X2343 a_6149_23770# sar9b_0.clknet_0_CLK VGND VGND sky130_fd_pr__nfet_01v8 ad=0.0588 pd=0.7 as=0.0588 ps=0.7 w=0.42 l=0.15
X2344 single_9b_cdac_0.cdac_sw_9b_0.cdac_sw_3_5.nooverlap_clk_0.CLKB0 single_9b_cdac_0.cdac_sw_9b_0.cdac_sw_3_5.nooverlap_clk_0.sky130_fd_sc_hs__inv_8_0.A VDPWR VDPWR sky130_fd_pr__pfet_01v8 ad=0.168 pd=1.42 as=0.196 ps=1.47 w=1.12 l=0.15
X2345 VDPWR single_9b_cdac_1.cdac_sw_9b_0.cdac_sw_3_7.nooverlap_clk_0.CLKB0 single_9b_cdac_1.cdac_sw_9b_0.cdac_sw_3_7.nooverlap_clk_0.CLK0 VDPWR sky130_fd_pr__pfet_01v8 ad=0.3864 pd=2.93 as=0.168 ps=1.42 w=1.12 l=0.15
X2346 VGND single_9b_cdac_0.cdac_sw_9b_0.cdac_sw_3_0.nooverlap_clk_0.x10.A single_9b_cdac_0.cdac_sw_9b_0.cdac_sw_3_0.tg_sw_3_3.SWN VGND sky130_fd_pr__nfet_01v8_lvt ad=0.1036 pd=1.02 as=0.1036 ps=1.02 w=0.74 l=0.15
X2347 a_9849_21318# a_9631_21076# VDPWR VDPWR sky130_fd_pr__pfet_01v8_hvt ad=0.12915 pd=1.185 as=0.2184 ps=2.2 w=0.84 l=0.15
X2348 VGND VDPWR VGND VGND sky130_fd_pr__nfet_01v8 ad=0.143 pd=1.62 as=0 ps=0 w=0.55 l=0.59
X2349 VDPWR VGND VDPWR VDPWR sky130_fd_pr__pfet_01v8_hvt ad=0.2262 pd=2.26 as=0 ps=0 w=0.87 l=0.59
X2350 single_9b_cdac_1.cdac_sw_9b_0.cdac_sw_3_7.nooverlap_clk_0.CLK0 single_9b_cdac_1.cdac_sw_9b_0.cdac_sw_3_7.nooverlap_clk_0.CLKB0 VDPWR VDPWR sky130_fd_pr__pfet_01v8 ad=0.168 pd=1.42 as=0.196 ps=1.47 w=1.12 l=0.15
X2351 th_dif_sw_0.VCP single_9b_cdac_1.cdac_sw_9b_0.S[6] sky130_fd_pr__cap_mim_m3_1 l=2 w=2
X2352 th_dif_sw_0.VCN single_9b_cdac_0.cdac_sw_9b_0.S[1] sky130_fd_pr__cap_mim_m3_1 l=2 w=2
X2353 a_12937_27279# sar9b_0.net24 VDPWR VDPWR sky130_fd_pr__pfet_01v8_hvt ad=0.2054 pd=2.1 as=0.11455 ps=1.08 w=0.79 l=0.15
X2354 sar9b_0.net32 a_14143_25188# VDPWR VDPWR sky130_fd_pr__pfet_01v8_hvt ad=0.26 pd=2.52 as=0.3012 ps=2.66 w=1 l=0.15
X2355 VDPWR sar9b_0.net35 a_14175_18356# VDPWR sky130_fd_pr__pfet_01v8_hvt ad=0.11455 pd=1.08 as=0.2054 ps=2.1 w=0.79 l=0.15
X2356 VGND tdc_0.OUTP a_12427_17812# VGND sky130_fd_pr__nfet_01v8 ad=0.06825 pd=0.745 as=0.1113 ps=1.37 w=0.42 l=0.15
X2357 a_13465_27398# sar9b_0.net15 a_13379_27398# VGND sky130_fd_pr__nfet_01v8 ad=0.0567 pd=0.69 as=0.1176 ps=1.4 w=0.42 l=0.15
X2358 single_9b_cdac_0.cdac_sw_9b_0.cdac_sw_3_5.nooverlap_clk_0.x10.A single_9b_cdac_0.cdac_sw_9b_0.cdac_sw_3_5.nooverlap_clk_0.x8.A VGND VGND sky130_fd_pr__nfet_01v8_lvt ad=0.1184 pd=1.06 as=0.1221 ps=1.07 w=0.74 l=0.15
X2359 single_9b_cdac_0.cdac_sw_9b_0.cdac_sw_3_1.nooverlap_clk_0.CLKB0 single_9b_cdac_0.cdac_sw_9b_0.cdac_sw_3_1.nooverlap_clk_0.sky130_fd_sc_hs__inv_8_0.A VGND VGND sky130_fd_pr__nfet_01v8_lvt ad=0.1036 pd=1.02 as=0.1295 ps=1.09 w=0.74 l=0.15
X2360 single_9b_cdac_0.cdac_sw_9b_0.cdac_sw_3_2.tg_sw_3_3.SWN single_9b_cdac_0.cdac_sw_9b_0.cdac_sw_3_2.nooverlap_clk_0.x10.A VGND VGND sky130_fd_pr__nfet_01v8_lvt ad=0.1036 pd=1.02 as=0.1036 ps=1.02 w=0.74 l=0.15
X2361 sar9b_0.net3 a_5343_25972# VGND VGND sky130_fd_pr__nfet_01v8 ad=0.0588 pd=0.7 as=0.07035 ps=0.755 w=0.42 l=0.15
X2362 VDPWR VGND VDPWR VDPWR sky130_fd_pr__pfet_01v8_hvt ad=0.2262 pd=2.26 as=0 ps=0 w=0.87 l=0.59
X2363 VGND sar9b_0.net10 a_9670_22708# VGND sky130_fd_pr__nfet_01v8 ad=0.2205 pd=1.89 as=0.066 ps=0.745 w=0.42 l=0.15
X2364 VGND VDPWR VGND VGND sky130_fd_pr__nfet_01v8 ad=0.143 pd=1.62 as=0 ps=0 w=0.55 l=0.59
X2365 single_9b_cdac_1.cdac_sw_9b_0.S[5] single_9b_cdac_1.cdac_sw_9b_0.cdac_sw_3_5.tg_sw_3_3.SWP ua[0] VGND sky130_fd_pr__nfet_01v8 ad=0.145 pd=1.58 as=0.145 ps=1.58 w=0.5 l=0.5
X2366 th_dif_sw_0.VCP single_9b_cdac_1.cdac_sw_9b_0.S[7] sky130_fd_pr__cap_mim_m3_1 l=2 w=2
X2367 th_dif_sw_0.VCP single_9b_cdac_1.cdac_sw_9b_0.S[3] sky130_fd_pr__cap_mim_m3_1 l=2 w=2
X2368 single_9b_cdac_0.cdac_sw_9b_0.cdac_sw_3_5.nooverlap_clk_0.CLK0 single_9b_cdac_0.cdac_sw_9b_0.cdac_sw_3_5.nooverlap_clk_0.CLKB0 VGND VGND sky130_fd_pr__nfet_01v8_lvt ad=0.1036 pd=1.02 as=0.1295 ps=1.09 w=0.74 l=0.15
X2369 VGND single_9b_cdac_0.cdac_sw_9b_0.cdac_sw_3_2.nooverlap_clk_0.CLKB0 single_9b_cdac_0.cdac_sw_9b_0.cdac_sw_3_2.nooverlap_clk_0.CLK0 VGND sky130_fd_pr__nfet_01v8_lvt ad=0.1554 pd=1.16 as=0.1036 ps=1.02 w=0.74 l=0.15
X2370 VDPWR sar9b_0.clknet_1_0__leaf_CLK a_8471_20538# VDPWR sky130_fd_pr__pfet_01v8_hvt ad=0.0864 pd=0.91 as=0.1664 ps=1.8 w=0.64 l=0.15
X2371 VGND a_7417_27279# uo_out[7] VGND sky130_fd_pr__nfet_01v8 ad=0.0754 pd=0.81 as=0.1352 ps=1.56 w=0.52 l=0.15
X2372 single_9b_cdac_0.cdac_sw_9b_0.cdac_sw_3_5.nooverlap_clk_0.x10.A single_9b_cdac_0.cdac_sw_9b_0.cdac_sw_3_5.nooverlap_clk_0.x8.A VDPWR VDPWR sky130_fd_pr__pfet_01v8 ad=0.168 pd=1.42 as=0.168 ps=1.42 w=1.12 l=0.15
X2373 th_dif_sw_0.VCP single_9b_cdac_1.cdac_sw_9b_0.S[2] sky130_fd_pr__cap_mim_m3_1 l=2 w=2
X2374 VDPWR sar9b_0.net10 a_12795_23802# VDPWR sky130_fd_pr__pfet_01v8_hvt ad=0.0864 pd=0.91 as=0.1664 ps=1.8 w=0.64 l=0.15
X2375 VDPWR a_9335_20532# a_9503_20506# VDPWR sky130_fd_pr__pfet_01v8_hvt ad=0.135 pd=1.27 as=0.27 ps=2.54 w=1 l=0.15
X2376 VGND VDPWR VGND VGND sky130_fd_pr__nfet_01v8 ad=0.143 pd=1.62 as=0 ps=0 w=0.55 l=0.59
X2377 VGND single_9b_cdac_1.cdac_sw_9b_0.cdac_sw_3_1.nooverlap_clk_0.CLKB0 single_9b_cdac_1.cdac_sw_9b_0.cdac_sw_3_1.nooverlap_clk_0.CLK0 VGND sky130_fd_pr__nfet_01v8_lvt ad=0.1036 pd=1.02 as=0.1036 ps=1.02 w=0.74 l=0.15
X2378 a_12145_26516# a_10955_26516# a_12036_26516# VGND sky130_fd_pr__special_nfet_01v8 ad=0.0669 pd=0.75 as=0.0711 ps=0.755 w=0.36 l=0.15
X2379 VGND single_9b_cdac_0.cdac_sw_9b_0.cdac_sw_3_8.nooverlap_clk_0.sky130_fd_sc_hs__inv_8_0.A single_9b_cdac_0.cdac_sw_9b_0.cdac_sw_3_8.nooverlap_clk_0.CLKB0 VGND sky130_fd_pr__nfet_01v8_lvt ad=0.1554 pd=1.16 as=0.1036 ps=1.02 w=0.74 l=0.15
X2380 th_dif_sw_0.VCP single_9b_cdac_1.cdac_sw_9b_0.S[3] sky130_fd_pr__cap_mim_m3_1 l=2 w=2
X2381 th_dif_sw_0.VCN single_9b_cdac_0.cdac_sw_9b_0.S[1] sky130_fd_pr__cap_mim_m3_1 l=2 w=2
X2382 a_60565_15501# single_9b_cdac_1.CF[1] single_9b_cdac_1.cdac_sw_9b_0.cdac_sw_3_1.nooverlap_clk_0.sky130_fd_sc_hs__nand2_1_0.Y VGND sky130_fd_pr__nfet_01v8_lvt ad=0.0888 pd=0.98 as=0.2109 ps=2.05 w=0.74 l=0.15
X2383 VDPWR single_9b_cdac_0.cdac_sw_9b_0.cdac_sw_3_5.nooverlap_clk_0.x8.A single_9b_cdac_0.cdac_sw_9b_0.cdac_sw_3_5.nooverlap_clk_0.x10.A VDPWR sky130_fd_pr__pfet_01v8 ad=0.168 pd=1.42 as=0.168 ps=1.42 w=1.12 l=0.15
X2384 VGND a_9335_20532# a_9503_20506# VGND sky130_fd_pr__nfet_01v8 ad=0.08775 pd=0.92 as=0.169 ps=1.82 w=0.65 l=0.15
X2385 single_9b_cdac_1.cdac_sw_9b_0.S[5] single_9b_cdac_1.cdac_sw_9b_0.cdac_sw_3_5.tg_sw_3_3.SWN ua[0] VDPWR sky130_fd_pr__pfet_01v8 ad=0.435 pd=3.58 as=0.435 ps=3.58 w=1.5 l=0.5
X2386 th_dif_sw_0.VCN single_9b_cdac_0.cdac_sw_9b_0.S[0] sky130_fd_pr__cap_mim_m3_1 l=2 w=2
X2387 single_9b_cdac_0.cdac_sw_9b_0.cdac_sw_3_7.tg_sw_3_3.SWP single_9b_cdac_0.cdac_sw_9b_0.cdac_sw_3_7.tg_sw_3_3.SWN VDPWR VDPWR sky130_fd_pr__pfet_01v8 ad=0.168 pd=1.42 as=0.196 ps=1.47 w=1.12 l=0.15
X2388 ua[0] single_9b_cdac_0.cdac_sw_9b_0.cdac_sw_3_2.tg_sw_3_3.SWP ua[0] VDPWR sky130_fd_pr__pfet_01v8 ad=0.435 pd=3.58 as=0 ps=0 w=1.5 l=0.5
X2389 VGND sar9b_0.FINAL a_11691_25978# VGND sky130_fd_pr__nfet_01v8 ad=0.0567 pd=0.69 as=0.1092 ps=1.36 w=0.42 l=0.15
X2390 VGND single_9b_cdac_1.cdac_sw_9b_0.cdac_sw_3_2.nooverlap_clk_0.x1.A single_9b_cdac_1.cdac_sw_9b_0.cdac_sw_3_2.nooverlap_clk_0.sky130_fd_sc_hs__inv_8_0.A VGND sky130_fd_pr__nfet_01v8_lvt ad=0.1221 pd=1.07 as=0.1184 ps=1.06 w=0.74 l=0.15
X2391 VGND VDPWR VGND VGND sky130_fd_pr__nfet_01v8 ad=0.143 pd=1.62 as=0 ps=0 w=0.55 l=0.59
X2392 VGND single_9b_cdac_0.cdac_sw_9b_0.cdac_sw_3_7.nooverlap_clk_0.x6.A single_9b_cdac_0.cdac_sw_9b_0.cdac_sw_3_7.nooverlap_clk_0.x8.A VGND sky130_fd_pr__nfet_01v8_lvt ad=0.2627 pd=2.19 as=0.2109 ps=2.05 w=0.74 l=0.15
X2393 dw_12589_1395# a_10166_3438# sky130_fd_pr__cap_mim_m3_1 l=2 w=2
X2394 th_dif_sw_0.VCP single_9b_cdac_1.cdac_sw_9b_0.S[2] sky130_fd_pr__cap_mim_m3_1 l=2 w=2
X2395 single_9b_cdac_0.cdac_sw_9b_0.cdac_sw_3_5.nooverlap_clk_0.x10.A single_9b_cdac_0.cdac_sw_9b_0.cdac_sw_3_5.nooverlap_clk_0.x8.A VDPWR VDPWR sky130_fd_pr__pfet_01v8 ad=0.168 pd=1.42 as=0.3304 ps=2.83 w=1.12 l=0.15
X2396 single_9b_cdac_0.cdac_sw_9b_0.cdac_sw_3_3.nooverlap_clk_0.CLK0 single_9b_cdac_0.cdac_sw_9b_0.cdac_sw_3_3.nooverlap_clk_0.CLKB0 VGND VGND sky130_fd_pr__nfet_01v8_lvt ad=0.1036 pd=1.02 as=0.2146 ps=2.06 w=0.74 l=0.15
X2397 single_9b_cdac_1.cdac_sw_9b_0.cdac_sw_3_8.nooverlap_clk_0.sky130_fd_sc_hs__inv_8_0.A single_9b_cdac_1.cdac_sw_9b_0.cdac_sw_3_8.nooverlap_clk_0.x1.A VGND VGND sky130_fd_pr__nfet_01v8_lvt ad=0.1184 pd=1.06 as=0.2331 ps=2.11 w=0.74 l=0.15
X2398 th_dif_sw_0.VCN single_9b_cdac_0.cdac_sw_9b_0.S[1] sky130_fd_pr__cap_mim_m3_1 l=2 w=2
X2399 VGND a_6149_23770# sar9b_0.clknet_1_1__leaf_CLK VGND sky130_fd_pr__nfet_01v8 ad=0.05775 pd=0.695 as=0.0588 ps=0.7 w=0.42 l=0.15
X2400 a_11471_24174# a_10955_23802# a_11376_24162# VGND sky130_fd_pr__special_nfet_01v8 ad=0.0594 pd=0.69 as=0.066 ps=0.745 w=0.36 l=0.15
X2401 a_9249_23252# a_9205_23494# a_9083_23252# VGND sky130_fd_pr__nfet_01v8 ad=0.0441 pd=0.63 as=0.1401 ps=1.1 w=0.42 l=0.15
X2402 dw_12589_1395# a_10166_3438# sky130_fd_pr__cap_mim_m3_1 l=2 w=2
X2403 VDPWR a_21177_7457# th_dif_sw_0.th_sw_1.CKB VDPWR sky130_fd_pr__pfet_01v8 ad=0.168 pd=1.42 as=0.168 ps=1.42 w=1.12 l=0.15
X2404 a_8545_25978# a_8379_25978# VDPWR VDPWR sky130_fd_pr__pfet_01v8_hvt ad=0.1664 pd=1.8 as=0.0864 ps=0.91 w=0.64 l=0.15
X2405 VGND VDPWR VGND VGND sky130_fd_pr__nfet_01v8 ad=0.143 pd=1.62 as=0 ps=0 w=0.55 l=0.59
X2406 a_11471_18900# a_10955_18900# a_11376_18900# VGND sky130_fd_pr__special_nfet_01v8 ad=0.0594 pd=0.69 as=0.066 ps=0.745 w=0.36 l=0.15
X2407 VGND single_9b_cdac_1.cdac_sw_9b_0.cdac_sw_3_8.nooverlap_clk_0.sky130_fd_sc_hs__inv_8_0.A single_9b_cdac_1.cdac_sw_9b_0.cdac_sw_3_8.nooverlap_clk_0.CLKB0 VGND sky130_fd_pr__nfet_01v8_lvt ad=0.1295 pd=1.09 as=0.1036 ps=1.02 w=0.74 l=0.15
X2408 th_dif_sw_0.VCP single_9b_cdac_1.cdac_sw_9b_0.S[0] sky130_fd_pr__cap_mim_m3_1 l=2 w=2
X2409 VGND a_16159_13315# tdc_0.RDY VGND sky130_fd_pr__nfet_01v8_lvt ad=0.2997 pd=2.29 as=0.1554 ps=1.16 w=0.74 l=0.15
X2410 VDPWR single_9b_cdac_1.cdac_sw_9b_0.cdac_sw_3_2.nooverlap_clk_0.sky130_fd_sc_hs__inv_8_0.A single_9b_cdac_1.cdac_sw_9b_0.cdac_sw_3_2.nooverlap_clk_0.CLKB0 VDPWR sky130_fd_pr__pfet_01v8 ad=0.196 pd=1.47 as=0.168 ps=1.42 w=1.12 l=0.15
X2411 th_dif_sw_0.VCN single_9b_cdac_0.cdac_sw_9b_0.S[0] sky130_fd_pr__cap_mim_m3_1 l=2 w=2
X2412 VDPWR sar9b_0.FINAL a_5803_25428# VDPWR sky130_fd_pr__pfet_01v8_hvt ad=0.0864 pd=0.91 as=0.1664 ps=1.8 w=0.64 l=0.15
X2413 a_13403_25262# a_12887_24890# a_13308_25250# VGND sky130_fd_pr__special_nfet_01v8 ad=0.0594 pd=0.69 as=0.066 ps=0.745 w=0.36 l=0.15
X2414 a_13216_24162# sar9b_0.net1 VDPWR VDPWR sky130_fd_pr__pfet_01v8_hvt ad=0.0651 pd=0.73 as=0.1092 ps=1.36 w=0.42 l=0.15
X2415 VDPWR VGND VDPWR VDPWR sky130_fd_pr__pfet_01v8_hvt ad=0.2262 pd=2.26 as=0 ps=0 w=0.87 l=0.59
X2416 single_9b_cdac_1.cdac_sw_9b_0.cdac_sw_3_5.nooverlap_clk_0.CLKB0 single_9b_cdac_1.cdac_sw_9b_0.cdac_sw_3_5.nooverlap_clk_0.sky130_fd_sc_hs__inv_8_0.A VDPWR VDPWR sky130_fd_pr__pfet_01v8 ad=0.168 pd=1.42 as=0.3304 ps=2.83 w=1.12 l=0.15
X2417 single_9b_cdac_1.cdac_sw_9b_0.cdac_sw_3_2.nooverlap_clk_0.CLKB0 single_9b_cdac_1.cdac_sw_9b_0.cdac_sw_3_2.nooverlap_clk_0.sky130_fd_sc_hs__inv_8_0.A VGND VGND sky130_fd_pr__nfet_01v8_lvt ad=0.1036 pd=1.02 as=0.1036 ps=1.02 w=0.74 l=0.15
X2418 single_9b_cdac_0.cdac_sw_9b_0.S[8] single_9b_cdac_0.cdac_sw_9b_0.cdac_sw_3_8.tg_sw_3_3.SWP ua[0] VGND sky130_fd_pr__nfet_01v8 ad=0.145 pd=1.58 as=0.145 ps=1.58 w=0.5 l=0.5
X2419 VGND single_9b_cdac_1.cdac_sw_9b_0.cdac_sw_3_3.nooverlap_clk_0.x10.A single_9b_cdac_1.cdac_sw_9b_0.cdac_sw_3_3.tg_sw_3_3.SWN VGND sky130_fd_pr__nfet_01v8_lvt ad=0.2146 pd=2.06 as=0.1036 ps=1.02 w=0.74 l=0.15
X2420 th_dif_sw_0.VCP single_9b_cdac_1.cdac_sw_9b_0.S[2] sky130_fd_pr__cap_mim_m3_1 l=2 w=2
X2421 single_9b_cdac_0.cdac_sw_9b_0.S[7] single_9b_cdac_0.cdac_sw_9b_0.cdac_sw_3_7.tg_sw_3_3.SWN single_9b_cdac_0.cdac_sw_9b_0.S[7] VGND sky130_fd_pr__nfet_01v8 ad=0.145 pd=1.58 as=2.32 ps=25.28 w=0.5 l=0.5
X2422 VGND single_9b_cdac_0.cdac_sw_9b_0.cdac_sw_3_4.nooverlap_clk_0.x10.A single_9b_cdac_0.cdac_sw_9b_0.cdac_sw_3_4.tg_sw_3_3.SWN VGND sky130_fd_pr__nfet_01v8_lvt ad=0.1295 pd=1.09 as=0.1036 ps=1.02 w=0.74 l=0.15
X2423 single_9b_cdac_0.cdac_sw_9b_0.cdac_sw_3_1.tg_sw_3_3.SWN single_9b_cdac_0.cdac_sw_9b_0.cdac_sw_3_1.nooverlap_clk_0.x10.A VDPWR VDPWR sky130_fd_pr__pfet_01v8 ad=0.168 pd=1.42 as=0.196 ps=1.47 w=1.12 l=0.15
X2424 VDPWR a_11760_25428# a_11935_25402# VDPWR sky130_fd_pr__pfet_01v8_hvt ad=0.1134 pd=1.38 as=0.0567 ps=0.69 w=0.42 l=0.15
X2425 VGND a_9535_19962# sar9b_0.net38 VGND sky130_fd_pr__nfet_01v8 ad=0.2087 pd=2.02 as=0.169 ps=1.82 w=0.65 l=0.15
X2426 VGND single_9b_cdac_1.SW[8] a_25210_17740# VGND sky130_fd_pr__nfet_01v8 ad=0.145 pd=1.58 as=0.145 ps=1.58 w=0.5 l=0.5
X2427 single_9b_cdac_1.cdac_sw_9b_0.cdac_sw_3_2.nooverlap_clk_0.CLKB0 single_9b_cdac_1.cdac_sw_9b_0.cdac_sw_3_2.nooverlap_clk_0.sky130_fd_sc_hs__inv_8_0.A VDPWR VDPWR sky130_fd_pr__pfet_01v8 ad=0.168 pd=1.42 as=0.168 ps=1.42 w=1.12 l=0.15
X2428 single_9b_cdac_1.cdac_sw_9b_0.S[0] single_9b_cdac_1.cdac_sw_9b_0.cdac_sw_3_2.tg_sw_3_3.SWN single_9b_cdac_1.cdac_sw_9b_0.S[0] VGND sky130_fd_pr__nfet_01v8 ad=0.145 pd=1.58 as=0 ps=0 w=0.5 l=0.5
X2429 single_9b_cdac_0.cdac_sw_9b_0.cdac_sw_3_7.nooverlap_clk_0.CLKB0 single_9b_cdac_0.cdac_sw_9b_0.cdac_sw_3_7.nooverlap_clk_0.sky130_fd_sc_hs__inv_8_0.A VGND VGND sky130_fd_pr__nfet_01v8_lvt ad=0.1036 pd=1.02 as=0.1036 ps=1.02 w=0.74 l=0.15
X2430 sar9b_0.net41 a_9727_23226# VGND VGND sky130_fd_pr__nfet_01v8 ad=0.169 pd=1.82 as=0.2087 ps=2.02 w=0.65 l=0.15
X2431 VDPWR tdc_0.RDY a_7735_17812# VDPWR sky130_fd_pr__pfet_01v8_hvt ad=0.1625 pd=1.325 as=0.265 ps=2.53 w=1 l=0.15
X2432 th_dif_sw_0.VCN single_9b_cdac_0.cdac_sw_9b_0.S[1] sky130_fd_pr__cap_mim_m3_1 l=2 w=2
X2433 VDPWR VGND VDPWR VDPWR sky130_fd_pr__pfet_01v8_hvt ad=0.2262 pd=2.26 as=0 ps=0 w=0.87 l=0.59
X2434 single_9b_cdac_0.cdac_sw_9b_0.S[0] single_9b_cdac_0.cdac_sw_9b_0.cdac_sw_3_2.nooverlap_clk_0.CLKB0 a_62748_26999# VDPWR sky130_fd_pr__pfet_01v8 ad=0.435 pd=3.58 as=0.435 ps=3.58 w=1.5 l=0.5
X2435 VGND VDPWR VGND VGND sky130_fd_pr__nfet_01v8 ad=0.143 pd=1.62 as=0 ps=0 w=0.55 l=0.59
X2436 VDPWR single_9b_cdac_1.cdac_sw_9b_0.cdac_sw_3_2.nooverlap_clk_0.sky130_fd_sc_hs__inv_8_0.A single_9b_cdac_1.cdac_sw_9b_0.cdac_sw_3_2.nooverlap_clk_0.CLKB0 VDPWR sky130_fd_pr__pfet_01v8 ad=0.168 pd=1.42 as=0.168 ps=1.42 w=1.12 l=0.15
X2437 VDPWR single_9b_cdac_0.cdac_sw_9b_0.cdac_sw_3_8.nooverlap_clk_0.x10.A single_9b_cdac_0.cdac_sw_9b_0.cdac_sw_3_8.tg_sw_3_3.SWN VDPWR sky130_fd_pr__pfet_01v8 ad=0.196 pd=1.47 as=0.168 ps=1.42 w=1.12 l=0.15
X2438 a_9335_20532# a_8471_20538# a_9078_20506# VDPWR sky130_fd_pr__pfet_01v8_hvt ad=0.0567 pd=0.69 as=0.1095 ps=1.075 w=0.42 l=0.15
X2439 VDPWR VGND VDPWR VDPWR sky130_fd_pr__pfet_01v8_hvt ad=0.2262 pd=2.26 as=0 ps=0 w=0.87 l=0.59
X2440 th_dif_sw_0.VCP single_9b_cdac_1.cdac_sw_9b_0.S[4] sky130_fd_pr__cap_mim_m3_1 l=2 w=2
X2441 th_dif_sw_0.VCP single_9b_cdac_1.cdac_sw_9b_0.S[1] sky130_fd_pr__cap_mim_m3_1 l=2 w=2
X2442 VDPWR single_9b_cdac_0.cdac_sw_9b_0.cdac_sw_3_4.nooverlap_clk_0.sky130_fd_sc_hs__inv_1_1.A single_9b_cdac_0.cdac_sw_9b_0.cdac_sw_3_4.nooverlap_clk_0.x1.A VDPWR sky130_fd_pr__pfet_01v8 ad=0.3864 pd=2.93 as=0.3304 ps=2.83 w=1.12 l=0.15
X2443 VDPWR VGND VDPWR VDPWR sky130_fd_pr__pfet_01v8_hvt ad=0.2262 pd=2.26 as=0 ps=0 w=0.87 l=0.59
X2444 VGND VDPWR VGND VGND sky130_fd_pr__nfet_01v8 ad=0.143 pd=1.62 as=0 ps=0 w=0.55 l=0.59
X2445 a_10521_19988# a_10142_20354# a_10449_19988# VGND sky130_fd_pr__nfet_01v8 ad=0.1401 pd=1.1 as=0.0441 ps=0.63 w=0.42 l=0.15
X2446 ua[0] single_9b_cdac_1.cdac_sw_9b_0.cdac_sw_3_8.tg_sw_3_3.SWN ua[0] VGND sky130_fd_pr__nfet_01v8 ad=0.145 pd=1.58 as=0 ps=0 w=0.5 l=0.5
X2447 th_dif_sw_0.VCN single_9b_cdac_0.cdac_sw_9b_0.S[2] sky130_fd_pr__cap_mim_m3_1 l=2 w=2
X2448 a_13665_26516# a_13621_26758# a_13499_26516# VGND sky130_fd_pr__nfet_01v8 ad=0.0441 pd=0.63 as=0.1401 ps=1.1 w=0.42 l=0.15
X2449 a_13499_25428# a_13053_25428# a_13403_25428# VGND sky130_fd_pr__special_nfet_01v8 ad=0.1401 pd=1.1 as=0.0594 ps=0.69 w=0.36 l=0.15
X2450 VGND single_9b_cdac_1.cdac_sw_9b_0.cdac_sw_3_5.tg_sw_3_3.SWN single_9b_cdac_1.cdac_sw_9b_0.cdac_sw_3_5.tg_sw_3_3.SWP VGND sky130_fd_pr__nfet_01v8_lvt ad=0.1554 pd=1.16 as=0.1036 ps=1.02 w=0.74 l=0.15
X2451 th_dif_sw_0.VCP single_9b_cdac_1.cdac_sw_9b_0.S[2] sky130_fd_pr__cap_mim_m3_1 l=2 w=2
X2452 single_9b_cdac_1.cdac_sw_9b_0.cdac_sw_3_2.nooverlap_clk_0.CLKB0 single_9b_cdac_1.cdac_sw_9b_0.cdac_sw_3_2.nooverlap_clk_0.sky130_fd_sc_hs__inv_8_0.A VDPWR VDPWR sky130_fd_pr__pfet_01v8 ad=0.168 pd=1.42 as=0.196 ps=1.47 w=1.12 l=0.15
X2453 single_9b_cdac_0.cdac_sw_9b_0.cdac_sw_3_8.tg_sw_3_3.SWN single_9b_cdac_0.cdac_sw_9b_0.cdac_sw_3_8.nooverlap_clk_0.x10.A VDPWR VDPWR sky130_fd_pr__pfet_01v8 ad=0.168 pd=1.42 as=0.3864 ps=2.93 w=1.12 l=0.15
X2454 single_9b_cdac_0.cdac_sw_9b_0.S[6] single_9b_cdac_0.cdac_sw_9b_0.cdac_sw_3_6.nooverlap_clk_0.CLKB0 a_33936_26999# VDPWR sky130_fd_pr__pfet_01v8 ad=0.435 pd=3.58 as=0.435 ps=3.58 w=1.5 l=0.5
X2455 VGND sar9b_0.clknet_0_CLK a_6701_20506# VGND sky130_fd_pr__nfet_01v8 ad=0.1113 pd=1.37 as=0.0588 ps=0.7 w=0.42 l=0.15
X2456 a_11747_20910# a_11397_20538# a_11652_20898# VDPWR sky130_fd_pr__pfet_01v8_hvt ad=0.07245 pd=0.765 as=0.0651 ps=0.73 w=0.42 l=0.15
X2457 ua[0] single_9b_cdac_0.cdac_sw_9b_0.cdac_sw_3_8.tg_sw_3_3.SWN ua[0] VGND sky130_fd_pr__nfet_01v8 ad=0.145 pd=1.58 as=0 ps=0 w=0.5 l=0.5
X2458 a_6726_27060# a_5968_27176# a_6163_27034# VDPWR sky130_fd_pr__pfet_01v8_hvt ad=0.0651 pd=0.73 as=0.07245 ps=0.765 w=0.42 l=0.15
X2459 a_24332_16877# single_9b_cdac_1.SW[8] VDPWR VDPWR sky130_fd_pr__pfet_01v8 ad=0.435 pd=3.58 as=0.435 ps=3.58 w=1.5 l=0.5
X2460 a_8911_19444# a_8287_19450# a_8803_19822# VDPWR sky130_fd_pr__pfet_01v8_hvt ad=0.1155 pd=0.97 as=0.07245 ps=0.765 w=0.42 l=0.15
X2461 single_9b_cdac_1.cdac_sw_9b_0.cdac_sw_3_4.tg_sw_3_3.SWN single_9b_cdac_1.cdac_sw_9b_0.cdac_sw_3_4.nooverlap_clk_0.x10.A VGND VGND sky130_fd_pr__nfet_01v8_lvt ad=0.1036 pd=1.02 as=0.2109 ps=2.05 w=0.74 l=0.15
X2462 single_9b_cdac_1.cdac_sw_9b_0.cdac_sw_3_4.nooverlap_clk_0.x3.Y single_9b_cdac_1.CF[3] VDPWR VDPWR sky130_fd_pr__pfet_01v8 ad=0.3304 pd=2.83 as=0.3864 ps=2.93 w=1.12 l=0.15
X2463 VGND VDPWR VGND VGND sky130_fd_pr__nfet_01v8 ad=0.143 pd=1.62 as=0 ps=0 w=0.55 l=0.59
X2464 th_dif_sw_0.VCN single_9b_cdac_0.cdac_sw_9b_0.S[0] sky130_fd_pr__cap_mim_m3_1 l=2 w=2
X2465 VDPWR a_7203_22682# a_7119_22708# VDPWR sky130_fd_pr__pfet_01v8_hvt ad=0.1113 pd=1.37 as=0.0882 ps=0.84 w=0.42 l=0.15
X2466 th_dif_sw_0.VCN single_9b_cdac_0.cdac_sw_9b_0.S[1] sky130_fd_pr__cap_mim_m3_1 l=2 w=2
X2467 a_9536_26516# sar9b_0.net41 VDPWR VDPWR sky130_fd_pr__pfet_01v8_hvt ad=0.0651 pd=0.73 as=0.1092 ps=1.36 w=0.42 l=0.15
X2468 VDPWR VGND VDPWR VDPWR sky130_fd_pr__pfet_01v8_hvt ad=0.2262 pd=2.26 as=0 ps=0 w=0.87 l=0.59
X2469 VDPWR single_9b_cdac_1.cdac_sw_9b_0.cdac_sw_3_4.nooverlap_clk_0.x10.A single_9b_cdac_1.cdac_sw_9b_0.cdac_sw_3_4.tg_sw_3_3.SWN VDPWR sky130_fd_pr__pfet_01v8 ad=0.3864 pd=2.93 as=0.168 ps=1.42 w=1.12 l=0.15
X2470 single_9b_cdac_0.cdac_sw_9b_0.cdac_sw_3_5.nooverlap_clk_0.CLKB0 single_9b_cdac_0.cdac_sw_9b_0.cdac_sw_3_5.nooverlap_clk_0.sky130_fd_sc_hs__inv_8_0.A VGND VGND sky130_fd_pr__nfet_01v8_lvt ad=0.1036 pd=1.02 as=0.1554 ps=1.16 w=0.74 l=0.15
X2471 sar9b_0._06_ sar9b_0.clk_div_0.COUNT\[3\] VGND VGND sky130_fd_pr__nfet_01v8 ad=0.08775 pd=0.92 as=0.169 ps=1.82 w=0.65 l=0.15
X2472 a_11376_21076# sar9b_0.net2 VDPWR VDPWR sky130_fd_pr__pfet_01v8_hvt ad=0.0651 pd=0.73 as=0.1092 ps=1.36 w=0.42 l=0.15
X2473 VDPWR VGND VDPWR VDPWR sky130_fd_pr__pfet_01v8_hvt ad=0.2262 pd=2.26 as=0 ps=0 w=0.87 l=0.59
X2474 th_dif_sw_0.VCN single_9b_cdac_0.cdac_sw_9b_0.S[0] sky130_fd_pr__cap_mim_m3_1 l=2 w=2
X2475 a_12421_20910# a_11231_20538# a_12312_20910# VGND sky130_fd_pr__special_nfet_01v8 ad=0.0669 pd=0.75 as=0.0711 ps=0.755 w=0.36 l=0.15
X2476 VGND VDPWR VGND VGND sky130_fd_pr__nfet_01v8 ad=0.143 pd=1.62 as=0 ps=0 w=0.55 l=0.59
X2477 th_dif_sw_0.VCN single_9b_cdac_0.cdac_sw_9b_0.S[0] sky130_fd_pr__cap_mim_m3_1 l=2 w=2
X2478 th_dif_sw_0.VCN single_9b_cdac_0.cdac_sw_9b_0.S[3] sky130_fd_pr__cap_mim_m3_1 l=2 w=2
X2479 single_9b_cdac_1.cdac_sw_9b_0.cdac_sw_3_4.tg_sw_3_3.SWN single_9b_cdac_1.cdac_sw_9b_0.cdac_sw_3_4.nooverlap_clk_0.x10.A VDPWR VDPWR sky130_fd_pr__pfet_01v8 ad=0.168 pd=1.42 as=0.196 ps=1.47 w=1.12 l=0.15
X2480 single_9b_cdac_1.cdac_sw_9b_0.S[0] single_9b_cdac_1.cdac_sw_9b_0.cdac_sw_3_2.tg_sw_3_3.SWP single_9b_cdac_1.cdac_sw_9b_0.S[0] VDPWR sky130_fd_pr__pfet_01v8 ad=0.435 pd=3.58 as=0 ps=0 w=1.5 l=0.5
X2481 VDPWR sar9b_0.net5 a_13347_21620# VDPWR sky130_fd_pr__pfet_01v8_hvt ad=0.11455 pd=1.08 as=0.2054 ps=2.1 w=0.79 l=0.15
X2482 single_9b_cdac_1.cdac_sw_9b_0.cdac_sw_3_0.tg_sw_3_3.SWP single_9b_cdac_1.cdac_sw_9b_0.cdac_sw_3_0.tg_sw_3_3.SWN VGND VGND sky130_fd_pr__nfet_01v8_lvt ad=0.1036 pd=1.02 as=0.2109 ps=2.05 w=0.74 l=0.15
X2483 single_9b_cdac_0.cdac_sw_9b_0.cdac_sw_3_2.tg_sw_3_3.SWN single_9b_cdac_0.cdac_sw_9b_0.cdac_sw_3_2.nooverlap_clk_0.x10.A VGND VGND sky130_fd_pr__nfet_01v8_lvt ad=0.1036 pd=1.02 as=0.1295 ps=1.09 w=0.74 l=0.15
X2484 a_10055_20130# sar9b_0.net8 VDPWR VDPWR sky130_fd_pr__pfet_01v8_hvt ad=0.1664 pd=1.8 as=0.0864 ps=0.91 w=0.64 l=0.15
X2485 th_dif_sw_0.VCP single_9b_cdac_1.cdac_sw_9b_0.S[0] sky130_fd_pr__cap_mim_m3_1 l=2 w=2
X2486 th_dif_sw_0.VCN single_9b_cdac_0.cdac_sw_9b_0.S[1] sky130_fd_pr__cap_mim_m3_1 l=2 w=2
X2487 th_dif_sw_0.VCN single_9b_cdac_0.cdac_sw_9b_0.S[5] sky130_fd_pr__cap_mim_m3_1 l=2 w=2
X2488 single_9b_cdac_0.cdac_sw_9b_0.cdac_sw_3_3.tg_sw_3_3.SWP single_9b_cdac_0.cdac_sw_9b_0.cdac_sw_3_3.tg_sw_3_3.SWN VGND VGND sky130_fd_pr__nfet_01v8_lvt ad=0.1036 pd=1.02 as=0.1295 ps=1.09 w=0.74 l=0.15
X2489 single_9b_cdac_1.cdac_sw_9b_0.S[8] single_9b_cdac_1.cdac_sw_9b_0.cdac_sw_3_8.tg_sw_3_3.SWP ua[0] VGND sky130_fd_pr__nfet_01v8 ad=0.145 pd=1.58 as=0.145 ps=1.58 w=0.5 l=0.5
X2490 VDPWR VGND VDPWR VDPWR sky130_fd_pr__pfet_01v8_hvt ad=0.2262 pd=2.26 as=0 ps=0 w=0.87 l=0.59
X2491 th_dif_sw_0.VCP single_9b_cdac_1.cdac_sw_9b_0.S[0] sky130_fd_pr__cap_mim_m3_1 l=2 w=2
X2492 tdc_0.delay_gate_ori_0.sky130_fd_sc_hs__and2_1_0.A a_14871_9671# VGND VGND sky130_fd_pr__nfet_01v8 ad=0.29 pd=2.58 as=0.145 ps=1.29 w=1 l=1
X2493 a_13053_19450# a_12887_19450# VDPWR VDPWR sky130_fd_pr__pfet_01v8_hvt ad=0.1664 pd=1.8 as=0.0864 ps=0.91 w=0.64 l=0.15
X2494 VGND single_9b_cdac_0.cdac_sw_9b_0.cdac_sw_3_1.nooverlap_clk_0.x1.A single_9b_cdac_0.cdac_sw_9b_0.cdac_sw_3_1.nooverlap_clk_0.sky130_fd_sc_hs__inv_8_0.A VGND sky130_fd_pr__nfet_01v8_lvt ad=0.1221 pd=1.07 as=0.1036 ps=1.02 w=0.74 l=0.15
X2495 a_11857_25978# a_11691_25978# VDPWR VDPWR sky130_fd_pr__pfet_01v8_hvt ad=0.1664 pd=1.8 as=0.0864 ps=0.91 w=0.64 l=0.15
X2496 th_dif_sw_0.VCP single_9b_cdac_1.cdac_sw_9b_0.S[0] sky130_fd_pr__cap_mim_m3_1 l=2 w=2
X2497 VDPWR a_9132_7271# th_dif_sw_0.th_sw_1.CK VDPWR sky130_fd_pr__pfet_01v8 ad=0.168 pd=1.42 as=0.168 ps=1.42 w=1.12 l=0.15
X2498 VGND single_9b_cdac_1.cdac_sw_9b_0.cdac_sw_3_2.tg_sw_3_3.SWN single_9b_cdac_1.cdac_sw_9b_0.cdac_sw_3_2.tg_sw_3_3.SWP VGND sky130_fd_pr__nfet_01v8_lvt ad=0.1036 pd=1.02 as=0.1036 ps=1.02 w=0.74 l=0.15
X2499 a_25210_17740# single_9b_cdac_1.cdac_sw_9b_0.cdac_sw_3_8.nooverlap_clk_0.CLK0 single_9b_cdac_1.cdac_sw_9b_0.S[8] VGND sky130_fd_pr__nfet_01v8 ad=0.145 pd=1.58 as=0.145 ps=1.58 w=0.5 l=0.5
X2500 a_15052_11404# tdc_0.phase_detector_0.INN VGND VGND sky130_fd_pr__nfet_01v8 ad=0.145 pd=1.29 as=0.29 ps=2.58 w=1 l=0.15
X2501 single_9b_cdac_0.cdac_sw_9b_0.S[8] single_9b_cdac_0.cdac_sw_9b_0.cdac_sw_3_8.tg_sw_3_3.SWN ua[0] VDPWR sky130_fd_pr__pfet_01v8 ad=0.435 pd=3.58 as=0.435 ps=3.58 w=1.5 l=0.5
X2502 VGND single_9b_cdac_0.SW[3] a_49221_26990# VGND sky130_fd_pr__nfet_01v8 ad=0.145 pd=1.58 as=0.145 ps=1.58 w=0.5 l=0.5
X2503 VDPWR single_9b_cdac_1.cdac_sw_9b_0.cdac_sw_3_7.nooverlap_clk_0.x10.A single_9b_cdac_1.cdac_sw_9b_0.cdac_sw_3_7.tg_sw_3_3.SWN VDPWR sky130_fd_pr__pfet_01v8 ad=0.196 pd=1.47 as=0.168 ps=1.42 w=1.12 l=0.15
X2504 single_9b_cdac_0.cdac_sw_9b_0.S[6] single_9b_cdac_0.cdac_sw_9b_0.cdac_sw_3_6.tg_sw_3_3.SWN single_9b_cdac_0.cdac_sw_9b_0.S[6] VGND sky130_fd_pr__nfet_01v8 ad=0.145 pd=1.58 as=0 ps=0 w=0.5 l=0.5
X2505 single_9b_cdac_1.cdac_sw_9b_0.cdac_sw_3_6.tg_sw_3_3.SWP single_9b_cdac_1.cdac_sw_9b_0.cdac_sw_3_6.tg_sw_3_3.SWN VGND VGND sky130_fd_pr__nfet_01v8_lvt ad=0.1036 pd=1.02 as=0.1295 ps=1.09 w=0.74 l=0.15
X2506 th_dif_sw_0.VCP single_9b_cdac_1.cdac_sw_9b_0.S[2] sky130_fd_pr__cap_mim_m3_1 l=2 w=2
X2507 a_14130_22530# a_13053_22164# a_13968_22164# VDPWR sky130_fd_pr__pfet_01v8_hvt ad=0.0567 pd=0.69 as=0.0588 ps=0.7 w=0.42 l=0.15
X2508 a_62748_26999# single_9b_cdac_0.SW[0] VDPWR VDPWR sky130_fd_pr__pfet_01v8 ad=0.435 pd=3.58 as=0.435 ps=3.58 w=1.5 l=0.5
X2509 VGND VDPWR VGND VGND sky130_fd_pr__nfet_01v8 ad=0.143 pd=1.62 as=0 ps=0 w=0.55 l=0.59
X2510 VDPWR a_6651_23520# a_6567_23618# VDPWR sky130_fd_pr__pfet_01v8_hvt ad=0.1113 pd=1.37 as=0.0882 ps=0.84 w=0.42 l=0.15
X2511 VGND a_7345_21594# sar9b_0.clknet_0_CLK VGND sky130_fd_pr__nfet_01v8 ad=0.0588 pd=0.7 as=0.0588 ps=0.7 w=0.42 l=0.15
X2512 VGND single_9b_cdac_1.cdac_sw_9b_0.cdac_sw_3_8.nooverlap_clk_0.sky130_fd_sc_hs__inv_8_0.A single_9b_cdac_1.cdac_sw_9b_0.cdac_sw_3_8.nooverlap_clk_0.CLKB0 VGND sky130_fd_pr__nfet_01v8_lvt ad=0.1036 pd=1.02 as=0.1036 ps=1.02 w=0.74 l=0.15
X2513 single_9b_cdac_1.cdac_sw_9b_0.cdac_sw_3_7.tg_sw_3_3.SWN single_9b_cdac_1.cdac_sw_9b_0.cdac_sw_3_7.nooverlap_clk_0.x10.A VDPWR VDPWR sky130_fd_pr__pfet_01v8 ad=0.168 pd=1.42 as=0.168 ps=1.42 w=1.12 l=0.15
X2514 a_8553_22164# sar9b_0._06_ sar9b_0._15_ VGND sky130_fd_pr__nfet_01v8 ad=0.08775 pd=0.92 as=0.169 ps=1.82 w=0.65 l=0.15
X2515 a_13665_19988# a_13621_20230# a_13499_19988# VGND sky130_fd_pr__nfet_01v8 ad=0.0441 pd=0.63 as=0.1401 ps=1.1 w=0.42 l=0.15
X2516 th_dif_sw_0.th_sw_1.CKB a_21177_7457# VDPWR VDPWR sky130_fd_pr__pfet_01v8 ad=0.168 pd=1.42 as=0.168 ps=1.42 w=1.12 l=0.15
X2517 th_dif_sw_0.VCP single_9b_cdac_1.cdac_sw_9b_0.S[2] sky130_fd_pr__cap_mim_m3_1 l=2 w=2
X2518 VGND single_9b_cdac_0.cdac_sw_9b_0.cdac_sw_3_4.nooverlap_clk_0.x10.A single_9b_cdac_0.cdac_sw_9b_0.cdac_sw_3_4.tg_sw_3_3.SWN VGND sky130_fd_pr__nfet_01v8_lvt ad=0.2109 pd=2.05 as=0.1036 ps=1.02 w=0.74 l=0.15
X2519 VDPWR VGND VDPWR VDPWR sky130_fd_pr__pfet_01v8_hvt ad=0.2262 pd=2.26 as=0 ps=0 w=0.87 l=0.59
X2520 VDPWR single_9b_cdac_1.cdac_sw_9b_0.cdac_sw_3_7.nooverlap_clk_0.x10.A single_9b_cdac_1.cdac_sw_9b_0.cdac_sw_3_7.tg_sw_3_3.SWN VDPWR sky130_fd_pr__pfet_01v8 ad=0.168 pd=1.42 as=0.168 ps=1.42 w=1.12 l=0.15
X2521 dw_12589_1395# a_10166_3438# sky130_fd_pr__cap_mim_m3_1 l=2 w=2
X2522 VDPWR clk a_16527_10454# VDPWR sky130_fd_pr__pfet_01v8 ad=0.1988 pd=1.505 as=0.147 ps=1.19 w=0.84 l=0.15
X2523 VGND VDPWR VGND VGND sky130_fd_pr__nfet_01v8 ad=0.143 pd=1.62 as=0 ps=0 w=0.55 l=0.59
X2524 single_9b_cdac_0.cdac_sw_9b_0.cdac_sw_3_7.nooverlap_clk_0.CLKB0 single_9b_cdac_0.cdac_sw_9b_0.cdac_sw_3_7.nooverlap_clk_0.sky130_fd_sc_hs__inv_8_0.A VGND VGND sky130_fd_pr__nfet_01v8_lvt ad=0.1036 pd=1.02 as=0.1295 ps=1.09 w=0.74 l=0.15
X2525 th_dif_sw_0.VCN single_9b_cdac_0.cdac_sw_9b_0.S[3] sky130_fd_pr__cap_mim_m3_1 l=2 w=2
X2526 a_12312_20910# a_11231_20538# a_11965_20506# VDPWR sky130_fd_pr__pfet_01v8_hvt ad=0.0588 pd=0.7 as=0.12915 ps=1.185 w=0.42 l=0.15
X2527 single_9b_cdac_1.cdac_sw_9b_0.cdac_sw_3_7.tg_sw_3_3.SWN single_9b_cdac_1.cdac_sw_9b_0.cdac_sw_3_7.nooverlap_clk_0.x10.A VDPWR VDPWR sky130_fd_pr__pfet_01v8 ad=0.168 pd=1.42 as=0.196 ps=1.47 w=1.12 l=0.15
X2528 VGND single_9b_cdac_1.SW[4] a_44418_17740# VGND sky130_fd_pr__nfet_01v8 ad=0.145 pd=1.58 as=0.145 ps=1.58 w=0.5 l=0.5
X2529 th_dif_sw_0.VCN single_9b_cdac_0.cdac_sw_9b_0.S[0] sky130_fd_pr__cap_mim_m3_1 l=2 w=2
X2530 VGND single_9b_cdac_0.cdac_sw_9b_0.cdac_sw_3_6.nooverlap_clk_0.CLKB0 single_9b_cdac_0.cdac_sw_9b_0.cdac_sw_3_6.nooverlap_clk_0.CLK0 VGND sky130_fd_pr__nfet_01v8_lvt ad=0.1554 pd=1.16 as=0.1036 ps=1.02 w=0.74 l=0.15
X2531 VDPWR sar9b_0.net15 a_9167_18874# VDPWR sky130_fd_pr__pfet_01v8_hvt ad=0.0819 pd=0.81 as=0.0567 ps=0.69 w=0.42 l=0.15
X2532 th_dif_sw_0.th_sw_1.CKB a_21177_7457# VGND VGND sky130_fd_pr__nfet_01v8_lvt ad=0.1036 pd=1.02 as=0.2109 ps=2.05 w=0.74 l=0.15
X2533 VGND tdc_0.phase_detector_0.pd_out_0.B a_16159_13315# VGND sky130_fd_pr__nfet_01v8_lvt ad=0.12607 pd=1.1 as=0.17738 ps=1.195 w=0.55 l=0.15
X2534 ua[0] single_9b_cdac_0.cdac_sw_9b_0.cdac_sw_3_2.tg_sw_3_3.SWP ua[0] VDPWR sky130_fd_pr__pfet_01v8 ad=0.435 pd=3.58 as=0 ps=0 w=1.5 l=0.5
X2535 VGND a_10311_17812# sar9b_0.net1 VGND sky130_fd_pr__nfet_01v8 ad=0.1092 pd=1.36 as=0.0567 ps=0.69 w=0.42 l=0.15
X2536 a_10013_19988# a_9535_19962# VGND VGND sky130_fd_pr__nfet_01v8 ad=0.0669 pd=0.75 as=0.12495 ps=1.015 w=0.42 l=0.15
X2537 single_9b_cdac_1.cdac_sw_9b_0.cdac_sw_3_0.nooverlap_clk_0.x6.A single_9b_cdac_1.cdac_sw_9b_0.cdac_sw_3_0.nooverlap_clk_0.x4.A VGND VGND sky130_fd_pr__nfet_01v8_lvt ad=0.2109 pd=2.05 as=0.2627 ps=2.19 w=0.74 l=0.15
X2538 th_dif_sw_0.VCP single_9b_cdac_1.cdac_sw_9b_0.S[0] sky130_fd_pr__cap_mim_m3_1 l=2 w=2
X2539 a_10827_25262# a_10311_24890# a_10732_25250# VGND sky130_fd_pr__special_nfet_01v8 ad=0.0594 pd=0.69 as=0.066 ps=0.745 w=0.36 l=0.15
X2540 a_11554_23618# a_10477_23252# a_11392_23252# VDPWR sky130_fd_pr__pfet_01v8_hvt ad=0.0567 pd=0.69 as=0.0588 ps=0.7 w=0.42 l=0.15
X2541 VGND single_9b_cdac_1.cdac_sw_9b_0.cdac_sw_3_7.nooverlap_clk_0.CLKB0 single_9b_cdac_1.cdac_sw_9b_0.cdac_sw_3_7.nooverlap_clk_0.CLK0 VGND sky130_fd_pr__nfet_01v8_lvt ad=0.1036 pd=1.02 as=0.1036 ps=1.02 w=0.74 l=0.15
X2542 ua[0] single_9b_cdac_1.cdac_sw_9b_0.cdac_sw_3_2.tg_sw_3_3.SWN ua[0] VGND sky130_fd_pr__nfet_01v8 ad=0.145 pd=1.58 as=0 ps=0 w=0.5 l=0.5
X2543 sar9b_0.net3 a_5343_25972# VDPWR VDPWR sky130_fd_pr__pfet_01v8_hvt ad=0.14 pd=1.28 as=0.14 ps=1.28 w=1 l=0.15
X2544 a_31753_15501# single_9b_cdac_1.CF[7] single_9b_cdac_1.cdac_sw_9b_0.cdac_sw_3_7.nooverlap_clk_0.sky130_fd_sc_hs__nand2_1_0.Y VGND sky130_fd_pr__nfet_01v8_lvt ad=0.0888 pd=0.98 as=0.2109 ps=2.05 w=0.74 l=0.15
X2545 th_dif_sw_0.VCP single_9b_cdac_1.cdac_sw_9b_0.S[0] sky130_fd_pr__cap_mim_m3_1 l=2 w=2
X2546 a_5798_19810# a_5483_19676# VGND VGND sky130_fd_pr__nfet_01v8 ad=0.066 pd=0.745 as=0.1092 ps=1.36 w=0.42 l=0.15
X2547 ua[0] single_9b_cdac_0.cdac_sw_9b_0.cdac_sw_3_6.tg_sw_3_3.SWP ua[0] VDPWR sky130_fd_pr__pfet_01v8 ad=0.435 pd=3.58 as=0 ps=0 w=1.5 l=0.5
X2548 ua[0] single_9b_cdac_0.cdac_sw_9b_0.cdac_sw_3_2.tg_sw_3_3.SWN ua[0] VGND sky130_fd_pr__nfet_01v8 ad=0.145 pd=1.58 as=0 ps=0 w=0.5 l=0.5
X2549 VGND single_9b_cdac_1.cdac_sw_9b_0.cdac_sw_3_6.nooverlap_clk_0.x1.A single_9b_cdac_1.cdac_sw_9b_0.cdac_sw_3_6.nooverlap_clk_0.sky130_fd_sc_hs__inv_8_0.A VGND sky130_fd_pr__nfet_01v8_lvt ad=0.1221 pd=1.07 as=0.1184 ps=1.06 w=0.74 l=0.15
X2550 single_9b_cdac_0.cdac_sw_9b_0.S[1] single_9b_cdac_0.cdac_sw_9b_0.cdac_sw_3_1.tg_sw_3_3.SWP single_9b_cdac_0.cdac_sw_9b_0.S[1] VDPWR sky130_fd_pr__pfet_01v8 ad=0.435 pd=3.58 as=0 ps=0 w=1.5 l=0.5
X2551 VGND single_9b_cdac_1.cdac_sw_9b_0.cdac_sw_3_7.nooverlap_clk_0.x8.A single_9b_cdac_1.cdac_sw_9b_0.cdac_sw_3_7.nooverlap_clk_0.x10.A VGND sky130_fd_pr__nfet_01v8_lvt ad=0.2109 pd=2.05 as=0.1036 ps=1.02 w=0.74 l=0.15
X2552 th_dif_sw_0.VCP single_9b_cdac_1.cdac_sw_9b_0.S[2] sky130_fd_pr__cap_mim_m3_1 l=2 w=2
X2553 a_13968_22164# a_13053_22164# a_13621_22406# VGND sky130_fd_pr__special_nfet_01v8 ad=0.0711 pd=0.755 as=0.0999 ps=0.985 w=0.36 l=0.15
X2554 sar9b_0.clknet_0_CLK a_7345_21594# VGND VGND sky130_fd_pr__nfet_01v8 ad=0.0588 pd=0.7 as=0.0588 ps=0.7 w=0.42 l=0.15
X2555 a_16222_11316# tdc_0.phase_detector_0.INN VDPWR VDPWR sky130_fd_pr__pfet_01v8 ad=0.435 pd=3.29 as=0.87 ps=6.58 w=3 l=0.15
X2556 VGND sar9b_0.FINAL a_9115_26516# VGND sky130_fd_pr__nfet_01v8 ad=0.0567 pd=0.69 as=0.1092 ps=1.36 w=0.42 l=0.15
X2557 single_9b_cdac_0.cdac_sw_9b_0.S[0] single_9b_cdac_0.cdac_sw_9b_0.cdac_sw_3_2.tg_sw_3_3.SWN single_9b_cdac_0.cdac_sw_9b_0.S[0] VGND sky130_fd_pr__nfet_01v8 ad=0.145 pd=1.58 as=0 ps=0 w=0.5 l=0.5
X2558 VDPWR single_9b_cdac_1.CF[3] single_9b_cdac_0.cdac_sw_9b_0.cdac_sw_3_4.nooverlap_clk_0.sky130_fd_sc_hs__nand2_1_0.Y VDPWR sky130_fd_pr__pfet_01v8 ad=0.3192 pd=2.81 as=0.168 ps=1.42 w=1.12 l=0.15
X2559 single_9b_cdac_0.cdac_sw_9b_0.cdac_sw_3_3.tg_sw_3_3.SWN single_9b_cdac_0.cdac_sw_9b_0.cdac_sw_3_3.nooverlap_clk_0.x10.A VGND VGND sky130_fd_pr__nfet_01v8_lvt ad=0.1036 pd=1.02 as=0.1554 ps=1.16 w=0.74 l=0.15
X2560 single_9b_cdac_1.cdac_sw_9b_0.S[1] single_9b_cdac_1.cdac_sw_9b_0.cdac_sw_3_1.tg_sw_3_3.SWN single_9b_cdac_1.cdac_sw_9b_0.S[1] VGND sky130_fd_pr__nfet_01v8 ad=0.145 pd=1.58 as=2.32 ps=25.28 w=0.5 l=0.5
X2561 th_dif_sw_0.VCN single_9b_cdac_0.cdac_sw_9b_0.S[3] sky130_fd_pr__cap_mim_m3_1 l=2 w=2
X2562 single_9b_cdac_1.cdac_sw_9b_0.cdac_sw_3_8.tg_sw_3_3.SWP single_9b_cdac_1.cdac_sw_9b_0.cdac_sw_3_8.tg_sw_3_3.SWN VGND VGND sky130_fd_pr__nfet_01v8_lvt ad=0.1036 pd=1.02 as=0.1554 ps=1.16 w=0.74 l=0.15
X2563 VGND single_9b_cdac_1.cdac_sw_9b_0.cdac_sw_3_7.nooverlap_clk_0.x10.A single_9b_cdac_1.cdac_sw_9b_0.cdac_sw_3_7.tg_sw_3_3.SWN VGND sky130_fd_pr__nfet_01v8_lvt ad=0.1554 pd=1.16 as=0.1036 ps=1.02 w=0.74 l=0.15
X2564 single_9b_cdac_1.cdac_sw_9b_0.cdac_sw_3_6.nooverlap_clk_0.CLKB0 single_9b_cdac_1.cdac_sw_9b_0.cdac_sw_3_6.nooverlap_clk_0.sky130_fd_sc_hs__inv_8_0.A VGND VGND sky130_fd_pr__nfet_01v8_lvt ad=0.1036 pd=1.02 as=0.1036 ps=1.02 w=0.74 l=0.15
X2565 th_dif_sw_0.VCN single_9b_cdac_0.cdac_sw_9b_0.S[0] sky130_fd_pr__cap_mim_m3_1 l=2 w=2
X2566 a_10211_20225# a_10016_20256# a_10521_19988# VGND sky130_fd_pr__special_nfet_01v8 ad=0.0594 pd=0.69 as=0.1401 ps=1.1 w=0.36 l=0.15
X2567 a_5393_17977# sar9b_0.net16 VDPWR VDPWR sky130_fd_pr__pfet_01v8_hvt ad=0.2054 pd=2.1 as=0.11455 ps=1.08 w=0.79 l=0.15
X2568 VGND sar9b_0.net15 a_9773_19988# VGND sky130_fd_pr__nfet_01v8 ad=0.12495 pd=1.015 as=0.06405 ps=0.725 w=0.42 l=0.15
X2569 single_9b_cdac_1.cdac_sw_9b_0.S[6] single_9b_cdac_1.cdac_sw_9b_0.cdac_sw_3_6.tg_sw_3_3.SWN single_9b_cdac_1.cdac_sw_9b_0.S[6] VGND sky130_fd_pr__nfet_01v8 ad=0.145 pd=1.58 as=0 ps=0 w=0.5 l=0.5
X2570 VGND single_9b_cdac_1.cdac_sw_9b_0.cdac_sw_3_1.nooverlap_clk_0.CLKB0 single_9b_cdac_1.cdac_sw_9b_0.cdac_sw_3_1.nooverlap_clk_0.CLK0 VGND sky130_fd_pr__nfet_01v8_lvt ad=0.1295 pd=1.09 as=0.1036 ps=1.02 w=0.74 l=0.15
X2571 single_9b_cdac_0.cdac_sw_9b_0.cdac_sw_3_4.nooverlap_clk_0.sky130_fd_sc_hs__nand2_1_0.Y single_9b_cdac_0.cdac_sw_9b_0.cdac_sw_3_4.nooverlap_clk_0.x8.A VDPWR VDPWR sky130_fd_pr__pfet_01v8 ad=0.168 pd=1.42 as=0.3192 ps=2.81 w=1.12 l=0.15
X2572 a_6061_19988# a_5895_19988# VDPWR VDPWR sky130_fd_pr__pfet_01v8_hvt ad=0.1664 pd=1.8 as=0.0864 ps=0.91 w=0.64 l=0.15
X2573 single_9b_cdac_0.cdac_sw_9b_0.cdac_sw_3_0.nooverlap_clk_0.x10.A single_9b_cdac_0.cdac_sw_9b_0.cdac_sw_3_0.nooverlap_clk_0.x8.A VGND VGND sky130_fd_pr__nfet_01v8_lvt ad=0.1036 pd=1.02 as=0.2109 ps=2.05 w=0.74 l=0.15
X2574 th_dif_sw_0.VCN single_9b_cdac_0.cdac_sw_9b_0.S[0] sky130_fd_pr__cap_mim_m3_1 l=2 w=2
X2575 single_9b_cdac_0.cdac_sw_9b_0.S[6] single_9b_cdac_0.cdac_sw_9b_0.cdac_sw_3_6.nooverlap_clk_0.CLKB0 a_33936_26999# VDPWR sky130_fd_pr__pfet_01v8 ad=0.435 pd=3.58 as=0.435 ps=3.58 w=1.5 l=0.5
X2576 a_11395_22530# sar9b_0.net15 VDPWR VDPWR sky130_fd_pr__pfet_01v8_hvt ad=0.1092 pd=1.36 as=0.07035 ps=0.755 w=0.42 l=0.15
X2577 a_13403_21076# a_13053_21076# a_13308_21076# VDPWR sky130_fd_pr__pfet_01v8_hvt ad=0.07245 pd=0.765 as=0.0651 ps=0.73 w=0.42 l=0.15
X2578 a_12036_26516# a_11121_26516# a_11689_26758# VGND sky130_fd_pr__special_nfet_01v8 ad=0.0711 pd=0.755 as=0.0999 ps=0.985 w=0.36 l=0.15
X2579 a_29134_26999# single_9b_cdac_0.SW[7] VDPWR VDPWR sky130_fd_pr__pfet_01v8 ad=0.435 pd=3.58 as=0.435 ps=3.58 w=1.5 l=0.5
X2580 VGND sar9b_0.net4 a_8379_24340# VGND sky130_fd_pr__nfet_01v8 ad=0.0567 pd=0.69 as=0.1092 ps=1.36 w=0.42 l=0.15
X2581 a_59529_15495# single_9b_cdac_1.cdac_sw_9b_0.cdac_sw_3_1.nooverlap_clk_0.x3.Y VGND VGND sky130_fd_pr__nfet_01v8_lvt ad=0.0888 pd=0.98 as=0.2109 ps=2.05 w=0.74 l=0.15
X2582 VGND single_9b_cdac_0.cdac_sw_9b_0.cdac_sw_3_0.nooverlap_clk_0.sky130_fd_sc_hs__inv_1_1.A single_9b_cdac_0.cdac_sw_9b_0.cdac_sw_3_0.nooverlap_clk_0.x1.A VGND sky130_fd_pr__nfet_01v8_lvt ad=0.2627 pd=2.19 as=0.2109 ps=2.05 w=0.74 l=0.15
X2583 VGND single_9b_cdac_0.cdac_sw_9b_0.cdac_sw_3_2.nooverlap_clk_0.x8.A single_9b_cdac_0.cdac_sw_9b_0.cdac_sw_3_2.nooverlap_clk_0.x10.A VGND sky130_fd_pr__nfet_01v8_lvt ad=0.1221 pd=1.07 as=0.1036 ps=1.02 w=0.74 l=0.15
X2584 a_9083_23252# a_8637_23252# a_8987_23252# VGND sky130_fd_pr__special_nfet_01v8 ad=0.1401 pd=1.1 as=0.0594 ps=0.69 w=0.36 l=0.15
X2585 a_9132_7271# th_dif_sw_0.CK VDPWR VDPWR sky130_fd_pr__pfet_01v8 ad=0.168 pd=1.42 as=0.168 ps=1.42 w=1.12 l=0.15
X2586 single_9b_cdac_1.cdac_sw_9b_0.cdac_sw_3_2.nooverlap_clk_0.sky130_fd_sc_hs__inv_8_0.A single_9b_cdac_1.cdac_sw_9b_0.cdac_sw_3_2.nooverlap_clk_0.x1.A VGND VGND sky130_fd_pr__nfet_01v8_lvt ad=0.1036 pd=1.02 as=0.1221 ps=1.07 w=0.74 l=0.15
X2587 VGND single_9b_cdac_0.cdac_sw_9b_0.cdac_sw_3_8.nooverlap_clk_0.CLKB0 single_9b_cdac_0.cdac_sw_9b_0.cdac_sw_3_8.nooverlap_clk_0.CLK0 VGND sky130_fd_pr__nfet_01v8_lvt ad=0.1295 pd=1.09 as=0.1036 ps=1.02 w=0.74 l=0.15
X2588 VDPWR single_9b_cdac_0.cdac_sw_9b_0.cdac_sw_3_3.nooverlap_clk_0.x10.A single_9b_cdac_0.cdac_sw_9b_0.cdac_sw_3_3.tg_sw_3_3.SWN VDPWR sky130_fd_pr__pfet_01v8 ad=0.3304 pd=2.83 as=0.168 ps=1.42 w=1.12 l=0.15
X2589 VGND sar9b_0.net5 a_13347_21620# VGND sky130_fd_pr__nfet_01v8 ad=0.0754 pd=0.81 as=0.1352 ps=1.56 w=0.52 l=0.15
X2590 th_dif_sw_0.VCP single_9b_cdac_1.cdac_sw_9b_0.S[0] sky130_fd_pr__cap_mim_m3_1 l=2 w=2
X2591 a_10477_19450# a_10311_19450# VDPWR VDPWR sky130_fd_pr__pfet_01v8_hvt ad=0.1664 pd=1.8 as=0.0864 ps=0.91 w=0.64 l=0.15
X2592 th_dif_sw_0.VCP single_9b_cdac_1.cdac_sw_9b_0.S[1] sky130_fd_pr__cap_mim_m3_1 l=2 w=2
X2593 VDPWR VGND VDPWR VDPWR sky130_fd_pr__pfet_01v8_hvt ad=0.2262 pd=2.26 as=0 ps=0 w=0.87 l=0.59
X2594 th_dif_sw_0.VCP single_9b_cdac_1.cdac_sw_9b_0.S[0] sky130_fd_pr__cap_mim_m3_1 l=2 w=2
X2595 th_dif_sw_0.VCN single_9b_cdac_0.cdac_sw_9b_0.S[1] sky130_fd_pr__cap_mim_m3_1 l=2 w=2
X2596 single_9b_cdac_0.cdac_sw_9b_0.cdac_sw_3_2.nooverlap_clk_0.CLK0 single_9b_cdac_0.cdac_sw_9b_0.cdac_sw_3_2.nooverlap_clk_0.CLKB0 VGND VGND sky130_fd_pr__nfet_01v8_lvt ad=0.1036 pd=1.02 as=0.1554 ps=1.16 w=0.74 l=0.15
X2597 single_9b_cdac_0.cdac_sw_9b_0.cdac_sw_3_3.tg_sw_3_3.SWN single_9b_cdac_0.cdac_sw_9b_0.cdac_sw_3_3.nooverlap_clk_0.x10.A VDPWR VDPWR sky130_fd_pr__pfet_01v8 ad=0.168 pd=1.42 as=0.196 ps=1.47 w=1.12 l=0.15
X2598 VDPWR single_9b_cdac_0.cdac_sw_9b_0.cdac_sw_3_3.nooverlap_clk_0.sky130_fd_sc_hs__inv_8_0.A single_9b_cdac_0.cdac_sw_9b_0.cdac_sw_3_3.nooverlap_clk_0.CLKB0 VDPWR sky130_fd_pr__pfet_01v8 ad=0.196 pd=1.47 as=0.168 ps=1.42 w=1.12 l=0.15
X2599 single_9b_cdac_1.cdac_sw_9b_0.cdac_sw_3_2.nooverlap_clk_0.CLKB0 single_9b_cdac_1.cdac_sw_9b_0.cdac_sw_3_2.nooverlap_clk_0.sky130_fd_sc_hs__inv_8_0.A VGND VGND sky130_fd_pr__nfet_01v8_lvt ad=0.1036 pd=1.02 as=0.1295 ps=1.09 w=0.74 l=0.15
X2600 a_14130_22708# a_13053_22714# a_13968_23086# VDPWR sky130_fd_pr__pfet_01v8_hvt ad=0.0567 pd=0.69 as=0.0588 ps=0.7 w=0.42 l=0.15
X2601 a_12211_18874# sar9b_0.net15 VDPWR VDPWR sky130_fd_pr__pfet_01v8_hvt ad=0.0567 pd=0.69 as=0.0819 ps=0.81 w=0.42 l=0.15
X2602 th_dif_sw_0.VCP single_9b_cdac_1.cdac_sw_9b_0.S[0] sky130_fd_pr__cap_mim_m3_1 l=2 w=2
X2603 VGND single_9b_cdac_0.cdac_sw_9b_0.cdac_sw_3_4.nooverlap_clk_0.x10.A single_9b_cdac_0.cdac_sw_9b_0.cdac_sw_3_4.tg_sw_3_3.SWN VGND sky130_fd_pr__nfet_01v8_lvt ad=0.1036 pd=1.02 as=0.1036 ps=1.02 w=0.74 l=0.15
X2604 a_6007_27302# sar9b_0.FINAL VDPWR VDPWR sky130_fd_pr__pfet_01v8_hvt ad=0.1664 pd=1.8 as=0.0864 ps=0.91 w=0.64 l=0.15
X2605 single_9b_cdac_0.cdac_sw_9b_0.cdac_sw_3_3.nooverlap_clk_0.CLKB0 single_9b_cdac_0.cdac_sw_9b_0.cdac_sw_3_3.nooverlap_clk_0.sky130_fd_sc_hs__inv_8_0.A VDPWR VDPWR sky130_fd_pr__pfet_01v8 ad=0.168 pd=1.42 as=0.3864 ps=2.93 w=1.12 l=0.15
X2606 VDPWR single_9b_cdac_1.cdac_sw_9b_0.cdac_sw_3_6.nooverlap_clk_0.CLKB0 single_9b_cdac_1.cdac_sw_9b_0.cdac_sw_3_6.nooverlap_clk_0.CLK0 VDPWR sky130_fd_pr__pfet_01v8 ad=0.196 pd=1.47 as=0.168 ps=1.42 w=1.12 l=0.15
X2607 single_9b_cdac_1.cdac_sw_9b_0.S[6] single_9b_cdac_1.cdac_sw_9b_0.cdac_sw_3_6.tg_sw_3_3.SWP single_9b_cdac_1.cdac_sw_9b_0.S[6] VDPWR sky130_fd_pr__pfet_01v8 ad=0.435 pd=3.58 as=0 ps=0 w=1.5 l=0.5
X2608 VDPWR single_9b_cdac_1.cdac_sw_9b_0.cdac_sw_3_4.nooverlap_clk_0.x1.A single_9b_cdac_1.cdac_sw_9b_0.cdac_sw_3_4.nooverlap_clk_0.sky130_fd_sc_hs__inv_8_0.A VDPWR sky130_fd_pr__pfet_01v8 ad=0.3304 pd=2.83 as=0.168 ps=1.42 w=1.12 l=0.15
X2609 th_dif_sw_0.VCN th_dif_sw_0.th_sw_0.th_sw_main_0.VGS ua[1] VGND sky130_fd_pr__nfet_01v8 ad=5.8 pd=40.58 as=5.8 ps=40.58 w=20 l=0.15
X2610 VDPWR single_9b_cdac_0.cdac_sw_9b_0.cdac_sw_3_4.nooverlap_clk_0.CLKB0 single_9b_cdac_0.cdac_sw_9b_0.cdac_sw_3_4.nooverlap_clk_0.CLK0 VDPWR sky130_fd_pr__pfet_01v8 ad=0.196 pd=1.47 as=0.168 ps=1.42 w=1.12 l=0.15
X2611 a_8800_26338# sar9b_0.net40 VGND VGND sky130_fd_pr__nfet_01v8 ad=0.066 pd=0.745 as=0.2205 ps=1.89 w=0.42 l=0.15
X2612 VGND sar9b_0.FINAL a_5803_25428# VGND sky130_fd_pr__nfet_01v8 ad=0.0567 pd=0.69 as=0.1092 ps=1.36 w=0.42 l=0.15
X2613 a_6870_26516# sar9b_0.net3 VGND VGND sky130_fd_pr__nfet_01v8 ad=0.06405 pd=0.725 as=0.12495 ps=1.015 w=0.42 l=0.15
X2614 a_8867_23796# a_8085_23802# a_8783_23796# VDPWR sky130_fd_pr__pfet_01v8_hvt ad=0.0882 pd=0.84 as=0.0567 ps=0.69 w=0.42 l=0.15
X2615 VGND VDPWR VGND VGND sky130_fd_pr__nfet_01v8 ad=0.143 pd=1.62 as=0 ps=0 w=0.55 l=0.59
X2616 th_dif_sw_0.VCN single_9b_cdac_0.cdac_sw_9b_0.S[0] sky130_fd_pr__cap_mim_m3_1 l=2 w=2
X2617 single_9b_cdac_0.SW[5] a_14175_25972# VGND VGND sky130_fd_pr__nfet_01v8 ad=0.1352 pd=1.56 as=0.0754 ps=0.81 w=0.52 l=0.15
X2618 VGND VDPWR VGND VGND sky130_fd_pr__nfet_01v8 ad=0.143 pd=1.62 as=0 ps=0 w=0.55 l=0.59
X2619 single_9b_cdac_1.cdac_sw_9b_0.cdac_sw_3_6.nooverlap_clk_0.CLK0 single_9b_cdac_1.cdac_sw_9b_0.cdac_sw_3_6.nooverlap_clk_0.CLKB0 VDPWR VDPWR sky130_fd_pr__pfet_01v8 ad=0.168 pd=1.42 as=0.3304 ps=2.83 w=1.12 l=0.15
X2620 single_9b_cdac_1.cdac_sw_9b_0.S[4] single_9b_cdac_1.cdac_sw_9b_0.cdac_sw_3_3.tg_sw_3_3.SWN ua[0] VDPWR sky130_fd_pr__pfet_01v8 ad=0.435 pd=3.58 as=0.435 ps=3.58 w=1.5 l=0.5
X2621 th_dif_sw_0.VCN single_9b_cdac_0.cdac_sw_9b_0.S[0] sky130_fd_pr__cap_mim_m3_1 l=2 w=2
X2622 VDPWR a_13529_23770# a_13419_23796# VDPWR sky130_fd_pr__pfet_01v8_hvt ad=0.07035 pd=0.755 as=0.1155 ps=0.97 w=0.42 l=0.15
X2623 single_9b_cdac_1.cdac_sw_9b_0.cdac_sw_3_4.nooverlap_clk_0.sky130_fd_sc_hs__inv_8_0.A single_9b_cdac_1.cdac_sw_9b_0.cdac_sw_3_4.nooverlap_clk_0.x1.A VDPWR VDPWR sky130_fd_pr__pfet_01v8 ad=0.168 pd=1.42 as=0.168 ps=1.42 w=1.12 l=0.15
X2624 VDPWR a_21177_7457# th_dif_sw_0.th_sw_1.CKB VDPWR sky130_fd_pr__pfet_01v8 ad=0.196 pd=1.47 as=0.168 ps=1.42 w=1.12 l=0.15
X2625 a_8987_23252# a_8471_23252# a_8892_23252# VGND sky130_fd_pr__special_nfet_01v8 ad=0.0594 pd=0.69 as=0.066 ps=0.745 w=0.36 l=0.15
X2626 VGND VDPWR VGND VGND sky130_fd_pr__nfet_01v8 ad=0.143 pd=1.62 as=0 ps=0 w=0.55 l=0.59
X2627 a_6094_27060# a_5968_27176# a_5690_27192# VGND sky130_fd_pr__special_nfet_01v8 ad=0.0999 pd=0.985 as=0.0711 ps=0.755 w=0.36 l=0.15
X2628 a_8653_27034# a_8435_27438# VGND VGND sky130_fd_pr__nfet_01v8 ad=0.0999 pd=0.985 as=0.1346 ps=1.15 w=0.64 l=0.15
X2629 a_62748_26999# single_9b_cdac_0.SW[0] VDPWR VDPWR sky130_fd_pr__pfet_01v8 ad=0.435 pd=3.58 as=0.435 ps=3.58 w=1.5 l=0.5
X2630 VDPWR single_9b_cdac_1.cdac_sw_9b_0.cdac_sw_3_4.nooverlap_clk_0.x1.A single_9b_cdac_1.cdac_sw_9b_0.cdac_sw_3_4.nooverlap_clk_0.sky130_fd_sc_hs__inv_8_0.A VDPWR sky130_fd_pr__pfet_01v8 ad=0.168 pd=1.42 as=0.168 ps=1.42 w=1.12 l=0.15
X2631 th_dif_sw_0.VCP single_9b_cdac_1.cdac_sw_9b_0.S[1] sky130_fd_pr__cap_mim_m3_1 l=2 w=2
X2632 th_dif_sw_0.VCN single_9b_cdac_0.cdac_sw_9b_0.S[1] sky130_fd_pr__cap_mim_m3_1 l=2 w=2
X2633 single_9b_cdac_0.cdac_sw_9b_0.cdac_sw_3_8.nooverlap_clk_0.sky130_fd_sc_hs__inv_8_0.A single_9b_cdac_0.cdac_sw_9b_0.cdac_sw_3_8.nooverlap_clk_0.x1.A VDPWR VDPWR sky130_fd_pr__pfet_01v8 ad=0.168 pd=1.42 as=0.168 ps=1.42 w=1.12 l=0.15
X2634 VGND single_9b_cdac_0.cdac_sw_9b_0.cdac_sw_3_7.nooverlap_clk_0.x1.A single_9b_cdac_0.cdac_sw_9b_0.cdac_sw_3_7.nooverlap_clk_0.sky130_fd_sc_hs__inv_8_0.A VGND sky130_fd_pr__nfet_01v8_lvt ad=0.1221 pd=1.07 as=0.1036 ps=1.02 w=0.74 l=0.15
X2635 single_9b_cdac_0.cdac_sw_9b_0.S[3] single_9b_cdac_0.cdac_sw_9b_0.cdac_sw_3_4.tg_sw_3_3.SWN ua[0] VDPWR sky130_fd_pr__pfet_01v8 ad=0.435 pd=3.58 as=0.435 ps=3.58 w=1.5 l=0.5
X2636 VDPWR VGND VDPWR VDPWR sky130_fd_pr__pfet_01v8_hvt ad=0.2262 pd=2.26 as=0 ps=0 w=0.87 l=0.59
X2637 ua[0] single_9b_cdac_1.cdac_sw_9b_0.cdac_sw_3_0.tg_sw_3_3.SWP ua[0] VDPWR sky130_fd_pr__pfet_01v8 ad=0.435 pd=3.58 as=0 ps=0 w=1.5 l=0.5
X2638 VDPWR VGND VDPWR VDPWR sky130_fd_pr__pfet_01v8_hvt ad=0.2262 pd=2.26 as=0 ps=0 w=0.87 l=0.59
X2639 sar9b_0.clknet_1_1__leaf_CLK a_6149_23770# VGND VGND sky130_fd_pr__nfet_01v8 ad=0.0588 pd=0.7 as=0.0588 ps=0.7 w=0.42 l=0.15
X2640 VDPWR single_9b_cdac_0.cdac_sw_9b_0.cdac_sw_3_8.nooverlap_clk_0.x1.A single_9b_cdac_0.cdac_sw_9b_0.cdac_sw_3_8.nooverlap_clk_0.sky130_fd_sc_hs__inv_8_0.A VDPWR sky130_fd_pr__pfet_01v8 ad=0.168 pd=1.42 as=0.168 ps=1.42 w=1.12 l=0.15
X2641 a_9460_24340# a_8379_24340# a_9113_24582# VDPWR sky130_fd_pr__pfet_01v8_hvt ad=0.0588 pd=0.7 as=0.12915 ps=1.185 w=0.42 l=0.15
X2642 a_10406_19266# a_9648_19168# a_9843_19137# VDPWR sky130_fd_pr__pfet_01v8_hvt ad=0.0651 pd=0.73 as=0.07245 ps=0.765 w=0.42 l=0.15
X2643 single_9b_cdac_1.cdac_sw_9b_0.cdac_sw_3_4.nooverlap_clk_0.sky130_fd_sc_hs__inv_8_0.A single_9b_cdac_1.cdac_sw_9b_0.cdac_sw_3_4.nooverlap_clk_0.x1.A VDPWR VDPWR sky130_fd_pr__pfet_01v8 ad=0.168 pd=1.42 as=0.3304 ps=2.83 w=1.12 l=0.15
X2644 th_dif_sw_0.VCN single_9b_cdac_0.cdac_sw_9b_0.S[0] sky130_fd_pr__cap_mim_m3_1 l=2 w=2
X2645 VGND single_9b_cdac_0.cdac_sw_9b_0.cdac_sw_3_3.nooverlap_clk_0.sky130_fd_sc_hs__inv_1_1.A single_9b_cdac_0.cdac_sw_9b_0.cdac_sw_3_3.nooverlap_clk_0.x1.A VGND sky130_fd_pr__nfet_01v8_lvt ad=0.2627 pd=2.19 as=0.2109 ps=2.05 w=0.74 l=0.15
X2646 a_33936_26999# single_9b_cdac_0.SW[6] VDPWR VDPWR sky130_fd_pr__pfet_01v8 ad=0.435 pd=3.58 as=0.435 ps=3.58 w=1.5 l=0.5
X2647 th_dif_sw_0.VCP single_9b_cdac_1.cdac_sw_9b_0.S[0] sky130_fd_pr__cap_mim_m3_1 l=2 w=2
X2648 VGND sar9b_0.net15 a_11549_22164# VGND sky130_fd_pr__nfet_01v8 ad=0.1346 pd=1.15 as=0.0441 ps=0.63 w=0.42 l=0.15
X2649 ua[0] single_9b_cdac_1.cdac_sw_9b_0.cdac_sw_3_5.tg_sw_3_3.SWP ua[0] VDPWR sky130_fd_pr__pfet_01v8 ad=0.435 pd=3.58 as=0 ps=0 w=1.5 l=0.5
X2650 single_9b_cdac_1.cdac_sw_9b_0.cdac_sw_3_0.tg_sw_3_3.SWP single_9b_cdac_1.cdac_sw_9b_0.cdac_sw_3_0.tg_sw_3_3.SWN VGND VGND sky130_fd_pr__nfet_01v8_lvt ad=0.1036 pd=1.02 as=0.1036 ps=1.02 w=0.74 l=0.15
X2651 single_9b_cdac_0.cdac_sw_9b_0.cdac_sw_3_8.nooverlap_clk_0.sky130_fd_sc_hs__inv_8_0.A single_9b_cdac_0.cdac_sw_9b_0.cdac_sw_3_8.nooverlap_clk_0.x1.A VDPWR VDPWR sky130_fd_pr__pfet_01v8 ad=0.168 pd=1.42 as=0.3304 ps=2.83 w=1.12 l=0.15
X2652 single_9b_cdac_0.cdac_sw_9b_0.S[3] single_9b_cdac_0.cdac_sw_9b_0.cdac_sw_3_4.nooverlap_clk_0.CLKB0 a_48343_26999# VDPWR sky130_fd_pr__pfet_01v8 ad=0.435 pd=3.58 as=0.435 ps=3.58 w=1.5 l=0.5
X2653 a_12312_20910# a_11397_20538# a_11965_20506# VGND sky130_fd_pr__special_nfet_01v8 ad=0.0711 pd=0.755 as=0.0999 ps=0.985 w=0.36 l=0.15
X2654 single_9b_cdac_1.cdac_sw_9b_0.S[3] single_9b_cdac_1.cdac_sw_9b_0.cdac_sw_3_4.tg_sw_3_3.SWN ua[0] VDPWR sky130_fd_pr__pfet_01v8 ad=0.435 pd=3.58 as=0.435 ps=3.58 w=1.5 l=0.5
X2655 th_dif_sw_0.VCP single_9b_cdac_1.cdac_sw_9b_0.S[1] sky130_fd_pr__cap_mim_m3_1 l=2 w=2
X2656 th_dif_sw_0.VCN single_9b_cdac_0.cdac_sw_9b_0.S[1] sky130_fd_pr__cap_mim_m3_1 l=2 w=2
X2657 th_dif_sw_0.VCN single_9b_cdac_0.cdac_sw_9b_0.S[1] sky130_fd_pr__cap_mim_m3_1 l=2 w=2
X2658 single_9b_cdac_1.cdac_sw_9b_0.S[0] single_9b_cdac_1.cdac_sw_9b_0.cdac_sw_3_2.nooverlap_clk_0.CLKB0 a_62748_16877# VDPWR sky130_fd_pr__pfet_01v8 ad=0.435 pd=3.58 as=0.435 ps=3.58 w=1.5 l=0.5
X2659 VGND single_9b_cdac_1.SW[5] a_39616_17740# VGND sky130_fd_pr__nfet_01v8 ad=0.145 pd=1.58 as=0.145 ps=1.58 w=0.5 l=0.5
X2660 VGND sar9b_0.net15 a_13665_26516# VGND sky130_fd_pr__nfet_01v8 ad=0.1346 pd=1.15 as=0.0441 ps=0.63 w=0.42 l=0.15
X2661 a_39616_17740# single_9b_cdac_1.cdac_sw_9b_0.cdac_sw_3_5.nooverlap_clk_0.CLK0 single_9b_cdac_1.cdac_sw_9b_0.S[5] VGND sky130_fd_pr__nfet_01v8 ad=0.145 pd=1.58 as=0.145 ps=1.58 w=0.5 l=0.5
X2662 single_9b_cdac_1.cdac_sw_9b_0.cdac_sw_3_3.tg_sw_3_3.SWN single_9b_cdac_1.cdac_sw_9b_0.cdac_sw_3_3.nooverlap_clk_0.x10.A VDPWR VDPWR sky130_fd_pr__pfet_01v8 ad=0.168 pd=1.42 as=0.3304 ps=2.83 w=1.12 l=0.15
X2663 VDPWR VGND VDPWR VDPWR sky130_fd_pr__pfet_01v8_hvt ad=0.2262 pd=2.26 as=0 ps=0 w=0.87 l=0.59
X2664 single_9b_cdac_1.cdac_sw_9b_0.cdac_sw_3_5.tg_sw_3_3.SWP single_9b_cdac_1.cdac_sw_9b_0.cdac_sw_3_5.tg_sw_3_3.SWN VGND VGND sky130_fd_pr__nfet_01v8_lvt ad=0.1036 pd=1.02 as=0.1554 ps=1.16 w=0.74 l=0.15
X2665 th_dif_sw_0.VCP single_9b_cdac_1.cdac_sw_9b_0.S[1] sky130_fd_pr__cap_mim_m3_1 l=2 w=2
X2666 VGND single_9b_cdac_1.cdac_sw_9b_0.cdac_sw_3_2.tg_sw_3_3.SWN single_9b_cdac_1.cdac_sw_9b_0.cdac_sw_3_2.tg_sw_3_3.SWP VGND sky130_fd_pr__nfet_01v8_lvt ad=0.1295 pd=1.09 as=0.1036 ps=1.02 w=0.74 l=0.15
X2667 sar9b_0.net14 a_13379_27398# VGND VGND sky130_fd_pr__nfet_01v8 ad=0.182 pd=1.86 as=0.1118 ps=1.04 w=0.65 l=0.15
X2668 VDPWR single_9b_cdac_1.cdac_sw_9b_0.cdac_sw_3_5.tg_sw_3_3.SWN single_9b_cdac_1.cdac_sw_9b_0.cdac_sw_3_5.tg_sw_3_3.SWP VDPWR sky130_fd_pr__pfet_01v8 ad=0.3864 pd=2.93 as=0.168 ps=1.42 w=1.12 l=0.15
X2669 tdc_0.delay_gate_ori_1.sky130_fd_sc_hs__and2_1_0.A a_16331_9671# VGND VGND sky130_fd_pr__nfet_01v8 ad=0.29 pd=2.58 as=0.145 ps=1.29 w=1 l=1
X2670 VDPWR single_9b_cdac_0.cdac_sw_9b_0.cdac_sw_3_1.nooverlap_clk_0.x10.A single_9b_cdac_0.cdac_sw_9b_0.cdac_sw_3_1.tg_sw_3_3.SWN VDPWR sky130_fd_pr__pfet_01v8 ad=0.196 pd=1.47 as=0.168 ps=1.42 w=1.12 l=0.15
X2671 ua[0] single_9b_cdac_0.cdac_sw_9b_0.cdac_sw_3_6.tg_sw_3_3.SWP ua[0] VDPWR sky130_fd_pr__pfet_01v8 ad=0.435 pd=3.58 as=0 ps=0 w=1.5 l=0.5
X2672 a_6778_22682# a_6610_22708# VDPWR VDPWR sky130_fd_pr__pfet_01v8_hvt ad=0.1095 pd=1.075 as=0.17887 ps=1.26 w=0.75 l=0.15
X2673 single_9b_cdac_1.cdac_sw_9b_0.cdac_sw_3_5.tg_sw_3_3.SWP single_9b_cdac_1.cdac_sw_9b_0.cdac_sw_3_5.tg_sw_3_3.SWN VDPWR VDPWR sky130_fd_pr__pfet_01v8 ad=0.168 pd=1.42 as=0.196 ps=1.47 w=1.12 l=0.15
X2674 VDPWR single_9b_cdac_1.cdac_sw_9b_0.cdac_sw_3_5.nooverlap_clk_0.CLKB0 single_9b_cdac_1.cdac_sw_9b_0.cdac_sw_3_5.nooverlap_clk_0.CLK0 VDPWR sky130_fd_pr__pfet_01v8 ad=0.196 pd=1.47 as=0.168 ps=1.42 w=1.12 l=0.15
X2675 th_dif_sw_0.VCP single_9b_cdac_1.cdac_sw_9b_0.S[5] sky130_fd_pr__cap_mim_m3_1 l=2 w=2
X2676 ua[0] single_9b_cdac_0.cdac_sw_9b_0.cdac_sw_3_1.tg_sw_3_3.SWN ua[0] VGND sky130_fd_pr__nfet_01v8 ad=0.145 pd=1.58 as=0 ps=0 w=0.5 l=0.5
X2677 ua[0] single_9b_cdac_1.cdac_sw_9b_0.cdac_sw_3_6.tg_sw_3_3.SWN ua[0] VGND sky130_fd_pr__nfet_01v8 ad=0.145 pd=1.58 as=0 ps=0 w=0.5 l=0.5
X2678 tdc_0.delay_gate_ori_1.sky130_fd_sc_hs__and2_1_0.A a_16331_9671# a_16357_9613# VDPWR sky130_fd_pr__pfet_01v8 ad=0.87 pd=6.58 as=0.435 ps=3.29 w=3 l=1
X2679 a_9162_27060# a_8085_27066# a_9000_27438# VDPWR sky130_fd_pr__pfet_01v8_hvt ad=0.0567 pd=0.69 as=0.0588 ps=0.7 w=0.42 l=0.15
X2680 single_9b_cdac_0.cdac_sw_9b_0.S[1] single_9b_cdac_0.cdac_sw_9b_0.cdac_sw_3_1.tg_sw_3_3.SWP single_9b_cdac_0.cdac_sw_9b_0.S[1] VDPWR sky130_fd_pr__pfet_01v8 ad=0.435 pd=3.58 as=0 ps=0 w=1.5 l=0.5
X2681 single_9b_cdac_0.cdac_sw_9b_0.cdac_sw_3_1.tg_sw_3_3.SWN single_9b_cdac_0.cdac_sw_9b_0.cdac_sw_3_1.nooverlap_clk_0.x10.A VDPWR VDPWR sky130_fd_pr__pfet_01v8 ad=0.168 pd=1.42 as=0.168 ps=1.42 w=1.12 l=0.15
X2682 single_9b_cdac_0.cdac_sw_9b_0.S[8] single_9b_cdac_0.cdac_sw_9b_0.cdac_sw_3_8.tg_sw_3_3.SWN ua[0] VDPWR sky130_fd_pr__pfet_01v8 ad=0.435 pd=3.58 as=0.435 ps=3.58 w=1.5 l=0.5
X2683 VGND single_9b_cdac_0.cdac_sw_9b_0.cdac_sw_3_6.nooverlap_clk_0.x8.A single_9b_cdac_0.cdac_sw_9b_0.cdac_sw_3_6.nooverlap_clk_0.x10.A VGND sky130_fd_pr__nfet_01v8_lvt ad=0.2331 pd=2.11 as=0.1184 ps=1.06 w=0.74 l=0.15
X2684 single_9b_cdac_0.cdac_sw_9b_0.cdac_sw_3_1.nooverlap_clk_0.sky130_fd_sc_hs__inv_8_0.A single_9b_cdac_0.cdac_sw_9b_0.cdac_sw_3_1.nooverlap_clk_0.x1.A VGND VGND sky130_fd_pr__nfet_01v8_lvt ad=0.1184 pd=1.06 as=0.1221 ps=1.07 w=0.74 l=0.15
X2685 ua[0] single_9b_cdac_0.cdac_sw_9b_0.cdac_sw_3_6.tg_sw_3_3.SWN ua[0] VGND sky130_fd_pr__nfet_01v8 ad=0.145 pd=1.58 as=0 ps=0 w=0.5 l=0.5
X2686 single_9b_cdac_1.cdac_sw_9b_0.cdac_sw_3_5.nooverlap_clk_0.CLK0 single_9b_cdac_1.cdac_sw_9b_0.cdac_sw_3_5.nooverlap_clk_0.CLKB0 VDPWR VDPWR sky130_fd_pr__pfet_01v8 ad=0.168 pd=1.42 as=0.3304 ps=2.83 w=1.12 l=0.15
X2687 single_9b_cdac_1.cdac_sw_9b_0.cdac_sw_3_4.nooverlap_clk_0.CLK0 single_9b_cdac_1.cdac_sw_9b_0.cdac_sw_3_4.nooverlap_clk_0.CLKB0 VGND VGND sky130_fd_pr__nfet_01v8_lvt ad=0.1036 pd=1.02 as=0.1295 ps=1.09 w=0.74 l=0.15
X2688 VDPWR single_9b_cdac_0.cdac_sw_9b_0.cdac_sw_3_1.nooverlap_clk_0.x10.A single_9b_cdac_0.cdac_sw_9b_0.cdac_sw_3_1.tg_sw_3_3.SWN VDPWR sky130_fd_pr__pfet_01v8 ad=0.168 pd=1.42 as=0.168 ps=1.42 w=1.12 l=0.15
X2689 th_dif_sw_0.VCP single_9b_cdac_1.cdac_sw_9b_0.S[0] sky130_fd_pr__cap_mim_m3_1 l=2 w=2
X2690 th_dif_sw_0.VCP th_dif_sw_0.th_sw_1.CK th_dif_sw_0.VCP VGND sky130_fd_pr__nfet_01v8 ad=5.8 pd=40.58 as=17.4 ps=121.74 w=20 l=0.15
X2691 VGND a_21177_7457# th_dif_sw_0.th_sw_1.CKB VGND sky130_fd_pr__nfet_01v8_lvt ad=0.1036 pd=1.02 as=0.1036 ps=1.02 w=0.74 l=0.15
X2692 single_9b_cdac_0.cdac_sw_9b_0.S[7] single_9b_cdac_0.cdac_sw_9b_0.cdac_sw_3_7.tg_sw_3_3.SWP single_9b_cdac_0.cdac_sw_9b_0.S[7] VDPWR sky130_fd_pr__pfet_01v8 ad=0.435 pd=3.58 as=0 ps=0 w=1.5 l=0.5
X2693 single_9b_cdac_0.cdac_sw_9b_0.S[1] single_9b_cdac_0.cdac_sw_9b_0.cdac_sw_3_1.tg_sw_3_3.SWN single_9b_cdac_0.cdac_sw_9b_0.S[1] VGND sky130_fd_pr__nfet_01v8 ad=0.145 pd=1.58 as=0 ps=0 w=0.5 l=0.5
X2694 VGND VDPWR VGND VGND sky130_fd_pr__nfet_01v8 ad=0.143 pd=1.62 as=0 ps=0 w=0.55 l=0.59
X2695 a_10732_19810# sar9b_0.net5 VDPWR VDPWR sky130_fd_pr__pfet_01v8_hvt ad=0.0651 pd=0.73 as=0.1092 ps=1.36 w=0.42 l=0.15
X2696 a_9622_24706# a_8545_24340# a_9460_24340# VDPWR sky130_fd_pr__pfet_01v8_hvt ad=0.0567 pd=0.69 as=0.0588 ps=0.7 w=0.42 l=0.15
X2697 single_9b_cdac_0.cdac_sw_9b_0.S[8] single_9b_cdac_0.cdac_sw_9b_0.cdac_sw_3_8.nooverlap_clk_0.CLKB0 a_24332_26999# VDPWR sky130_fd_pr__pfet_01v8 ad=0.435 pd=3.58 as=0.435 ps=3.58 w=1.5 l=0.5
X2698 single_9b_cdac_0.cdac_sw_9b_0.cdac_sw_3_7.tg_sw_3_3.SWN single_9b_cdac_0.cdac_sw_9b_0.cdac_sw_3_7.nooverlap_clk_0.x10.A VGND VGND sky130_fd_pr__nfet_01v8_lvt ad=0.1036 pd=1.02 as=0.2146 ps=2.06 w=0.74 l=0.15
X2699 VGND VDPWR VGND VGND sky130_fd_pr__nfet_01v8 ad=0.143 pd=1.62 as=0 ps=0 w=0.55 l=0.59
X2700 VGND VDPWR VGND VGND sky130_fd_pr__nfet_01v8 ad=0.143 pd=1.62 as=0 ps=0 w=0.55 l=0.59
X2701 th_dif_sw_0.VCN single_9b_cdac_0.cdac_sw_9b_0.S[1] sky130_fd_pr__cap_mim_m3_1 l=2 w=2
X2702 single_9b_cdac_0.cdac_sw_9b_0.S[6] single_9b_cdac_0.cdac_sw_9b_0.cdac_sw_3_6.tg_sw_3_3.SWN single_9b_cdac_0.cdac_sw_9b_0.S[6] VGND sky130_fd_pr__nfet_01v8 ad=0.145 pd=1.58 as=0 ps=0 w=0.5 l=0.5
X2703 VDPWR single_9b_cdac_0.cdac_sw_9b_0.cdac_sw_3_1.nooverlap_clk_0.sky130_fd_sc_hs__inv_8_0.A single_9b_cdac_0.cdac_sw_9b_0.cdac_sw_3_1.nooverlap_clk_0.CLKB0 VDPWR sky130_fd_pr__pfet_01v8 ad=0.196 pd=1.47 as=0.168 ps=1.42 w=1.12 l=0.15
X2704 VGND VDPWR VGND VGND sky130_fd_pr__nfet_01v8 ad=0.143 pd=1.62 as=0 ps=0 w=0.55 l=0.59
X2705 VDPWR sar9b_0.net29 a_14451_24340# VDPWR sky130_fd_pr__pfet_01v8_hvt ad=0.11455 pd=1.08 as=0.2054 ps=2.1 w=0.79 l=0.15
X2706 single_9b_cdac_1.cdac_sw_9b_0.S[7] single_9b_cdac_1.cdac_sw_9b_0.cdac_sw_3_7.tg_sw_3_3.SWN single_9b_cdac_1.cdac_sw_9b_0.S[7] VGND sky130_fd_pr__nfet_01v8 ad=0.145 pd=1.58 as=2.32 ps=25.28 w=0.5 l=0.5
X2707 VDPWR single_9b_cdac_0.cdac_sw_9b_0.cdac_sw_3_4.nooverlap_clk_0.x8.A single_9b_cdac_0.cdac_sw_9b_0.cdac_sw_3_4.nooverlap_clk_0.x10.A VDPWR sky130_fd_pr__pfet_01v8 ad=0.3304 pd=2.83 as=0.168 ps=1.42 w=1.12 l=0.15
X2708 a_8273_23796# sar9b_0._03_ VGND VGND sky130_fd_pr__nfet_01v8 ad=0.0813 pd=0.83 as=0.1092 ps=1.36 w=0.42 l=0.15
X2709 VDPWR a_13968_21076# a_14143_21050# VDPWR sky130_fd_pr__pfet_01v8_hvt ad=0.1134 pd=1.38 as=0.0567 ps=0.69 w=0.42 l=0.15
X2710 a_29134_26999# single_9b_cdac_0.SW[7] VDPWR VDPWR sky130_fd_pr__pfet_01v8 ad=0.435 pd=3.58 as=0.435 ps=3.58 w=1.5 l=0.5
X2711 VDPWR VGND VDPWR VDPWR sky130_fd_pr__pfet_01v8_hvt ad=0.2262 pd=2.26 as=0 ps=0 w=0.87 l=0.59
X2712 a_9095_23618# a_8471_23252# a_8987_23252# VDPWR sky130_fd_pr__pfet_01v8_hvt ad=0.1155 pd=0.97 as=0.07245 ps=0.765 w=0.42 l=0.15
X2713 VGND single_9b_cdac_1.cdac_sw_9b_0.cdac_sw_3_7.nooverlap_clk_0.CLKB0 single_9b_cdac_1.cdac_sw_9b_0.cdac_sw_3_7.nooverlap_clk_0.CLK0 VGND sky130_fd_pr__nfet_01v8_lvt ad=0.1295 pd=1.09 as=0.1036 ps=1.02 w=0.74 l=0.15
X2714 dw_17224_1400# a_21368_4076# sky130_fd_pr__cap_mim_m3_1 l=2 w=2
X2715 th_dif_sw_0.VCN single_9b_cdac_0.cdac_sw_9b_0.S[0] sky130_fd_pr__cap_mim_m3_1 l=2 w=2
X2716 single_9b_cdac_1.cdac_sw_9b_0.cdac_sw_3_8.nooverlap_clk_0.x3.Y single_9b_cdac_1.CF[8] VDPWR VDPWR sky130_fd_pr__pfet_01v8 ad=0.3304 pd=2.83 as=0.3864 ps=2.93 w=1.12 l=0.15
X2717 sar9b_0.net24 a_12211_26490# VDPWR VDPWR sky130_fd_pr__pfet_01v8_hvt ad=0.26 pd=2.52 as=0.3012 ps=2.66 w=1 l=0.15
X2718 single_9b_cdac_0.cdac_sw_9b_0.cdac_sw_3_8.tg_sw_3_3.SWP single_9b_cdac_0.cdac_sw_9b_0.cdac_sw_3_8.tg_sw_3_3.SWN VGND VGND sky130_fd_pr__nfet_01v8_lvt ad=0.1036 pd=1.02 as=0.2146 ps=2.06 w=0.74 l=0.15
X2719 single_9b_cdac_0.cdac_sw_9b_0.S[0] single_9b_cdac_0.cdac_sw_9b_0.cdac_sw_3_2.tg_sw_3_3.SWP ua[0] VGND sky130_fd_pr__nfet_01v8 ad=0.145 pd=1.58 as=0.145 ps=1.58 w=0.5 l=0.5
X2720 single_9b_cdac_0.cdac_sw_9b_0.cdac_sw_3_1.nooverlap_clk_0.CLKB0 single_9b_cdac_0.cdac_sw_9b_0.cdac_sw_3_1.nooverlap_clk_0.sky130_fd_sc_hs__inv_8_0.A VDPWR VDPWR sky130_fd_pr__pfet_01v8 ad=0.168 pd=1.42 as=0.3864 ps=2.93 w=1.12 l=0.15
X2721 a_10732_23252# sar9b_0.net2 VGND VGND sky130_fd_pr__nfet_01v8 ad=0.066 pd=0.745 as=0.2205 ps=1.89 w=0.42 l=0.15
X2722 th_dif_sw_0.th_sw_1.CKB a_21177_7457# VDPWR VDPWR sky130_fd_pr__pfet_01v8 ad=0.168 pd=1.42 as=0.168 ps=1.42 w=1.12 l=0.15
X2723 VGND VDPWR VGND VGND sky130_fd_pr__nfet_01v8 ad=0.143 pd=1.62 as=0 ps=0 w=0.55 l=0.59
X2724 ua[0] single_9b_cdac_1.cdac_sw_9b_0.cdac_sw_3_3.tg_sw_3_3.SWP ua[0] VDPWR sky130_fd_pr__pfet_01v8 ad=0.435 pd=3.58 as=0 ps=0 w=1.5 l=0.5
X2725 single_9b_cdac_1.cdac_sw_9b_0.cdac_sw_3_4.tg_sw_3_3.SWP single_9b_cdac_1.cdac_sw_9b_0.cdac_sw_3_4.tg_sw_3_3.SWN VGND VGND sky130_fd_pr__nfet_01v8_lvt ad=0.1036 pd=1.02 as=0.2109 ps=2.05 w=0.74 l=0.15
X2726 VDPWR a_9535_19962# sar9b_0.net38 VDPWR sky130_fd_pr__pfet_01v8_hvt ad=0.3012 pd=2.66 as=0.26 ps=2.52 w=1 l=0.15
X2727 a_5393_17977# sar9b_0.net16 VGND VGND sky130_fd_pr__nfet_01v8 ad=0.1352 pd=1.56 as=0.0754 ps=0.81 w=0.52 l=0.15
X2728 VDPWR single_9b_cdac_1.cdac_sw_9b_0.cdac_sw_3_8.nooverlap_clk_0.x10.A single_9b_cdac_1.cdac_sw_9b_0.cdac_sw_3_8.tg_sw_3_3.SWN VDPWR sky130_fd_pr__pfet_01v8 ad=0.3864 pd=2.93 as=0.168 ps=1.42 w=1.12 l=0.15
X2729 VDPWR sar9b_0.clk_div_0.COUNT\[1\] sar9b_0._12_ VDPWR sky130_fd_pr__pfet_01v8_hvt ad=0.165 pd=1.33 as=0.135 ps=1.27 w=1 l=0.15
X2730 VGND a_6701_20506# sar9b_0.clknet_1_0__leaf_CLK VGND sky130_fd_pr__nfet_01v8 ad=0.05775 pd=0.695 as=0.0588 ps=0.7 w=0.42 l=0.15
X2731 VGND sar9b_0.net15 a_13665_19988# VGND sky130_fd_pr__nfet_01v8 ad=0.1346 pd=1.15 as=0.0441 ps=0.63 w=0.42 l=0.15
X2732 a_13403_19822# a_12887_19450# a_13308_19810# VGND sky130_fd_pr__special_nfet_01v8 ad=0.0594 pd=0.69 as=0.066 ps=0.745 w=0.36 l=0.15
X2733 th_dif_sw_0.VCP single_9b_cdac_1.cdac_sw_9b_0.S[0] sky130_fd_pr__cap_mim_m3_1 l=2 w=2
X2734 a_10845_25428# a_10679_25428# VDPWR VDPWR sky130_fd_pr__pfet_01v8_hvt ad=0.1664 pd=1.8 as=0.0864 ps=0.91 w=0.64 l=0.15
X2735 a_11689_23770# a_11471_24174# VDPWR VDPWR sky130_fd_pr__pfet_01v8_hvt ad=0.12915 pd=1.185 as=0.2184 ps=2.2 w=0.84 l=0.15
X2736 VGND sar9b_0.clknet_0_CLK a_6701_20506# VGND sky130_fd_pr__nfet_01v8 ad=0.0588 pd=0.7 as=0.0588 ps=0.7 w=0.42 l=0.15
X2737 th_dif_sw_0.VCN single_9b_cdac_0.cdac_sw_9b_0.S[4] sky130_fd_pr__cap_mim_m3_1 l=2 w=2
X2738 a_13529_23770# a_13311_24174# VGND VGND sky130_fd_pr__nfet_01v8 ad=0.0999 pd=0.985 as=0.1346 ps=1.15 w=0.64 l=0.15
X2739 a_10937_22164# a_10771_22164# VDPWR VDPWR sky130_fd_pr__pfet_01v8_hvt ad=0.1664 pd=1.8 as=0.0864 ps=0.91 w=0.64 l=0.15
X2740 VGND single_9b_cdac_1.cdac_sw_9b_0.cdac_sw_3_2.nooverlap_clk_0.sky130_fd_sc_hs__inv_8_0.A single_9b_cdac_1.cdac_sw_9b_0.cdac_sw_3_2.nooverlap_clk_0.CLKB0 VGND sky130_fd_pr__nfet_01v8_lvt ad=0.2146 pd=2.06 as=0.1036 ps=1.02 w=0.74 l=0.15
X2741 single_9b_cdac_1.cdac_sw_9b_0.cdac_sw_3_8.tg_sw_3_3.SWN single_9b_cdac_1.cdac_sw_9b_0.cdac_sw_3_8.nooverlap_clk_0.x10.A VDPWR VDPWR sky130_fd_pr__pfet_01v8 ad=0.168 pd=1.42 as=0.196 ps=1.47 w=1.12 l=0.15
X2742 a_9038_22708# a_8912_22824# a_8634_22840# VGND sky130_fd_pr__special_nfet_01v8 ad=0.0999 pd=0.985 as=0.0711 ps=0.755 w=0.36 l=0.15
X2743 single_9b_cdac_1.cdac_sw_9b_0.cdac_sw_3_6.nooverlap_clk_0.sky130_fd_sc_hs__inv_8_0.A single_9b_cdac_1.cdac_sw_9b_0.cdac_sw_3_6.nooverlap_clk_0.x1.A VGND VGND sky130_fd_pr__nfet_01v8_lvt ad=0.1036 pd=1.02 as=0.1221 ps=1.07 w=0.74 l=0.15
X2744 VGND single_9b_cdac_1.cdac_sw_9b_0.cdac_sw_3_0.nooverlap_clk_0.x1.A single_9b_cdac_1.cdac_sw_9b_0.cdac_sw_3_0.nooverlap_clk_0.sky130_fd_sc_hs__inv_8_0.A VGND sky130_fd_pr__nfet_01v8_lvt ad=0.2109 pd=2.05 as=0.1036 ps=1.02 w=0.74 l=0.15
X2745 ua[0] single_9b_cdac_0.cdac_sw_9b_0.cdac_sw_3_8.tg_sw_3_3.SWP ua[0] VDPWR sky130_fd_pr__pfet_01v8 ad=0.435 pd=3.58 as=0 ps=0 w=1.5 l=0.5
X2746 a_13985_24174# a_12795_23802# a_13876_24174# VGND sky130_fd_pr__special_nfet_01v8 ad=0.0669 pd=0.75 as=0.0711 ps=0.755 w=0.36 l=0.15
X2747 VDPWR VGND VDPWR VDPWR sky130_fd_pr__pfet_01v8_hvt ad=0.2262 pd=2.26 as=0 ps=0 w=0.87 l=0.59
X2748 sar9b_0.net9 a_10371_21050# VGND VGND sky130_fd_pr__nfet_01v8 ad=0.169 pd=1.82 as=0.2087 ps=2.02 w=0.65 l=0.15
X2749 VDPWR sar9b_0.net7 a_12887_18900# VDPWR sky130_fd_pr__pfet_01v8_hvt ad=0.0864 pd=0.91 as=0.1664 ps=1.8 w=0.64 l=0.15
X2750 VGND VDPWR VGND VGND sky130_fd_pr__nfet_01v8 ad=0.143 pd=1.62 as=0 ps=0 w=0.55 l=0.59
X2751 VDPWR single_9b_cdac_1.cdac_sw_9b_0.cdac_sw_3_4.nooverlap_clk_0.sky130_fd_sc_hs__inv_8_0.A single_9b_cdac_1.cdac_sw_9b_0.cdac_sw_3_4.nooverlap_clk_0.CLKB0 VDPWR sky130_fd_pr__pfet_01v8 ad=0.196 pd=1.47 as=0.168 ps=1.42 w=1.12 l=0.15
X2752 VDPWR a_9113_24582# a_9003_24706# VDPWR sky130_fd_pr__pfet_01v8_hvt ad=0.07035 pd=0.755 as=0.1155 ps=0.97 w=0.42 l=0.15
X2753 th_dif_sw_0.VCP single_9b_cdac_1.cdac_sw_9b_0.S[0] sky130_fd_pr__cap_mim_m3_1 l=2 w=2
X2754 single_9b_cdac_0.cdac_sw_9b_0.cdac_sw_3_6.nooverlap_clk_0.CLK0 single_9b_cdac_0.cdac_sw_9b_0.cdac_sw_3_6.nooverlap_clk_0.CLKB0 VGND VGND sky130_fd_pr__nfet_01v8_lvt ad=0.1036 pd=1.02 as=0.1554 ps=1.16 w=0.74 l=0.15
X2755 single_9b_cdac_1.cdac_sw_9b_0.cdac_sw_3_6.nooverlap_clk_0.CLKB0 single_9b_cdac_1.cdac_sw_9b_0.cdac_sw_3_6.nooverlap_clk_0.sky130_fd_sc_hs__inv_8_0.A VGND VGND sky130_fd_pr__nfet_01v8_lvt ad=0.1036 pd=1.02 as=0.1295 ps=1.09 w=0.74 l=0.15
X2756 ua[0] single_9b_cdac_0.cdac_sw_9b_0.cdac_sw_3_2.tg_sw_3_3.SWN ua[0] VGND sky130_fd_pr__nfet_01v8 ad=0.145 pd=1.58 as=0 ps=0 w=0.5 l=0.5
X2757 VDPWR a_11567_25188# a_11554_24884# VDPWR sky130_fd_pr__pfet_01v8_hvt ad=0.0819 pd=0.81 as=0.0567 ps=0.69 w=0.42 l=0.15
X2758 VGND single_9b_cdac_1.cdac_sw_9b_0.cdac_sw_3_0.nooverlap_clk_0.sky130_fd_sc_hs__inv_8_0.A single_9b_cdac_1.cdac_sw_9b_0.cdac_sw_3_0.nooverlap_clk_0.CLKB0 VGND sky130_fd_pr__nfet_01v8_lvt ad=0.1554 pd=1.16 as=0.1036 ps=1.02 w=0.74 l=0.15
X2759 VGND single_9b_cdac_1.cdac_sw_9b_0.cdac_sw_3_1.nooverlap_clk_0.CLKB0 single_9b_cdac_1.cdac_sw_9b_0.cdac_sw_3_1.nooverlap_clk_0.CLK0 VGND sky130_fd_pr__nfet_01v8_lvt ad=0.1554 pd=1.16 as=0.1036 ps=1.02 w=0.74 l=0.15
X2760 single_9b_cdac_0.SW[1] a_13899_24340# VGND VGND sky130_fd_pr__nfet_01v8 ad=0.1352 pd=1.56 as=0.0754 ps=0.81 w=0.52 l=0.15
X2761 a_10187_22138# a_10012_22164# a_10366_22164# VGND sky130_fd_pr__nfet_01v8 ad=0.1092 pd=1.36 as=0.06405 ps=0.725 w=0.42 l=0.15
X2762 th_dif_sw_0.VCN single_9b_cdac_0.cdac_sw_9b_0.S[5] sky130_fd_pr__cap_mim_m3_1 l=2 w=2
X2763 a_6525_22708# sar9b_0._04_ VDPWR VDPWR sky130_fd_pr__pfet_01v8_hvt ad=0.05775 pd=0.695 as=0.1092 ps=1.36 w=0.42 l=0.15
X2764 th_dif_sw_0.VCP single_9b_cdac_1.cdac_sw_9b_0.S[0] sky130_fd_pr__cap_mim_m3_1 l=2 w=2
X2765 VDPWR single_9b_cdac_0.cdac_sw_9b_0.cdac_sw_3_0.tg_sw_3_3.SWN single_9b_cdac_0.cdac_sw_9b_0.cdac_sw_3_0.tg_sw_3_3.SWP VDPWR sky130_fd_pr__pfet_01v8 ad=0.196 pd=1.47 as=0.168 ps=1.42 w=1.12 l=0.15
X2766 VDPWR single_9b_cdac_0.cdac_sw_9b_0.cdac_sw_3_2.nooverlap_clk_0.sky130_fd_sc_hs__inv_8_0.A single_9b_cdac_0.cdac_sw_9b_0.cdac_sw_3_2.nooverlap_clk_0.CLKB0 VDPWR sky130_fd_pr__pfet_01v8 ad=0.3304 pd=2.83 as=0.168 ps=1.42 w=1.12 l=0.15
X2767 VDPWR VGND VDPWR VDPWR sky130_fd_pr__pfet_01v8_hvt ad=0.2262 pd=2.26 as=0 ps=0 w=0.87 l=0.59
X2768 th_dif_sw_0.VCN single_9b_cdac_0.cdac_sw_9b_0.S[0] sky130_fd_pr__cap_mim_m3_1 l=2 w=2
X2769 a_6343_20354# a_5895_19988# a_6249_19988# VGND sky130_fd_pr__special_nfet_01v8 ad=0.0594 pd=0.69 as=0.066 ps=0.745 w=0.36 l=0.15
X2770 VDPWR VGND VDPWR VDPWR sky130_fd_pr__pfet_01v8_hvt ad=0.2262 pd=2.26 as=0 ps=0 w=0.87 l=0.59
X2771 VGND single_9b_cdac_1.CF[8] single_9b_cdac_0.cdac_sw_9b_0.cdac_sw_3_8.nooverlap_clk_0.x3.Y VGND sky130_fd_pr__nfet_01v8_lvt ad=0.2627 pd=2.19 as=0.2109 ps=2.05 w=0.74 l=0.15
X2772 single_9b_cdac_0.cdac_sw_9b_0.cdac_sw_3_0.tg_sw_3_3.SWP single_9b_cdac_0.cdac_sw_9b_0.cdac_sw_3_0.tg_sw_3_3.SWN VDPWR VDPWR sky130_fd_pr__pfet_01v8 ad=0.168 pd=1.42 as=0.168 ps=1.42 w=1.12 l=0.15
X2773 single_9b_cdac_1.cdac_sw_9b_0.S[3] single_9b_cdac_1.cdac_sw_9b_0.cdac_sw_3_4.tg_sw_3_3.SWP ua[0] VGND sky130_fd_pr__nfet_01v8 ad=0.145 pd=1.58 as=0.145 ps=1.58 w=0.5 l=0.5
X2774 single_9b_cdac_0.cdac_sw_9b_0.cdac_sw_3_2.nooverlap_clk_0.CLKB0 single_9b_cdac_0.cdac_sw_9b_0.cdac_sw_3_2.nooverlap_clk_0.sky130_fd_sc_hs__inv_8_0.A VDPWR VDPWR sky130_fd_pr__pfet_01v8 ad=0.168 pd=1.42 as=0.196 ps=1.47 w=1.12 l=0.15
X2775 th_dif_sw_0.VCP single_9b_cdac_1.cdac_sw_9b_0.S[0] sky130_fd_pr__cap_mim_m3_1 l=2 w=2
X2776 single_9b_cdac_1.cdac_sw_9b_0.cdac_sw_3_4.nooverlap_clk_0.x6.A single_9b_cdac_1.cdac_sw_9b_0.cdac_sw_3_4.nooverlap_clk_0.x4.A VGND VGND sky130_fd_pr__nfet_01v8_lvt ad=0.2109 pd=2.05 as=0.2627 ps=2.19 w=0.74 l=0.15
X2777 a_9972_20354# a_9535_19962# VDPWR VDPWR sky130_fd_pr__pfet_01v8_hvt ad=0.0567 pd=0.69 as=0.0819 ps=0.81 w=0.42 l=0.15
X2778 th_dif_sw_0.VCN single_9b_cdac_0.cdac_sw_9b_0.S[4] sky130_fd_pr__cap_mim_m3_1 l=2 w=2
X2779 a_33936_26999# single_9b_cdac_0.SW[6] VDPWR VDPWR sky130_fd_pr__pfet_01v8 ad=0.435 pd=3.58 as=0.435 ps=3.58 w=1.5 l=0.5
X2780 VDPWR single_9b_cdac_0.cdac_sw_9b_0.cdac_sw_3_0.tg_sw_3_3.SWN single_9b_cdac_0.cdac_sw_9b_0.cdac_sw_3_0.tg_sw_3_3.SWP VDPWR sky130_fd_pr__pfet_01v8 ad=0.168 pd=1.42 as=0.168 ps=1.42 w=1.12 l=0.15
X2781 VDPWR single_9b_cdac_1.cdac_sw_9b_0.cdac_sw_3_4.nooverlap_clk_0.x1.A single_9b_cdac_1.cdac_sw_9b_0.cdac_sw_3_4.nooverlap_clk_0.x4.A VDPWR sky130_fd_pr__pfet_01v8 ad=0.3192 pd=2.81 as=0.168 ps=1.42 w=1.12 l=0.15
X2782 th_dif_sw_0.VCP single_9b_cdac_1.cdac_sw_9b_0.S[0] sky130_fd_pr__cap_mim_m3_1 l=2 w=2
X2783 th_dif_sw_0.VCN single_9b_cdac_0.cdac_sw_9b_0.S[0] sky130_fd_pr__cap_mim_m3_1 l=2 w=2
X2784 a_12390_26516# sar9b_0.net3 VGND VGND sky130_fd_pr__nfet_01v8 ad=0.06405 pd=0.725 as=0.12495 ps=1.015 w=0.42 l=0.15
X2785 single_9b_cdac_0.cdac_sw_9b_0.cdac_sw_3_2.nooverlap_clk_0.x10.A single_9b_cdac_0.cdac_sw_9b_0.cdac_sw_3_2.nooverlap_clk_0.x8.A VGND VGND sky130_fd_pr__nfet_01v8_lvt ad=0.1184 pd=1.06 as=0.1221 ps=1.07 w=0.74 l=0.15
X2786 VGND VDPWR VGND VGND sky130_fd_pr__nfet_01v8 ad=0.143 pd=1.62 as=0 ps=0 w=0.55 l=0.59
X2787 VGND a_7345_21594# sar9b_0.clknet_0_CLK VGND sky130_fd_pr__nfet_01v8 ad=0.0588 pd=0.7 as=0.0588 ps=0.7 w=0.42 l=0.15
X2788 ua[0] single_9b_cdac_1.cdac_sw_9b_0.cdac_sw_3_5.tg_sw_3_3.SWP ua[0] VDPWR sky130_fd_pr__pfet_01v8 ad=0.435 pd=3.58 as=0 ps=0 w=1.5 l=0.5
X2789 VDPWR a_10371_26490# a_10358_26882# VDPWR sky130_fd_pr__pfet_01v8_hvt ad=0.0819 pd=0.81 as=0.0567 ps=0.69 w=0.42 l=0.15
X2790 VDPWR a_11689_26758# a_11579_26882# VDPWR sky130_fd_pr__pfet_01v8_hvt ad=0.07035 pd=0.755 as=0.1155 ps=0.97 w=0.42 l=0.15
X2791 VGND a_7345_21594# sar9b_0.clknet_0_CLK VGND sky130_fd_pr__nfet_01v8 ad=0.0588 pd=0.7 as=0.0588 ps=0.7 w=0.42 l=0.15
X2792 single_9b_cdac_1.cdac_sw_9b_0.S[3] single_9b_cdac_1.cdac_sw_9b_0.cdac_sw_3_4.tg_sw_3_3.SWN ua[0] VDPWR sky130_fd_pr__pfet_01v8 ad=0.435 pd=3.58 as=0.435 ps=3.58 w=1.5 l=0.5
X2793 single_9b_cdac_0.cdac_sw_9b_0.cdac_sw_3_2.nooverlap_clk_0.CLK0 single_9b_cdac_0.cdac_sw_9b_0.cdac_sw_3_2.nooverlap_clk_0.CLKB0 VGND VGND sky130_fd_pr__nfet_01v8_lvt ad=0.1036 pd=1.02 as=0.1295 ps=1.09 w=0.74 l=0.15
X2794 single_9b_cdac_1.cdac_sw_9b_0.S[0] single_9b_cdac_1.cdac_sw_9b_0.cdac_sw_3_2.nooverlap_clk_0.CLKB0 a_62748_16877# VDPWR sky130_fd_pr__pfet_01v8 ad=0.435 pd=3.58 as=0.435 ps=3.58 w=1.5 l=0.5
X2795 single_9b_cdac_1.cdac_sw_9b_0.cdac_sw_3_4.nooverlap_clk_0.x4.A single_9b_cdac_1.cdac_sw_9b_0.cdac_sw_3_4.nooverlap_clk_0.x3.Y VDPWR VDPWR sky130_fd_pr__pfet_01v8 ad=0.168 pd=1.42 as=0.3192 ps=2.81 w=1.12 l=0.15
X2796 single_9b_cdac_0.cdac_sw_9b_0.cdac_sw_3_2.nooverlap_clk_0.x10.A single_9b_cdac_0.cdac_sw_9b_0.cdac_sw_3_2.nooverlap_clk_0.x8.A VDPWR VDPWR sky130_fd_pr__pfet_01v8 ad=0.168 pd=1.42 as=0.168 ps=1.42 w=1.12 l=0.15
X2797 th_dif_sw_0.VCP single_9b_cdac_1.cdac_sw_9b_0.S[2] sky130_fd_pr__cap_mim_m3_1 l=2 w=2
X2798 ua[0] single_9b_cdac_0.cdac_sw_9b_0.cdac_sw_3_8.tg_sw_3_3.SWP ua[0] VDPWR sky130_fd_pr__pfet_01v8 ad=0.435 pd=3.58 as=0 ps=0 w=1.5 l=0.5
X2799 single_9b_cdac_0.cdac_sw_9b_0.S[7] single_9b_cdac_0.cdac_sw_9b_0.cdac_sw_3_7.tg_sw_3_3.SWP ua[0] VGND sky130_fd_pr__nfet_01v8 ad=0.145 pd=1.58 as=0.145 ps=1.58 w=0.5 l=0.5
X2800 VGND single_9b_cdac_1.cdac_sw_9b_0.cdac_sw_3_3.nooverlap_clk_0.x1.A single_9b_cdac_1.cdac_sw_9b_0.cdac_sw_3_3.nooverlap_clk_0.sky130_fd_sc_hs__inv_8_0.A VGND sky130_fd_pr__nfet_01v8_lvt ad=0.2109 pd=2.05 as=0.1036 ps=1.02 w=0.74 l=0.15
X2801 th_dif_sw_0.th_sw_1.CK a_9132_7271# VDPWR VDPWR sky130_fd_pr__pfet_01v8 ad=0.168 pd=1.42 as=0.168 ps=1.42 w=1.12 l=0.15
X2802 VDPWR VGND VDPWR VDPWR sky130_fd_pr__pfet_01v8_hvt ad=0.2262 pd=2.26 as=0 ps=0 w=0.87 l=0.59
X2803 VDPWR single_9b_cdac_1.CF[2] single_9b_cdac_0.cdac_sw_9b_0.cdac_sw_3_0.nooverlap_clk_0.x3.Y VDPWR sky130_fd_pr__pfet_01v8 ad=0.3864 pd=2.93 as=0.3304 ps=2.83 w=1.12 l=0.15
X2804 single_9b_cdac_1.cdac_sw_9b_0.S[6] single_9b_cdac_1.cdac_sw_9b_0.cdac_sw_3_6.nooverlap_clk_0.CLKB0 a_33936_16877# VDPWR sky130_fd_pr__pfet_01v8 ad=0.435 pd=3.58 as=0.435 ps=3.58 w=1.5 l=0.5
X2805 th_dif_sw_0.VCN single_9b_cdac_0.cdac_sw_9b_0.S[1] sky130_fd_pr__cap_mim_m3_1 l=2 w=2
X2806 VDPWR single_9b_cdac_0.cdac_sw_9b_0.cdac_sw_3_2.nooverlap_clk_0.x8.A single_9b_cdac_0.cdac_sw_9b_0.cdac_sw_3_2.nooverlap_clk_0.x10.A VDPWR sky130_fd_pr__pfet_01v8 ad=0.168 pd=1.42 as=0.168 ps=1.42 w=1.12 l=0.15
X2807 VGND single_9b_cdac_1.SW[2] a_54032_17740# VGND sky130_fd_pr__nfet_01v8 ad=0.145 pd=1.58 as=0.145 ps=1.58 w=0.5 l=0.5
X2808 a_14143_19748# sar9b_0.net15 VDPWR VDPWR sky130_fd_pr__pfet_01v8_hvt ad=0.0567 pd=0.69 as=0.0819 ps=0.81 w=0.42 l=0.15
X2809 VGND single_9b_cdac_1.cdac_sw_9b_0.cdac_sw_3_3.nooverlap_clk_0.sky130_fd_sc_hs__inv_8_0.A single_9b_cdac_1.cdac_sw_9b_0.cdac_sw_3_3.nooverlap_clk_0.CLKB0 VGND sky130_fd_pr__nfet_01v8_lvt ad=0.1554 pd=1.16 as=0.1036 ps=1.02 w=0.74 l=0.15
X2810 a_11733_18900# a_11689_19142# a_11567_18900# VGND sky130_fd_pr__nfet_01v8 ad=0.0441 pd=0.63 as=0.1401 ps=1.1 w=0.42 l=0.15
X2811 single_9b_cdac_0.cdac_sw_9b_0.cdac_sw_3_2.nooverlap_clk_0.x10.A single_9b_cdac_0.cdac_sw_9b_0.cdac_sw_3_2.nooverlap_clk_0.x8.A VDPWR VDPWR sky130_fd_pr__pfet_01v8 ad=0.168 pd=1.42 as=0.3304 ps=2.83 w=1.12 l=0.15
X2812 a_13053_25428# a_12887_25428# VDPWR VDPWR sky130_fd_pr__pfet_01v8_hvt ad=0.1664 pd=1.8 as=0.0864 ps=0.91 w=0.64 l=0.15
X2813 VDPWR sar9b_0.net11 a_12887_24890# VDPWR sky130_fd_pr__pfet_01v8_hvt ad=0.0864 pd=0.91 as=0.1664 ps=1.8 w=0.64 l=0.15
X2814 VDPWR a_7145_23226# sar9b_0._13_ VDPWR sky130_fd_pr__pfet_01v8_hvt ad=0.26 pd=2.52 as=0.26 ps=2.52 w=1 l=0.15
X2815 th_dif_sw_0.VCP single_9b_cdac_1.cdac_sw_9b_0.S[0] sky130_fd_pr__cap_mim_m3_1 l=2 w=2
X2816 th_dif_sw_0.VCN single_9b_cdac_0.cdac_sw_9b_0.S[3] sky130_fd_pr__cap_mim_m3_1 l=2 w=2
X2817 VDPWR VGND VDPWR VDPWR sky130_fd_pr__pfet_01v8_hvt ad=0.2262 pd=2.26 as=0 ps=0 w=0.87 l=0.59
X2818 VGND sar9b_0.net35 a_14175_18356# VGND sky130_fd_pr__nfet_01v8 ad=0.0754 pd=0.81 as=0.1352 ps=1.56 w=0.52 l=0.15
X2819 th_dif_sw_0.VCP single_9b_cdac_1.cdac_sw_9b_0.S[0] sky130_fd_pr__cap_mim_m3_1 l=2 w=2
X2820 VDPWR a_21177_7457# th_dif_sw_0.th_sw_1.CKB VDPWR sky130_fd_pr__pfet_01v8 ad=0.196 pd=1.47 as=0.168 ps=1.42 w=1.12 l=0.15
X2821 single_9b_cdac_0.cdac_sw_9b_0.cdac_sw_3_5.tg_sw_3_3.SWP single_9b_cdac_0.cdac_sw_9b_0.cdac_sw_3_5.tg_sw_3_3.SWN VGND VGND sky130_fd_pr__nfet_01v8_lvt ad=0.1036 pd=1.02 as=0.2146 ps=2.06 w=0.74 l=0.15
X2822 single_9b_cdac_0.cdac_sw_9b_0.cdac_sw_3_4.nooverlap_clk_0.x10.A single_9b_cdac_0.cdac_sw_9b_0.cdac_sw_3_4.nooverlap_clk_0.x8.A VGND VGND sky130_fd_pr__nfet_01v8_lvt ad=0.1036 pd=1.02 as=0.2109 ps=2.05 w=0.74 l=0.15
X2823 sar9b_0.net3 a_5343_25972# VDPWR VDPWR sky130_fd_pr__pfet_01v8_hvt ad=0.14 pd=1.28 as=0.165 ps=1.33 w=1 l=0.15
X2824 sar9b_0.net1 a_10311_17812# VGND VGND sky130_fd_pr__nfet_01v8 ad=0.0567 pd=0.69 as=0.06825 ps=0.745 w=0.42 l=0.15
X2825 single_9b_cdac_1.cdac_sw_9b_0.cdac_sw_3_8.nooverlap_clk_0.CLKB0 single_9b_cdac_1.cdac_sw_9b_0.cdac_sw_3_8.nooverlap_clk_0.sky130_fd_sc_hs__inv_8_0.A VGND VGND sky130_fd_pr__nfet_01v8_lvt ad=0.1036 pd=1.02 as=0.1554 ps=1.16 w=0.74 l=0.15
X2826 VGND a_12211_26490# a_12145_26516# VGND sky130_fd_pr__nfet_01v8 ad=0.12495 pd=1.015 as=0.0669 ps=0.75 w=0.42 l=0.15
X2827 VDPWR a_6315_21050# sar9b_0._01_ VDPWR sky130_fd_pr__pfet_01v8_hvt ad=0.26 pd=2.52 as=0.26 ps=2.52 w=1 l=0.15
X2828 a_13499_18900# a_13053_18900# a_13403_18900# VGND sky130_fd_pr__special_nfet_01v8 ad=0.1401 pd=1.1 as=0.0594 ps=0.69 w=0.36 l=0.15
X2829 a_5690_27192# a_6007_27302# a_5965_27426# VGND sky130_fd_pr__special_nfet_01v8 ad=0.0711 pd=0.755 as=0.0669 ps=0.75 w=0.36 l=0.15
X2830 single_9b_cdac_0.cdac_sw_9b_0.cdac_sw_3_4.nooverlap_clk_0.CLKB0 single_9b_cdac_0.cdac_sw_9b_0.cdac_sw_3_4.nooverlap_clk_0.sky130_fd_sc_hs__inv_8_0.A VDPWR VDPWR sky130_fd_pr__pfet_01v8 ad=0.168 pd=1.42 as=0.196 ps=1.47 w=1.12 l=0.15
X2831 th_dif_sw_0.VCN single_9b_cdac_0.cdac_sw_9b_0.S[0] sky130_fd_pr__cap_mim_m3_1 l=2 w=2
X2832 th_dif_sw_0.VCN single_9b_cdac_0.cdac_sw_9b_0.S[1] sky130_fd_pr__cap_mim_m3_1 l=2 w=2
X2833 single_9b_cdac_1.cdac_sw_9b_0.cdac_sw_3_2.nooverlap_clk_0.CLKB0 single_9b_cdac_1.cdac_sw_9b_0.cdac_sw_3_2.nooverlap_clk_0.sky130_fd_sc_hs__inv_8_0.A VDPWR VDPWR sky130_fd_pr__pfet_01v8 ad=0.168 pd=1.42 as=0.3304 ps=2.83 w=1.12 l=0.15
X2834 single_9b_cdac_0.cdac_sw_9b_0.S[7] single_9b_cdac_0.cdac_sw_9b_0.cdac_sw_3_7.tg_sw_3_3.SWP single_9b_cdac_0.cdac_sw_9b_0.S[7] VDPWR sky130_fd_pr__pfet_01v8 ad=0.435 pd=3.58 as=0 ps=0 w=1.5 l=0.5
X2835 VDPWR VGND VDPWR VDPWR sky130_fd_pr__pfet_01v8_hvt ad=0.2262 pd=2.26 as=0 ps=0 w=0.87 l=0.59
X2836 single_9b_cdac_0.cdac_sw_9b_0.cdac_sw_3_7.nooverlap_clk_0.sky130_fd_sc_hs__inv_8_0.A single_9b_cdac_0.cdac_sw_9b_0.cdac_sw_3_7.nooverlap_clk_0.x1.A VGND VGND sky130_fd_pr__nfet_01v8_lvt ad=0.1184 pd=1.06 as=0.1221 ps=1.07 w=0.74 l=0.15
X2837 a_45123_15495# single_9b_cdac_1.cdac_sw_9b_0.cdac_sw_3_3.nooverlap_clk_0.x3.Y VGND VGND sky130_fd_pr__nfet_01v8_lvt ad=0.0888 pd=0.98 as=0.2109 ps=2.05 w=0.74 l=0.15
X2838 th_dif_sw_0.VCP single_9b_cdac_1.cdac_sw_9b_0.S[1] sky130_fd_pr__cap_mim_m3_1 l=2 w=2
X2839 a_6337_22714# a_6171_22714# VDPWR VDPWR sky130_fd_pr__pfet_01v8_hvt ad=0.1664 pd=1.8 as=0.0864 ps=0.91 w=0.64 l=0.15
X2840 a_10827_19822# a_10311_19450# a_10732_19810# VGND sky130_fd_pr__special_nfet_01v8 ad=0.0594 pd=0.69 as=0.066 ps=0.745 w=0.36 l=0.15
X2841 th_dif_sw_0.VCN single_9b_cdac_0.cdac_sw_9b_0.S[0] sky130_fd_pr__cap_mim_m3_1 l=2 w=2
X2842 single_9b_cdac_0.cdac_sw_9b_0.S[8] single_9b_cdac_0.cdac_sw_9b_0.cdac_sw_3_8.tg_sw_3_3.SWP ua[0] VGND sky130_fd_pr__nfet_01v8 ad=0.145 pd=1.58 as=0.145 ps=1.58 w=0.5 l=0.5
X2843 VGND a_7795_26276# a_7729_26350# VGND sky130_fd_pr__nfet_01v8 ad=0.12495 pd=1.015 as=0.0669 ps=0.75 w=0.42 l=0.15
X2844 VDPWR VGND VDPWR VDPWR sky130_fd_pr__pfet_01v8_hvt ad=0.2262 pd=2.26 as=0 ps=0 w=0.87 l=0.59
X2845 th_dif_sw_0.VCN single_9b_cdac_0.cdac_sw_9b_0.S[0] sky130_fd_pr__cap_mim_m3_1 l=2 w=2
X2846 VDPWR single_9b_cdac_0.cdac_sw_9b_0.cdac_sw_3_7.nooverlap_clk_0.x10.A single_9b_cdac_0.cdac_sw_9b_0.cdac_sw_3_7.tg_sw_3_3.SWN VDPWR sky130_fd_pr__pfet_01v8 ad=0.3304 pd=2.83 as=0.168 ps=1.42 w=1.12 l=0.15
X2847 single_9b_cdac_0.cdac_sw_9b_0.S[7] single_9b_cdac_0.cdac_sw_9b_0.cdac_sw_3_7.tg_sw_3_3.SWN single_9b_cdac_0.cdac_sw_9b_0.S[7] VGND sky130_fd_pr__nfet_01v8 ad=0.145 pd=1.58 as=0 ps=0 w=0.5 l=0.5
X2848 VDPWR sar9b_0.net10 a_9670_22708# VDPWR sky130_fd_pr__pfet_01v8_hvt ad=0.1092 pd=1.36 as=0.0651 ps=0.73 w=0.42 l=0.15
X2849 VGND single_9b_cdac_1.SW[8] a_25210_17740# VGND sky130_fd_pr__nfet_01v8 ad=0.145 pd=1.58 as=0.145 ps=1.58 w=0.5 l=0.5
X2850 a_13315_18660# a_13140_18734# a_13494_18722# VGND sky130_fd_pr__nfet_01v8 ad=0.1092 pd=1.36 as=0.06405 ps=0.725 w=0.42 l=0.15
X2851 VDPWR a_12793_18330# a_12683_18356# VDPWR sky130_fd_pr__pfet_01v8_hvt ad=0.07035 pd=0.755 as=0.1155 ps=0.97 w=0.42 l=0.15
X2852 VGND single_9b_cdac_0.cdac_sw_9b_0.cdac_sw_3_8.nooverlap_clk_0.x3.Y a_25915_29917# VGND sky130_fd_pr__nfet_01v8_lvt ad=0.2109 pd=2.05 as=0.0888 ps=0.98 w=0.74 l=0.15
X2853 th_dif_sw_0.VCP single_9b_cdac_1.cdac_sw_9b_0.S[0] sky130_fd_pr__cap_mim_m3_1 l=2 w=2
X2854 th_dif_sw_0.VCP single_9b_cdac_1.cdac_sw_9b_0.S[0] sky130_fd_pr__cap_mim_m3_1 l=2 w=2
X2855 th_dif_sw_0.VCN single_9b_cdac_0.cdac_sw_9b_0.S[0] sky130_fd_pr__cap_mim_m3_1 l=2 w=2
X2856 a_8613_26681# sar9b_0.net20 VDPWR VDPWR sky130_fd_pr__pfet_01v8_hvt ad=0.2054 pd=2.1 as=0.11455 ps=1.08 w=0.79 l=0.15
X2857 single_9b_cdac_0.cdac_sw_9b_0.cdac_sw_3_7.tg_sw_3_3.SWN single_9b_cdac_0.cdac_sw_9b_0.cdac_sw_3_7.nooverlap_clk_0.x10.A VDPWR VDPWR sky130_fd_pr__pfet_01v8 ad=0.168 pd=1.42 as=0.196 ps=1.47 w=1.12 l=0.15
X2858 VDPWR single_9b_cdac_0.cdac_sw_9b_0.cdac_sw_3_7.nooverlap_clk_0.sky130_fd_sc_hs__inv_8_0.A single_9b_cdac_0.cdac_sw_9b_0.cdac_sw_3_7.nooverlap_clk_0.CLKB0 VDPWR sky130_fd_pr__pfet_01v8 ad=0.196 pd=1.47 as=0.168 ps=1.42 w=1.12 l=0.15
X2859 ua[0] single_9b_cdac_1.cdac_sw_9b_0.cdac_sw_3_3.tg_sw_3_3.SWP ua[0] VDPWR sky130_fd_pr__pfet_01v8 ad=0.435 pd=3.58 as=0 ps=0 w=1.5 l=0.5
X2860 single_9b_cdac_0.cdac_sw_9b_0.S[1] single_9b_cdac_0.cdac_sw_9b_0.cdac_sw_3_1.nooverlap_clk_0.CLKB0 a_57946_26999# VDPWR sky130_fd_pr__pfet_01v8 ad=0.435 pd=3.58 as=0.435 ps=3.58 w=1.5 l=0.5
X2861 single_9b_cdac_0.SW[7] a_13623_25972# VGND VGND sky130_fd_pr__nfet_01v8 ad=0.1352 pd=1.56 as=0.0754 ps=0.81 w=0.52 l=0.15
X2862 VGND single_9b_cdac_1.cdac_sw_9b_0.cdac_sw_3_2.tg_sw_3_3.SWN single_9b_cdac_1.cdac_sw_9b_0.cdac_sw_3_2.tg_sw_3_3.SWP VGND sky130_fd_pr__nfet_01v8_lvt ad=0.1554 pd=1.16 as=0.1036 ps=1.02 w=0.74 l=0.15
X2863 a_62748_16877# single_9b_cdac_1.SW[0] VDPWR VDPWR sky130_fd_pr__pfet_01v8 ad=0.435 pd=3.58 as=0.435 ps=3.58 w=1.5 l=0.5
X2864 single_9b_cdac_0.cdac_sw_9b_0.S[6] single_9b_cdac_0.cdac_sw_9b_0.cdac_sw_3_6.tg_sw_3_3.SWP ua[0] VGND sky130_fd_pr__nfet_01v8 ad=0.145 pd=1.58 as=0.145 ps=1.58 w=0.5 l=0.5
X2865 single_9b_cdac_0.cdac_sw_9b_0.cdac_sw_3_7.nooverlap_clk_0.CLKB0 single_9b_cdac_0.cdac_sw_9b_0.cdac_sw_3_7.nooverlap_clk_0.sky130_fd_sc_hs__inv_8_0.A VDPWR VDPWR sky130_fd_pr__pfet_01v8 ad=0.168 pd=1.42 as=0.3864 ps=2.93 w=1.12 l=0.15
X2866 VGND VDPWR VGND VGND sky130_fd_pr__nfet_01v8 ad=0.143 pd=1.62 as=0 ps=0 w=0.55 l=0.59
X2867 th_dif_sw_0.VCN single_9b_cdac_0.cdac_sw_9b_0.S[2] sky130_fd_pr__cap_mim_m3_1 l=2 w=2
X2868 VDPWR single_9b_cdac_0.cdac_sw_9b_0.cdac_sw_3_0.nooverlap_clk_0.x4.A single_9b_cdac_0.cdac_sw_9b_0.cdac_sw_3_0.nooverlap_clk_0.x6.A VDPWR sky130_fd_pr__pfet_01v8 ad=0.3864 pd=2.93 as=0.3304 ps=2.83 w=1.12 l=0.15
X2869 VGND VDPWR VGND VGND sky130_fd_pr__nfet_01v8 ad=0.143 pd=1.62 as=0 ps=0 w=0.55 l=0.59
X2870 VDPWR VGND VDPWR VDPWR sky130_fd_pr__pfet_01v8_hvt ad=0.2262 pd=2.26 as=0 ps=0 w=0.87 l=0.59
X2871 single_9b_cdac_0.cdac_sw_9b_0.cdac_sw_3_2.nooverlap_clk_0.CLKB0 single_9b_cdac_0.cdac_sw_9b_0.cdac_sw_3_2.nooverlap_clk_0.sky130_fd_sc_hs__inv_8_0.A VGND VGND sky130_fd_pr__nfet_01v8_lvt ad=0.1036 pd=1.02 as=0.1554 ps=1.16 w=0.74 l=0.15
X2872 a_6149_23770# sar9b_0.clknet_0_CLK VDPWR VDPWR sky130_fd_pr__pfet_01v8_hvt ad=0.14 pd=1.28 as=0.14 ps=1.28 w=1 l=0.15
X2873 VGND single_9b_cdac_1.CF[5] single_9b_cdac_0.cdac_sw_9b_0.cdac_sw_3_5.nooverlap_clk_0.x3.Y VGND sky130_fd_pr__nfet_01v8_lvt ad=0.2627 pd=2.19 as=0.2109 ps=2.05 w=0.74 l=0.15
X2874 VDPWR VGND VDPWR VDPWR sky130_fd_pr__pfet_01v8_hvt ad=0.2262 pd=2.26 as=0 ps=0 w=0.87 l=0.59
X2875 th_dif_sw_0.VCN single_9b_cdac_0.cdac_sw_9b_0.S[1] sky130_fd_pr__cap_mim_m3_1 l=2 w=2
X2876 single_9b_cdac_1.cdac_sw_9b_0.cdac_sw_3_7.nooverlap_clk_0.x3.Y single_9b_cdac_1.CF[7] VGND VGND sky130_fd_pr__nfet_01v8_lvt ad=0.2109 pd=2.05 as=0.2627 ps=2.19 w=0.74 l=0.15
X2877 VGND single_9b_cdac_0.cdac_sw_9b_0.cdac_sw_3_4.nooverlap_clk_0.x1.A single_9b_cdac_0.cdac_sw_9b_0.cdac_sw_3_4.nooverlap_clk_0.sky130_fd_sc_hs__inv_8_0.A VGND sky130_fd_pr__nfet_01v8_lvt ad=0.2331 pd=2.11 as=0.1184 ps=1.06 w=0.74 l=0.15
X2878 dw_12589_1395# a_10166_3438# sky130_fd_pr__cap_mim_m3_1 l=2 w=2
X2879 VGND single_9b_cdac_1.cdac_sw_9b_0.cdac_sw_3_6.nooverlap_clk_0.sky130_fd_sc_hs__inv_8_0.A single_9b_cdac_1.cdac_sw_9b_0.cdac_sw_3_6.nooverlap_clk_0.CLKB0 VGND sky130_fd_pr__nfet_01v8_lvt ad=0.2146 pd=2.06 as=0.1036 ps=1.02 w=0.74 l=0.15
X2880 a_8800_24340# sar9b_0.net11 VGND VGND sky130_fd_pr__nfet_01v8 ad=0.066 pd=0.745 as=0.2205 ps=1.89 w=0.42 l=0.15
X2881 VDPWR a_6679_22316# sar9b_0._07_ VDPWR sky130_fd_pr__pfet_01v8_hvt ad=0.14825 pd=1.34 as=0.275 ps=2.55 w=1 l=0.15
X2882 ua[0] single_9b_cdac_1.cdac_sw_9b_0.cdac_sw_3_4.tg_sw_3_3.SWP ua[0] VDPWR sky130_fd_pr__pfet_01v8 ad=0.435 pd=3.58 as=0 ps=0 w=1.5 l=0.5
X2883 VDPWR VGND VDPWR VDPWR sky130_fd_pr__pfet_01v8_hvt ad=0.2262 pd=2.26 as=0 ps=0 w=0.87 l=0.59
X2884 th_dif_sw_0.VCN single_9b_cdac_0.cdac_sw_9b_0.S[0] sky130_fd_pr__cap_mim_m3_1 l=2 w=2
X2885 single_9b_cdac_0.cdac_sw_9b_0.cdac_sw_3_0.nooverlap_clk_0.CLKB0 single_9b_cdac_0.cdac_sw_9b_0.cdac_sw_3_0.nooverlap_clk_0.sky130_fd_sc_hs__inv_8_0.A VGND VGND sky130_fd_pr__nfet_01v8_lvt ad=0.1036 pd=1.02 as=0.2146 ps=2.06 w=0.74 l=0.15
X2886 VDPWR single_9b_cdac_1.cdac_sw_9b_0.cdac_sw_3_3.nooverlap_clk_0.sky130_fd_sc_hs__inv_8_0.A single_9b_cdac_1.cdac_sw_9b_0.cdac_sw_3_3.nooverlap_clk_0.CLKB0 VDPWR sky130_fd_pr__pfet_01v8 ad=0.3864 pd=2.93 as=0.168 ps=1.42 w=1.12 l=0.15
X2887 th_dif_sw_0.VCP single_9b_cdac_1.cdac_sw_9b_0.S[0] sky130_fd_pr__cap_mim_m3_1 l=2 w=2
X2888 VDPWR VGND VDPWR VDPWR sky130_fd_pr__pfet_01v8_hvt ad=0.2262 pd=2.26 as=0 ps=0 w=0.87 l=0.59
X2889 VDPWR a_6163_27034# a_6094_27060# VDPWR sky130_fd_pr__pfet_01v8_hvt ad=0.2184 pd=2.2 as=0.12915 ps=1.185 w=0.84 l=0.15
X2890 ua[0] single_9b_cdac_0.cdac_sw_9b_0.cdac_sw_3_6.tg_sw_3_3.SWN ua[0] VGND sky130_fd_pr__nfet_01v8 ad=0.145 pd=1.58 as=0 ps=0 w=0.5 l=0.5
X2891 single_9b_cdac_1.cdac_sw_9b_0.S[8] single_9b_cdac_1.cdac_sw_9b_0.cdac_sw_3_8.tg_sw_3_3.SWP ua[0] VGND sky130_fd_pr__nfet_01v8 ad=0.145 pd=1.58 as=0.145 ps=1.58 w=0.5 l=0.5
X2892 single_9b_cdac_1.cdac_sw_9b_0.cdac_sw_3_4.tg_sw_3_3.SWP single_9b_cdac_1.cdac_sw_9b_0.cdac_sw_3_4.tg_sw_3_3.SWN VGND VGND sky130_fd_pr__nfet_01v8_lvt ad=0.1036 pd=1.02 as=0.1036 ps=1.02 w=0.74 l=0.15
X2893 VDPWR th_dif_sw_0.CK a_9132_7271# VDPWR sky130_fd_pr__pfet_01v8 ad=0.168 pd=1.42 as=0.168 ps=1.42 w=1.12 l=0.15
X2894 VGND single_9b_cdac_1.cdac_sw_9b_0.cdac_sw_3_7.nooverlap_clk_0.CLKB0 single_9b_cdac_1.cdac_sw_9b_0.cdac_sw_3_7.nooverlap_clk_0.CLK0 VGND sky130_fd_pr__nfet_01v8_lvt ad=0.1554 pd=1.16 as=0.1036 ps=1.02 w=0.74 l=0.15
X2895 single_9b_cdac_0.cdac_sw_9b_0.cdac_sw_3_0.tg_sw_3_3.SWP single_9b_cdac_0.cdac_sw_9b_0.cdac_sw_3_0.tg_sw_3_3.SWN VDPWR VDPWR sky130_fd_pr__pfet_01v8 ad=0.168 pd=1.42 as=0.3864 ps=2.93 w=1.12 l=0.15
X2896 single_9b_cdac_0.cdac_sw_9b_0.S[0] single_9b_cdac_0.cdac_sw_9b_0.cdac_sw_3_2.tg_sw_3_3.SWN ua[0] VDPWR sky130_fd_pr__pfet_01v8 ad=0.435 pd=3.58 as=0.435 ps=3.58 w=1.5 l=0.5
X2897 a_13053_24890# a_12887_24890# VGND VGND sky130_fd_pr__nfet_01v8 ad=0.1092 pd=1.36 as=0.0567 ps=0.69 w=0.42 l=0.15
X2898 VGND VDPWR VGND VGND sky130_fd_pr__nfet_01v8 ad=0.143 pd=1.62 as=0 ps=0 w=0.55 l=0.59
X2899 single_9b_cdac_1.cdac_sw_9b_0.cdac_sw_3_3.nooverlap_clk_0.CLKB0 single_9b_cdac_1.cdac_sw_9b_0.cdac_sw_3_3.nooverlap_clk_0.sky130_fd_sc_hs__inv_8_0.A VDPWR VDPWR sky130_fd_pr__pfet_01v8 ad=0.168 pd=1.42 as=0.196 ps=1.47 w=1.12 l=0.15
X2900 single_9b_cdac_0.cdac_sw_9b_0.S[1] single_9b_cdac_0.cdac_sw_9b_0.cdac_sw_3_1.tg_sw_3_3.SWN single_9b_cdac_0.cdac_sw_9b_0.S[1] VGND sky130_fd_pr__nfet_01v8 ad=0.145 pd=1.58 as=0 ps=0 w=0.5 l=0.5
X2901 th_dif_sw_0.VCN single_9b_cdac_0.cdac_sw_9b_0.S[0] sky130_fd_pr__cap_mim_m3_1 l=2 w=2
X2902 single_9b_cdac_1.cdac_sw_9b_0.cdac_sw_3_1.tg_sw_3_3.SWP single_9b_cdac_1.cdac_sw_9b_0.cdac_sw_3_1.tg_sw_3_3.SWN VGND VGND sky130_fd_pr__nfet_01v8_lvt ad=0.1036 pd=1.02 as=0.1295 ps=1.09 w=0.74 l=0.15
X2903 a_25210_17740# single_9b_cdac_1.cdac_sw_9b_0.cdac_sw_3_8.nooverlap_clk_0.CLK0 single_9b_cdac_1.cdac_sw_9b_0.S[8] VGND sky130_fd_pr__nfet_01v8 ad=0.145 pd=1.58 as=0.145 ps=1.58 w=0.5 l=0.5
X2904 single_9b_cdac_1.cdac_sw_9b_0.cdac_sw_3_7.tg_sw_3_3.SWN single_9b_cdac_1.cdac_sw_9b_0.cdac_sw_3_7.nooverlap_clk_0.x10.A VDPWR VDPWR sky130_fd_pr__pfet_01v8 ad=0.168 pd=1.42 as=0.3304 ps=2.83 w=1.12 l=0.15
X2905 single_9b_cdac_0.cdac_sw_9b_0.S[0] single_9b_cdac_0.cdac_sw_9b_0.cdac_sw_3_2.tg_sw_3_3.SWP single_9b_cdac_0.cdac_sw_9b_0.S[0] VDPWR sky130_fd_pr__pfet_01v8 ad=0.435 pd=3.58 as=0 ps=0 w=1.5 l=0.5
X2906 a_9722_19810# sar9b_0.net15 VGND VGND sky130_fd_pr__nfet_01v8 ad=0.06405 pd=0.725 as=0.12495 ps=1.015 w=0.42 l=0.15
X2907 VDPWR a_9635_26276# a_9622_25972# VDPWR sky130_fd_pr__pfet_01v8_hvt ad=0.0819 pd=0.81 as=0.0567 ps=0.69 w=0.42 l=0.15
X2908 VDPWR single_9b_cdac_1.cdac_sw_9b_0.cdac_sw_3_8.nooverlap_clk_0.CLKB0 single_9b_cdac_1.cdac_sw_9b_0.cdac_sw_3_8.nooverlap_clk_0.CLK0 VDPWR sky130_fd_pr__pfet_01v8 ad=0.3864 pd=2.93 as=0.168 ps=1.42 w=1.12 l=0.15
X2909 VDPWR single_9b_cdac_1.cdac_sw_9b_0.cdac_sw_3_3.tg_sw_3_3.SWN single_9b_cdac_1.cdac_sw_9b_0.cdac_sw_3_3.tg_sw_3_3.SWP VDPWR sky130_fd_pr__pfet_01v8 ad=0.196 pd=1.47 as=0.168 ps=1.42 w=1.12 l=0.15
X2910 th_dif_sw_0.VCP single_9b_cdac_1.cdac_sw_9b_0.S[1] sky130_fd_pr__cap_mim_m3_1 l=2 w=2
X2911 th_dif_sw_0.VCN single_9b_cdac_0.cdac_sw_9b_0.S[2] sky130_fd_pr__cap_mim_m3_1 l=2 w=2
X2912 a_14130_26882# a_13053_26516# a_13968_26516# VDPWR sky130_fd_pr__pfet_01v8_hvt ad=0.0567 pd=0.69 as=0.0588 ps=0.7 w=0.42 l=0.15
X2913 sar9b_0.clknet_1_1__leaf_CLK a_6149_23770# VGND VGND sky130_fd_pr__nfet_01v8 ad=0.0588 pd=0.7 as=0.0588 ps=0.7 w=0.42 l=0.15
X2914 a_10845_25428# a_10679_25428# VGND VGND sky130_fd_pr__nfet_01v8 ad=0.1092 pd=1.36 as=0.0567 ps=0.69 w=0.42 l=0.15
X2915 sar9b_0.clknet_1_1__leaf_CLK a_6149_23770# VGND VGND sky130_fd_pr__nfet_01v8 ad=0.0588 pd=0.7 as=0.0588 ps=0.7 w=0.42 l=0.15
X2916 th_dif_sw_0.VCP single_9b_cdac_1.cdac_sw_9b_0.S[0] sky130_fd_pr__cap_mim_m3_1 l=2 w=2
X2917 th_dif_sw_0.VCN single_9b_cdac_0.cdac_sw_9b_0.S[0] sky130_fd_pr__cap_mim_m3_1 l=2 w=2
X2918 a_11471_21076# a_10955_21076# a_11376_21076# VGND sky130_fd_pr__special_nfet_01v8 ad=0.0594 pd=0.69 as=0.066 ps=0.745 w=0.36 l=0.15
X2919 single_9b_cdac_1.cdac_sw_9b_0.cdac_sw_3_8.nooverlap_clk_0.CLK0 single_9b_cdac_1.cdac_sw_9b_0.cdac_sw_3_8.nooverlap_clk_0.CLKB0 VDPWR VDPWR sky130_fd_pr__pfet_01v8 ad=0.168 pd=1.42 as=0.196 ps=1.47 w=1.12 l=0.15
X2920 single_9b_cdac_1.cdac_sw_9b_0.cdac_sw_3_3.tg_sw_3_3.SWP single_9b_cdac_1.cdac_sw_9b_0.cdac_sw_3_3.tg_sw_3_3.SWN VDPWR VDPWR sky130_fd_pr__pfet_01v8 ad=0.168 pd=1.42 as=0.3304 ps=2.83 w=1.12 l=0.15
X2921 a_10937_22164# a_10771_22164# VGND VGND sky130_fd_pr__nfet_01v8 ad=0.1092 pd=1.36 as=0.0567 ps=0.69 w=0.42 l=0.15
X2922 a_12487_20836# a_12312_20910# a_12666_20898# VGND sky130_fd_pr__nfet_01v8 ad=0.1092 pd=1.36 as=0.06405 ps=0.725 w=0.42 l=0.15
X2923 ua[2] th_dif_sw_0.th_sw_1.CK ua[2] VGND sky130_fd_pr__nfet_01v8 ad=5.8 pd=40.58 as=18.56 ps=130.32001 w=20 l=0.15
X2924 a_13876_24174# a_12961_23802# a_13529_23770# VGND sky130_fd_pr__special_nfet_01v8 ad=0.0711 pd=0.755 as=0.0999 ps=0.985 w=0.36 l=0.15
X2925 VDPWR sar9b_0.net41 a_14175_20532# VDPWR sky130_fd_pr__pfet_01v8_hvt ad=0.11455 pd=1.08 as=0.2054 ps=2.1 w=0.79 l=0.15
X2926 ua[0] single_9b_cdac_1.cdac_sw_9b_0.cdac_sw_3_8.tg_sw_3_3.SWP ua[0] VDPWR sky130_fd_pr__pfet_01v8 ad=0.435 pd=3.58 as=0 ps=0 w=1.5 l=0.5
X2927 single_9b_cdac_0.cdac_sw_9b_0.cdac_sw_3_6.nooverlap_clk_0.CLK0 single_9b_cdac_0.cdac_sw_9b_0.cdac_sw_3_6.nooverlap_clk_0.CLKB0 VGND VGND sky130_fd_pr__nfet_01v8_lvt ad=0.1036 pd=1.02 as=0.1295 ps=1.09 w=0.74 l=0.15
X2928 a_6943_22316# sar9b_0.clk_div_0.COUNT\[2\] VDPWR VDPWR sky130_fd_pr__pfet_01v8_hvt ad=0.1092 pd=1.36 as=0.1226 ps=1.32 w=0.42 l=0.15
X2929 single_9b_cdac_1.cdac_sw_9b_0.S[6] single_9b_cdac_1.cdac_sw_9b_0.cdac_sw_3_6.nooverlap_clk_0.CLKB0 a_33936_16877# VDPWR sky130_fd_pr__pfet_01v8 ad=0.435 pd=3.58 as=0.435 ps=3.58 w=1.5 l=0.5
X2930 VDPWR sar9b_0.net27 a_13899_24340# VDPWR sky130_fd_pr__pfet_01v8_hvt ad=0.11455 pd=1.08 as=0.2054 ps=2.1 w=0.79 l=0.15
X2931 VGND VDPWR VGND VGND sky130_fd_pr__nfet_01v8 ad=0.143 pd=1.62 as=0 ps=0 w=0.55 l=0.59
X2932 th_dif_sw_0.VCP single_9b_cdac_1.cdac_sw_9b_0.S[1] sky130_fd_pr__cap_mim_m3_1 l=2 w=2
X2933 single_9b_cdac_0.cdac_sw_9b_0.cdac_sw_3_6.nooverlap_clk_0.x10.A single_9b_cdac_0.cdac_sw_9b_0.cdac_sw_3_6.nooverlap_clk_0.x8.A VDPWR VDPWR sky130_fd_pr__pfet_01v8 ad=0.168 pd=1.42 as=0.168 ps=1.42 w=1.12 l=0.15
X2934 VDPWR VGND VDPWR VDPWR sky130_fd_pr__pfet_01v8_hvt ad=0.2262 pd=2.26 as=0 ps=0 w=0.87 l=0.59
X2935 a_13403_22164# a_12887_22164# a_13308_22164# VGND sky130_fd_pr__special_nfet_01v8 ad=0.0594 pd=0.69 as=0.066 ps=0.745 w=0.36 l=0.15
X2936 a_29134_16877# single_9b_cdac_1.SW[7] VDPWR VDPWR sky130_fd_pr__pfet_01v8 ad=0.435 pd=3.58 as=0.435 ps=3.58 w=1.5 l=0.5
X2937 th_dif_sw_0.VCN single_9b_cdac_0.cdac_sw_9b_0.S[0] sky130_fd_pr__cap_mim_m3_1 l=2 w=2
X2938 th_dif_sw_0.VCN single_9b_cdac_0.cdac_sw_9b_0.S[0] sky130_fd_pr__cap_mim_m3_1 l=2 w=2
X2939 single_9b_cdac_0.cdac_sw_9b_0.cdac_sw_3_3.nooverlap_clk_0.CLKB0 single_9b_cdac_0.cdac_sw_9b_0.cdac_sw_3_3.nooverlap_clk_0.sky130_fd_sc_hs__inv_8_0.A VGND VGND sky130_fd_pr__nfet_01v8_lvt ad=0.1036 pd=1.02 as=0.2146 ps=2.06 w=0.74 l=0.15
X2940 VGND a_9543_19748# a_9477_19822# VGND sky130_fd_pr__nfet_01v8 ad=0.12495 pd=1.015 as=0.0669 ps=0.75 w=0.42 l=0.15
X2941 th_dif_sw_0.VCP single_9b_cdac_1.cdac_sw_9b_0.S[2] sky130_fd_pr__cap_mim_m3_1 l=2 w=2
X2942 VGND single_9b_cdac_0.cdac_sw_9b_0.cdac_sw_3_5.nooverlap_clk_0.x3.Y a_40321_29917# VGND sky130_fd_pr__nfet_01v8_lvt ad=0.2109 pd=2.05 as=0.0888 ps=0.98 w=0.74 l=0.15
X2943 VDPWR single_9b_cdac_0.cdac_sw_9b_0.cdac_sw_3_6.nooverlap_clk_0.x8.A single_9b_cdac_0.cdac_sw_9b_0.cdac_sw_3_6.nooverlap_clk_0.x10.A VDPWR sky130_fd_pr__pfet_01v8 ad=0.168 pd=1.42 as=0.168 ps=1.42 w=1.12 l=0.15
X2944 ua[0] single_9b_cdac_0.cdac_sw_9b_0.cdac_sw_3_1.tg_sw_3_3.SWP ua[0] VDPWR sky130_fd_pr__pfet_01v8 ad=0.435 pd=3.58 as=0 ps=0 w=1.5 l=0.5
X2945 sar9b_0.net26 a_14143_19748# VDPWR VDPWR sky130_fd_pr__pfet_01v8_hvt ad=0.26 pd=2.52 as=0.3012 ps=2.66 w=1 l=0.15
X2946 ua[0] single_9b_cdac_1.cdac_sw_9b_0.cdac_sw_3_2.tg_sw_3_3.SWN ua[0] VGND sky130_fd_pr__nfet_01v8 ad=0.145 pd=1.58 as=0 ps=0 w=0.5 l=0.5
X2947 VGND single_9b_cdac_0.cdac_sw_9b_0.cdac_sw_3_8.nooverlap_clk_0.x6.A single_9b_cdac_0.cdac_sw_9b_0.cdac_sw_3_8.nooverlap_clk_0.x8.A VGND sky130_fd_pr__nfet_01v8_lvt ad=0.2627 pd=2.19 as=0.2109 ps=2.05 w=0.74 l=0.15
X2948 th_dif_sw_0.VCP single_9b_cdac_1.cdac_sw_9b_0.S[0] sky130_fd_pr__cap_mim_m3_1 l=2 w=2
X2949 single_9b_cdac_0.cdac_sw_9b_0.cdac_sw_3_6.nooverlap_clk_0.x10.A single_9b_cdac_0.cdac_sw_9b_0.cdac_sw_3_6.nooverlap_clk_0.x8.A VDPWR VDPWR sky130_fd_pr__pfet_01v8 ad=0.168 pd=1.42 as=0.3304 ps=2.83 w=1.12 l=0.15
X2950 ua[0] single_9b_cdac_0.cdac_sw_9b_0.cdac_sw_3_2.tg_sw_3_3.SWN ua[0] VGND sky130_fd_pr__nfet_01v8 ad=0.145 pd=1.58 as=0 ps=0 w=0.5 l=0.5
X2951 a_9113_24582# a_8895_24340# VGND VGND sky130_fd_pr__nfet_01v8 ad=0.0999 pd=0.985 as=0.1346 ps=1.15 w=0.64 l=0.15
X2952 a_13968_19988# a_12887_19988# a_13621_20230# VDPWR sky130_fd_pr__pfet_01v8_hvt ad=0.0588 pd=0.7 as=0.12915 ps=1.185 w=0.42 l=0.15
X2953 a_13053_22714# a_12887_22714# VDPWR VDPWR sky130_fd_pr__pfet_01v8_hvt ad=0.1664 pd=1.8 as=0.0864 ps=0.91 w=0.64 l=0.15
X2954 VGND single_9b_cdac_1.cdac_sw_9b_0.cdac_sw_3_0.tg_sw_3_3.SWN single_9b_cdac_1.cdac_sw_9b_0.cdac_sw_3_0.tg_sw_3_3.SWP VGND sky130_fd_pr__nfet_01v8_lvt ad=0.2146 pd=2.06 as=0.1036 ps=1.02 w=0.74 l=0.15
X2955 th_dif_sw_0.VCN single_9b_cdac_0.cdac_sw_9b_0.S[0] sky130_fd_pr__cap_mim_m3_1 l=2 w=2
X2956 VGND a_6483_23618# a_6651_23520# VGND sky130_fd_pr__nfet_01v8 ad=0.08775 pd=0.92 as=0.169 ps=1.82 w=0.65 l=0.15
X2957 th_dif_sw_0.VCP single_9b_cdac_1.cdac_sw_9b_0.S[0] sky130_fd_pr__cap_mim_m3_1 l=2 w=2
X2958 VGND a_8951_22950# a_8912_22824# VGND sky130_fd_pr__nfet_01v8 ad=0.0567 pd=0.69 as=0.1092 ps=1.36 w=0.42 l=0.15
X2959 a_9205_23494# a_8987_23252# VDPWR VDPWR sky130_fd_pr__pfet_01v8_hvt ad=0.12915 pd=1.185 as=0.2184 ps=2.2 w=0.84 l=0.15
X2960 VDPWR single_9b_cdac_0.cdac_sw_9b_0.cdac_sw_3_8.nooverlap_clk_0.x8.A single_9b_cdac_0.cdac_sw_9b_0.cdac_sw_3_8.nooverlap_clk_0.x10.A VDPWR sky130_fd_pr__pfet_01v8 ad=0.3304 pd=2.83 as=0.168 ps=1.42 w=1.12 l=0.15
X2961 th_dif_sw_0.VCP single_9b_cdac_1.cdac_sw_9b_0.S[1] sky130_fd_pr__cap_mim_m3_1 l=2 w=2
X2962 th_dif_sw_0.VCP single_9b_cdac_1.cdac_sw_9b_0.S[0] sky130_fd_pr__cap_mim_m3_1 l=2 w=2
X2963 single_9b_cdac_1.cdac_sw_9b_0.cdac_sw_3_1.nooverlap_clk_0.CLK0 single_9b_cdac_1.cdac_sw_9b_0.cdac_sw_3_1.nooverlap_clk_0.CLKB0 VGND VGND sky130_fd_pr__nfet_01v8_lvt ad=0.1036 pd=1.02 as=0.1554 ps=1.16 w=0.74 l=0.15
X2964 single_9b_cdac_0.cdac_sw_9b_0.cdac_sw_3_8.nooverlap_clk_0.CLKB0 single_9b_cdac_0.cdac_sw_9b_0.cdac_sw_3_8.nooverlap_clk_0.sky130_fd_sc_hs__inv_8_0.A VGND VGND sky130_fd_pr__nfet_01v8_lvt ad=0.1036 pd=1.02 as=0.1036 ps=1.02 w=0.74 l=0.15
X2965 single_9b_cdac_1.cdac_sw_9b_0.S[1] single_9b_cdac_1.cdac_sw_9b_0.cdac_sw_3_1.tg_sw_3_3.SWN single_9b_cdac_1.cdac_sw_9b_0.S[1] VGND sky130_fd_pr__nfet_01v8 ad=0.145 pd=1.58 as=0 ps=0 w=0.5 l=0.5
X2966 th_dif_sw_0.VCP single_9b_cdac_1.cdac_sw_9b_0.S[0] sky130_fd_pr__cap_mim_m3_1 l=2 w=2
X2967 single_9b_cdac_0.cdac_sw_9b_0.S[7] single_9b_cdac_0.cdac_sw_9b_0.cdac_sw_3_7.tg_sw_3_3.SWN ua[0] VDPWR sky130_fd_pr__pfet_01v8 ad=0.435 pd=3.58 as=0.435 ps=3.58 w=1.5 l=0.5
X2968 th_dif_sw_0.VCN single_9b_cdac_0.cdac_sw_9b_0.S[2] sky130_fd_pr__cap_mim_m3_1 l=2 w=2
X2969 VGND single_9b_cdac_0.cdac_sw_9b_0.cdac_sw_3_0.nooverlap_clk_0.x4.A single_9b_cdac_0.cdac_sw_9b_0.cdac_sw_3_0.nooverlap_clk_0.x6.A VGND sky130_fd_pr__nfet_01v8_lvt ad=0.2627 pd=2.19 as=0.2109 ps=2.05 w=0.74 l=0.15
X2970 VDPWR single_9b_cdac_0.cdac_sw_9b_0.cdac_sw_3_0.nooverlap_clk_0.x6.A single_9b_cdac_0.cdac_sw_9b_0.cdac_sw_3_0.nooverlap_clk_0.x8.A VDPWR sky130_fd_pr__pfet_01v8 ad=0.3864 pd=2.93 as=0.3304 ps=2.83 w=1.12 l=0.15
X2971 single_9b_cdac_0.cdac_sw_9b_0.S[1] single_9b_cdac_0.cdac_sw_9b_0.cdac_sw_3_1.nooverlap_clk_0.CLKB0 a_57946_26999# VDPWR sky130_fd_pr__pfet_01v8 ad=0.435 pd=3.58 as=0.435 ps=3.58 w=1.5 l=0.5
X2972 sar9b_0.net20 a_7795_26276# VDPWR VDPWR sky130_fd_pr__pfet_01v8_hvt ad=0.26 pd=2.52 as=0.3012 ps=2.66 w=1 l=0.15
X2973 th_dif_sw_0.VCP single_9b_cdac_1.cdac_sw_9b_0.S[0] sky130_fd_pr__cap_mim_m3_1 l=2 w=2
X2974 th_dif_sw_0.VCN single_9b_cdac_0.cdac_sw_9b_0.S[0] sky130_fd_pr__cap_mim_m3_1 l=2 w=2
X2975 VGND VDPWR VGND VGND sky130_fd_pr__nfet_01v8 ad=0.143 pd=1.62 as=0 ps=0 w=0.55 l=0.59
X2976 a_62748_16877# single_9b_cdac_1.SW[0] VDPWR VDPWR sky130_fd_pr__pfet_01v8 ad=0.435 pd=3.58 as=0.435 ps=3.58 w=1.5 l=0.5
X2977 a_10732_23252# sar9b_0.net2 VDPWR VDPWR sky130_fd_pr__pfet_01v8_hvt ad=0.0651 pd=0.73 as=0.1092 ps=1.36 w=0.42 l=0.15
X2978 VDPWR VGND VDPWR VDPWR sky130_fd_pr__pfet_01v8_hvt ad=0.2262 pd=2.26 as=0 ps=0 w=0.87 l=0.59
X2979 VDPWR single_9b_cdac_1.cdac_sw_9b_0.cdac_sw_3_1.nooverlap_clk_0.sky130_fd_sc_hs__inv_8_0.A single_9b_cdac_1.cdac_sw_9b_0.cdac_sw_3_1.nooverlap_clk_0.CLKB0 VDPWR sky130_fd_pr__pfet_01v8 ad=0.3864 pd=2.93 as=0.168 ps=1.42 w=1.12 l=0.15
X2980 VDPWR a_12947_26276# a_12934_25972# VDPWR sky130_fd_pr__pfet_01v8_hvt ad=0.0819 pd=0.81 as=0.0567 ps=0.69 w=0.42 l=0.15
X2981 a_6537_25670# a_6319_25428# VGND VGND sky130_fd_pr__nfet_01v8 ad=0.0999 pd=0.985 as=0.1346 ps=1.15 w=0.64 l=0.15
X2982 sar9b_0.clkload0.X a_6907_19444# VGND VGND sky130_fd_pr__nfet_01v8 ad=0.0588 pd=0.7 as=0.0588 ps=0.7 w=0.42 l=0.15
X2983 single_9b_cdac_1.cdac_sw_9b_0.cdac_sw_3_0.nooverlap_clk_0.x8.A single_9b_cdac_1.cdac_sw_9b_0.cdac_sw_3_0.nooverlap_clk_0.x6.A VGND VGND sky130_fd_pr__nfet_01v8_lvt ad=0.2109 pd=2.05 as=0.2627 ps=2.19 w=0.74 l=0.15
X2984 single_9b_cdac_0.cdac_sw_9b_0.S[7] single_9b_cdac_0.cdac_sw_9b_0.cdac_sw_3_7.nooverlap_clk_0.CLKB0 a_29134_26999# VDPWR sky130_fd_pr__pfet_01v8 ad=0.435 pd=3.58 as=0.435 ps=3.58 w=1.5 l=0.5
X2985 a_13403_25428# a_13053_25428# a_13308_25428# VDPWR sky130_fd_pr__pfet_01v8_hvt ad=0.07245 pd=0.765 as=0.0651 ps=0.73 w=0.42 l=0.15
X2986 a_33936_16877# single_9b_cdac_1.SW[6] VDPWR VDPWR sky130_fd_pr__pfet_01v8 ad=0.435 pd=3.58 as=0.435 ps=3.58 w=1.5 l=0.5
X2987 single_9b_cdac_1.cdac_sw_9b_0.cdac_sw_3_1.nooverlap_clk_0.CLKB0 single_9b_cdac_1.cdac_sw_9b_0.cdac_sw_3_1.nooverlap_clk_0.sky130_fd_sc_hs__inv_8_0.A VDPWR VDPWR sky130_fd_pr__pfet_01v8 ad=0.168 pd=1.42 as=0.196 ps=1.47 w=1.12 l=0.15
X2988 VGND a_6701_20506# sar9b_0.clknet_1_0__leaf_CLK VGND sky130_fd_pr__nfet_01v8 ad=0.0588 pd=0.7 as=0.0588 ps=0.7 w=0.42 l=0.15
X2989 single_9b_cdac_1.cdac_sw_9b_0.S[3] single_9b_cdac_1.cdac_sw_9b_0.cdac_sw_3_4.nooverlap_clk_0.CLKB0 a_48343_16877# VDPWR sky130_fd_pr__pfet_01v8 ad=0.435 pd=3.58 as=0.435 ps=3.58 w=1.5 l=0.5
X2990 th_dif_sw_0.VCP single_9b_cdac_1.cdac_sw_9b_0.S[0] sky130_fd_pr__cap_mim_m3_1 l=2 w=2
X2991 th_dif_sw_0.VCN single_9b_cdac_0.cdac_sw_9b_0.S[0] sky130_fd_pr__cap_mim_m3_1 l=2 w=2
X2992 single_9b_cdac_0.SW[4] a_14451_25972# VGND VGND sky130_fd_pr__nfet_01v8 ad=0.1352 pd=1.56 as=0.0754 ps=0.81 w=0.52 l=0.15
X2993 a_13053_25428# a_12887_25428# VGND VGND sky130_fd_pr__nfet_01v8 ad=0.1092 pd=1.36 as=0.0567 ps=0.69 w=0.42 l=0.15
X2994 sar9b_0.clknet_0_CLK a_7345_21594# VGND VGND sky130_fd_pr__nfet_01v8 ad=0.0588 pd=0.7 as=0.0588 ps=0.7 w=0.42 l=0.15
X2995 a_6343_20354# a_6061_19988# a_6249_19988# VDPWR sky130_fd_pr__pfet_01v8_hvt ad=0.06615 pd=0.735 as=0.0672 ps=0.74 w=0.42 l=0.15
X2996 th_dif_sw_0.VCP single_9b_cdac_1.cdac_sw_9b_0.S[0] sky130_fd_pr__cap_mim_m3_1 l=2 w=2
X2997 th_dif_sw_0.VCN single_9b_cdac_0.cdac_sw_9b_0.S[1] sky130_fd_pr__cap_mim_m3_1 l=2 w=2
X2998 VDPWR clk a_14871_9671# VDPWR sky130_fd_pr__pfet_01v8 ad=0.435 pd=3.29 as=0.87 ps=6.58 w=3 l=1
X2999 single_9b_cdac_0.cdac_sw_9b_0.cdac_sw_3_6.nooverlap_clk_0.CLKB0 single_9b_cdac_0.cdac_sw_9b_0.cdac_sw_3_6.nooverlap_clk_0.sky130_fd_sc_hs__inv_8_0.A VGND VGND sky130_fd_pr__nfet_01v8_lvt ad=0.1036 pd=1.02 as=0.1554 ps=1.16 w=0.74 l=0.15
X3000 single_9b_cdac_0.cdac_sw_9b_0.cdac_sw_3_0.nooverlap_clk_0.sky130_fd_sc_hs__inv_8_0.A single_9b_cdac_0.cdac_sw_9b_0.cdac_sw_3_0.nooverlap_clk_0.x1.A VDPWR VDPWR sky130_fd_pr__pfet_01v8 ad=0.168 pd=1.42 as=0.168 ps=1.42 w=1.12 l=0.15
X3001 a_10477_24890# a_10311_24890# VGND VGND sky130_fd_pr__nfet_01v8 ad=0.1092 pd=1.36 as=0.0567 ps=0.69 w=0.42 l=0.15
X3002 VDPWR VGND VDPWR VDPWR sky130_fd_pr__pfet_01v8_hvt ad=0.2262 pd=2.26 as=0 ps=0 w=0.87 l=0.59
X3003 VDPWR VGND VDPWR VDPWR sky130_fd_pr__pfet_01v8_hvt ad=0.2262 pd=2.26 as=0 ps=0 w=0.87 l=0.59
X3004 th_dif_sw_0.VCP single_9b_cdac_1.cdac_sw_9b_0.S[2] sky130_fd_pr__cap_mim_m3_1 l=2 w=2
X3005 th_dif_sw_0.VCN single_9b_cdac_0.cdac_sw_9b_0.S[0] sky130_fd_pr__cap_mim_m3_1 l=2 w=2
X3006 sar9b_0.FINAL a_11935_25402# VDPWR VDPWR sky130_fd_pr__pfet_01v8_hvt ad=0.135 pd=1.27 as=0.3012 ps=2.66 w=1 l=0.15
X3007 single_9b_cdac_1.CF[7] a_14175_23252# VDPWR VDPWR sky130_fd_pr__pfet_01v8_hvt ad=0.2054 pd=2.1 as=0.11455 ps=1.08 w=0.79 l=0.15
X3008 th_dif_sw_0.VCP single_9b_cdac_1.cdac_sw_9b_0.S[0] sky130_fd_pr__cap_mim_m3_1 l=2 w=2
X3009 single_9b_cdac_1.cdac_sw_9b_0.S[1] single_9b_cdac_1.cdac_sw_9b_0.cdac_sw_3_1.tg_sw_3_3.SWP single_9b_cdac_1.cdac_sw_9b_0.S[1] VDPWR sky130_fd_pr__pfet_01v8 ad=0.435 pd=3.58 as=0 ps=0 w=1.5 l=0.5
X3010 th_dif_sw_0.VCP single_9b_cdac_1.cdac_sw_9b_0.S[0] sky130_fd_pr__cap_mim_m3_1 l=2 w=2
X3011 VDPWR single_9b_cdac_0.cdac_sw_9b_0.cdac_sw_3_0.nooverlap_clk_0.x1.A single_9b_cdac_0.cdac_sw_9b_0.cdac_sw_3_0.nooverlap_clk_0.sky130_fd_sc_hs__inv_8_0.A VDPWR sky130_fd_pr__pfet_01v8 ad=0.168 pd=1.42 as=0.168 ps=1.42 w=1.12 l=0.15
X3012 VDPWR VGND VDPWR VDPWR sky130_fd_pr__pfet_01v8_hvt ad=0.2262 pd=2.26 as=0 ps=0 w=0.87 l=0.59
X3013 single_9b_cdac_1.cdac_sw_9b_0.cdac_sw_3_7.nooverlap_clk_0.x4.A single_9b_cdac_1.cdac_sw_9b_0.cdac_sw_3_7.nooverlap_clk_0.x1.A a_30717_15495# VGND sky130_fd_pr__nfet_01v8_lvt ad=0.2109 pd=2.05 as=0.0888 ps=0.98 w=0.74 l=0.15
X3014 sar9b_0._10_ sar9b_0.net3 VDPWR VDPWR sky130_fd_pr__pfet_01v8_hvt ad=0.135 pd=1.27 as=0.26 ps=2.52 w=1 l=0.15
X3015 VDPWR sar9b_0.net3 a_7059_21228# VDPWR sky130_fd_pr__pfet_01v8_hvt ad=0.1176 pd=1.4 as=0.0567 ps=0.69 w=0.42 l=0.15
X3016 th_dif_sw_0.VCP single_9b_cdac_1.cdac_sw_9b_0.S[0] sky130_fd_pr__cap_mim_m3_1 l=2 w=2
X3017 th_dif_sw_0.VCN single_9b_cdac_0.cdac_sw_9b_0.S[1] sky130_fd_pr__cap_mim_m3_1 l=2 w=2
X3018 a_7055_26350# a_6539_25978# a_6960_26338# VGND sky130_fd_pr__special_nfet_01v8 ad=0.0594 pd=0.69 as=0.066 ps=0.745 w=0.36 l=0.15
X3019 single_9b_cdac_0.cdac_sw_9b_0.cdac_sw_3_0.nooverlap_clk_0.sky130_fd_sc_hs__inv_8_0.A single_9b_cdac_0.cdac_sw_9b_0.cdac_sw_3_0.nooverlap_clk_0.x1.A VDPWR VDPWR sky130_fd_pr__pfet_01v8 ad=0.168 pd=1.42 as=0.3304 ps=2.83 w=1.12 l=0.15
X3020 a_6381_22164# sar9b_0._13_ VGND VGND sky130_fd_pr__nfet_01v8 ad=0.0441 pd=0.63 as=0.13165 ps=1.14 w=0.42 l=0.15
X3021 single_9b_cdac_1.cdac_sw_9b_0.cdac_sw_3_4.nooverlap_clk_0.x6.A single_9b_cdac_1.cdac_sw_9b_0.cdac_sw_3_4.nooverlap_clk_0.x4.A VDPWR VDPWR sky130_fd_pr__pfet_01v8 ad=0.3304 pd=2.83 as=0.3864 ps=2.93 w=1.12 l=0.15
X3022 VDPWR a_6701_20506# sar9b_0.clknet_1_0__leaf_CLK VDPWR sky130_fd_pr__pfet_01v8_hvt ad=0.14 pd=1.28 as=0.14 ps=1.28 w=1 l=0.15
X3023 th_dif_sw_0.VCP single_9b_cdac_1.cdac_sw_9b_0.S[0] sky130_fd_pr__cap_mim_m3_1 l=2 w=2
X3024 th_dif_sw_0.VCN single_9b_cdac_0.cdac_sw_9b_0.S[2] sky130_fd_pr__cap_mim_m3_1 l=2 w=2
X3025 sar9b_0.net22 a_9635_26276# VGND VGND sky130_fd_pr__nfet_01v8 ad=0.169 pd=1.82 as=0.2087 ps=2.02 w=0.65 l=0.15
X3026 a_10081_18900# sar9b_0.net15 VGND VGND sky130_fd_pr__nfet_01v8 ad=0.0441 pd=0.63 as=0.1346 ps=1.15 w=0.42 l=0.15
X3027 single_9b_cdac_0.cdac_sw_9b_0.cdac_sw_3_6.tg_sw_3_3.SWP single_9b_cdac_0.cdac_sw_9b_0.cdac_sw_3_6.tg_sw_3_3.SWN VGND VGND sky130_fd_pr__nfet_01v8_lvt ad=0.1036 pd=1.02 as=0.1036 ps=1.02 w=0.74 l=0.15
X3028 VGND single_9b_cdac_0.cdac_sw_9b_0.cdac_sw_3_0.tg_sw_3_3.SWN single_9b_cdac_0.cdac_sw_9b_0.cdac_sw_3_0.tg_sw_3_3.SWP VGND sky130_fd_pr__nfet_01v8_lvt ad=0.2109 pd=2.05 as=0.1036 ps=1.02 w=0.74 l=0.15
X3029 sar9b_0._11_ sar9b_0.net3 VDPWR VDPWR sky130_fd_pr__pfet_01v8_hvt ad=0.174 pd=1.39 as=0.182 ps=1.92 w=0.7 l=0.15
X3030 VDPWR single_9b_cdac_1.cdac_sw_9b_0.cdac_sw_3_8.nooverlap_clk_0.x1.A single_9b_cdac_1.cdac_sw_9b_0.cdac_sw_3_8.nooverlap_clk_0.x4.A VDPWR sky130_fd_pr__pfet_01v8 ad=0.3192 pd=2.81 as=0.168 ps=1.42 w=1.12 l=0.15
X3031 single_9b_cdac_0.cdac_sw_9b_0.S[6] single_9b_cdac_0.cdac_sw_9b_0.cdac_sw_3_6.tg_sw_3_3.SWN ua[0] VDPWR sky130_fd_pr__pfet_01v8 ad=0.435 pd=3.58 as=0.435 ps=3.58 w=1.5 l=0.5
X3032 single_9b_cdac_0.cdac_sw_9b_0.S[7] single_9b_cdac_0.cdac_sw_9b_0.cdac_sw_3_7.tg_sw_3_3.SWN single_9b_cdac_0.cdac_sw_9b_0.S[7] VGND sky130_fd_pr__nfet_01v8 ad=0.145 pd=1.58 as=0 ps=0 w=0.5 l=0.5
X3033 VGND single_9b_cdac_1.SW[3] a_49221_17740# VGND sky130_fd_pr__nfet_01v8 ad=0.145 pd=1.58 as=0.145 ps=1.58 w=0.5 l=0.5
X3034 th_dif_sw_0.VCP single_9b_cdac_1.cdac_sw_9b_0.S[2] sky130_fd_pr__cap_mim_m3_1 l=2 w=2
X3035 single_9b_cdac_0.cdac_sw_9b_0.S[6] single_9b_cdac_0.cdac_sw_9b_0.cdac_sw_3_6.tg_sw_3_3.SWP single_9b_cdac_0.cdac_sw_9b_0.S[6] VDPWR sky130_fd_pr__pfet_01v8 ad=0.435 pd=3.58 as=0 ps=0 w=1.5 l=0.5
X3036 a_5793_21326# sar9b_0.net16 VDPWR VDPWR sky130_fd_pr__pfet_01v8_hvt ad=0.1525 pd=1.305 as=0.26 ps=2.52 w=1 l=0.15
X3037 single_9b_cdac_1.cdac_sw_9b_0.cdac_sw_3_8.nooverlap_clk_0.x4.A single_9b_cdac_1.cdac_sw_9b_0.cdac_sw_3_8.nooverlap_clk_0.x3.Y VDPWR VDPWR sky130_fd_pr__pfet_01v8 ad=0.168 pd=1.42 as=0.3192 ps=2.81 w=1.12 l=0.15
X3038 single_9b_cdac_1.cdac_sw_9b_0.cdac_sw_3_5.nooverlap_clk_0.CLK0 single_9b_cdac_1.cdac_sw_9b_0.cdac_sw_3_5.nooverlap_clk_0.CLKB0 VGND VGND sky130_fd_pr__nfet_01v8_lvt ad=0.1036 pd=1.02 as=0.1295 ps=1.09 w=0.74 l=0.15
X3039 th_dif_sw_0.VCN single_9b_cdac_0.cdac_sw_9b_0.S[0] sky130_fd_pr__cap_mim_m3_1 l=2 w=2
X3040 th_dif_sw_0.VCN single_9b_cdac_0.cdac_sw_9b_0.S[1] sky130_fd_pr__cap_mim_m3_1 l=2 w=2
X3041 VGND single_9b_cdac_0.cdac_sw_9b_0.cdac_sw_3_5.nooverlap_clk_0.x6.A single_9b_cdac_0.cdac_sw_9b_0.cdac_sw_3_5.nooverlap_clk_0.x8.A VGND sky130_fd_pr__nfet_01v8_lvt ad=0.2627 pd=2.19 as=0.2109 ps=2.05 w=0.74 l=0.15
X3042 a_57946_26999# single_9b_cdac_0.SW[1] VDPWR VDPWR sky130_fd_pr__pfet_01v8 ad=0.435 pd=3.58 as=0.435 ps=3.58 w=1.5 l=0.5
X3043 VGND sar9b_0.net41 a_14175_20532# VGND sky130_fd_pr__nfet_01v8 ad=0.0754 pd=0.81 as=0.1352 ps=1.56 w=0.52 l=0.15
X3044 single_9b_cdac_1.cdac_sw_9b_0.S[8] single_9b_cdac_1.cdac_sw_9b_0.cdac_sw_3_8.nooverlap_clk_0.CLKB0 a_24332_16877# VDPWR sky130_fd_pr__pfet_01v8 ad=0.435 pd=3.58 as=0.435 ps=3.58 w=1.5 l=0.5
X3045 th_dif_sw_0.VCN single_9b_cdac_0.cdac_sw_9b_0.S[0] sky130_fd_pr__cap_mim_m3_1 l=2 w=2
X3046 th_dif_sw_0.VCP single_9b_cdac_1.cdac_sw_9b_0.S[1] sky130_fd_pr__cap_mim_m3_1 l=2 w=2
X3047 th_dif_sw_0.VCP single_9b_cdac_1.cdac_sw_9b_0.S[1] sky130_fd_pr__cap_mim_m3_1 l=2 w=2
X3048 VGND a_7345_21594# sar9b_0.clknet_0_CLK VGND sky130_fd_pr__nfet_01v8 ad=0.0588 pd=0.7 as=0.0588 ps=0.7 w=0.42 l=0.15
X3049 th_dif_sw_0.VCP single_9b_cdac_1.cdac_sw_9b_0.S[0] sky130_fd_pr__cap_mim_m3_1 l=2 w=2
X3050 th_dif_sw_0.VCN single_9b_cdac_0.cdac_sw_9b_0.S[2] sky130_fd_pr__cap_mim_m3_1 l=2 w=2
X3051 VGND a_7345_21594# sar9b_0.clknet_0_CLK VGND sky130_fd_pr__nfet_01v8 ad=0.0588 pd=0.7 as=0.0588 ps=0.7 w=0.42 l=0.15
X3052 th_dif_sw_0.VCN single_9b_cdac_0.cdac_sw_9b_0.S[2] sky130_fd_pr__cap_mim_m3_1 l=2 w=2
X3053 VDPWR single_9b_cdac_0.cdac_sw_9b_0.cdac_sw_3_4.nooverlap_clk_0.sky130_fd_sc_hs__inv_8_0.A single_9b_cdac_0.cdac_sw_9b_0.cdac_sw_3_4.nooverlap_clk_0.CLKB0 VDPWR sky130_fd_pr__pfet_01v8 ad=0.196 pd=1.47 as=0.168 ps=1.42 w=1.12 l=0.15
X3054 VDPWR VGND VDPWR VDPWR sky130_fd_pr__pfet_01v8_hvt ad=0.2262 pd=2.26 as=0 ps=0 w=0.87 l=0.59
X3055 a_29134_16877# single_9b_cdac_1.SW[7] VDPWR VDPWR sky130_fd_pr__pfet_01v8 ad=0.435 pd=3.58 as=0.435 ps=3.58 w=1.5 l=0.5
X3056 th_dif_sw_0.VCP single_9b_cdac_1.cdac_sw_9b_0.S[0] sky130_fd_pr__cap_mim_m3_1 l=2 w=2
X3057 th_dif_sw_0.VCP single_9b_cdac_1.cdac_sw_9b_0.S[2] sky130_fd_pr__cap_mim_m3_1 l=2 w=2
X3058 dw_17224_1400# a_21368_4076# sky130_fd_pr__cap_mim_m3_1 l=2 w=2
X3059 th_dif_sw_0.VCP single_9b_cdac_1.cdac_sw_9b_0.S[0] sky130_fd_pr__cap_mim_m3_1 l=2 w=2
X3060 th_dif_sw_0.VCP single_9b_cdac_1.cdac_sw_9b_0.S[1] sky130_fd_pr__cap_mim_m3_1 l=2 w=2
X3061 a_10358_26882# a_9281_26516# a_10196_26516# VDPWR sky130_fd_pr__pfet_01v8_hvt ad=0.0567 pd=0.69 as=0.0588 ps=0.7 w=0.42 l=0.15
X3062 single_9b_cdac_0.cdac_sw_9b_0.cdac_sw_3_8.nooverlap_clk_0.CLKB0 single_9b_cdac_0.cdac_sw_9b_0.cdac_sw_3_8.nooverlap_clk_0.sky130_fd_sc_hs__inv_8_0.A VGND VGND sky130_fd_pr__nfet_01v8_lvt ad=0.1036 pd=1.02 as=0.1295 ps=1.09 w=0.74 l=0.15
X3063 a_6319_25428# a_5969_25428# a_6224_25428# VDPWR sky130_fd_pr__pfet_01v8_hvt ad=0.07245 pd=0.765 as=0.0651 ps=0.73 w=0.42 l=0.15
X3064 a_12009_20898# a_11965_20506# a_11843_20910# VGND sky130_fd_pr__nfet_01v8 ad=0.0441 pd=0.63 as=0.1401 ps=1.1 w=0.42 l=0.15
X3065 a_11121_18900# a_10955_18900# VGND VGND sky130_fd_pr__nfet_01v8 ad=0.1092 pd=1.36 as=0.0567 ps=0.69 w=0.42 l=0.15
X3066 VGND single_9b_cdac_1.SW[5] a_39616_17740# VGND sky130_fd_pr__nfet_01v8 ad=0.145 pd=1.58 as=0.145 ps=1.58 w=0.5 l=0.5
X3067 th_dif_sw_0.VCN single_9b_cdac_0.cdac_sw_9b_0.S[0] sky130_fd_pr__cap_mim_m3_1 l=2 w=2
X3068 single_9b_cdac_1.cdac_sw_9b_0.cdac_sw_3_2.tg_sw_3_3.SWP single_9b_cdac_1.cdac_sw_9b_0.cdac_sw_3_2.tg_sw_3_3.SWN VGND VGND sky130_fd_pr__nfet_01v8_lvt ad=0.1036 pd=1.02 as=0.1554 ps=1.16 w=0.74 l=0.15
X3069 VDPWR single_9b_cdac_1.cdac_sw_9b_0.cdac_sw_3_2.tg_sw_3_3.SWN single_9b_cdac_1.cdac_sw_9b_0.cdac_sw_3_2.tg_sw_3_3.SWP VDPWR sky130_fd_pr__pfet_01v8 ad=0.3864 pd=2.93 as=0.168 ps=1.42 w=1.12 l=0.15
X3070 single_9b_cdac_0.cdac_sw_9b_0.cdac_sw_3_4.nooverlap_clk_0.CLKB0 single_9b_cdac_0.cdac_sw_9b_0.cdac_sw_3_4.nooverlap_clk_0.sky130_fd_sc_hs__inv_8_0.A VDPWR VDPWR sky130_fd_pr__pfet_01v8 ad=0.168 pd=1.42 as=0.168 ps=1.42 w=1.12 l=0.15
X3071 ua[0] single_9b_cdac_0.cdac_sw_9b_0.cdac_sw_3_1.tg_sw_3_3.SWP ua[0] VDPWR sky130_fd_pr__pfet_01v8 ad=0.435 pd=3.58 as=0 ps=0 w=1.5 l=0.5
X3072 th_dif_sw_0.VCP single_9b_cdac_1.cdac_sw_9b_0.S[0] sky130_fd_pr__cap_mim_m3_1 l=2 w=2
X3073 VGND VDPWR VGND VGND sky130_fd_pr__nfet_01v8 ad=0.143 pd=1.62 as=0 ps=0 w=0.55 l=0.59
X3074 ua[0] single_9b_cdac_1.cdac_sw_9b_0.cdac_sw_3_1.tg_sw_3_3.SWN ua[0] VGND sky130_fd_pr__nfet_01v8 ad=0.145 pd=1.58 as=0 ps=0 w=0.5 l=0.5
X3075 th_dif_sw_0.VCP single_9b_cdac_1.cdac_sw_9b_0.S[0] sky130_fd_pr__cap_mim_m3_1 l=2 w=2
X3076 VDPWR single_9b_cdac_1.cdac_sw_9b_0.cdac_sw_3_2.nooverlap_clk_0.CLKB0 single_9b_cdac_1.cdac_sw_9b_0.cdac_sw_3_2.nooverlap_clk_0.CLK0 VDPWR sky130_fd_pr__pfet_01v8 ad=0.196 pd=1.47 as=0.168 ps=1.42 w=1.12 l=0.15
X3077 single_9b_cdac_1.cdac_sw_9b_0.cdac_sw_3_2.tg_sw_3_3.SWP single_9b_cdac_1.cdac_sw_9b_0.cdac_sw_3_2.tg_sw_3_3.SWN VDPWR VDPWR sky130_fd_pr__pfet_01v8 ad=0.168 pd=1.42 as=0.196 ps=1.47 w=1.12 l=0.15
X3078 VDPWR single_9b_cdac_0.cdac_sw_9b_0.cdac_sw_3_4.nooverlap_clk_0.sky130_fd_sc_hs__inv_8_0.A single_9b_cdac_0.cdac_sw_9b_0.cdac_sw_3_4.nooverlap_clk_0.CLKB0 VDPWR sky130_fd_pr__pfet_01v8 ad=0.168 pd=1.42 as=0.168 ps=1.42 w=1.12 l=0.15
X3079 a_6679_22316# sar9b_0.clk_div_0.COUNT\[0\] VGND VGND sky130_fd_pr__nfet_01v8 ad=0.0567 pd=0.69 as=0.10187 ps=0.99 w=0.42 l=0.15
X3080 VGND single_9b_cdac_1.cdac_sw_9b_0.cdac_sw_3_8.nooverlap_clk_0.CLKB0 single_9b_cdac_1.cdac_sw_9b_0.cdac_sw_3_8.nooverlap_clk_0.CLK0 VGND sky130_fd_pr__nfet_01v8_lvt ad=0.1036 pd=1.02 as=0.1036 ps=1.02 w=0.74 l=0.15
X3081 th_dif_sw_0.VCN single_9b_cdac_0.cdac_sw_9b_0.S[2] sky130_fd_pr__cap_mim_m3_1 l=2 w=2
X3082 VGND single_9b_cdac_0.cdac_sw_9b_0.cdac_sw_3_1.nooverlap_clk_0.x8.A single_9b_cdac_0.cdac_sw_9b_0.cdac_sw_3_1.nooverlap_clk_0.x10.A VGND sky130_fd_pr__nfet_01v8_lvt ad=0.2331 pd=2.11 as=0.1184 ps=1.06 w=0.74 l=0.15
X3083 a_8910_20532# a_8637_20538# a_8825_20532# VDPWR sky130_fd_pr__pfet_01v8_hvt ad=0.06825 pd=0.745 as=0.05775 ps=0.695 w=0.42 l=0.15
X3084 a_26951_15501# single_9b_cdac_1.CF[8] single_9b_cdac_1.cdac_sw_9b_0.cdac_sw_3_8.nooverlap_clk_0.sky130_fd_sc_hs__nand2_1_0.Y VGND sky130_fd_pr__nfet_01v8_lvt ad=0.0888 pd=0.98 as=0.2109 ps=2.05 w=0.74 l=0.15
X3085 ua[0] single_9b_cdac_0.cdac_sw_9b_0.cdac_sw_3_1.tg_sw_3_3.SWN ua[0] VGND sky130_fd_pr__nfet_01v8 ad=0.145 pd=1.58 as=0 ps=0 w=0.5 l=0.5
X3086 VGND VDPWR VGND VGND sky130_fd_pr__nfet_01v8 ad=0.143 pd=1.62 as=0 ps=0 w=0.55 l=0.59
X3087 VDPWR VGND VDPWR VDPWR sky130_fd_pr__pfet_01v8_hvt ad=0.2262 pd=2.26 as=0 ps=0 w=0.87 l=0.59
X3088 single_9b_cdac_1.cdac_sw_9b_0.cdac_sw_3_2.nooverlap_clk_0.CLK0 single_9b_cdac_1.cdac_sw_9b_0.cdac_sw_3_2.nooverlap_clk_0.CLKB0 VDPWR VDPWR sky130_fd_pr__pfet_01v8 ad=0.168 pd=1.42 as=0.3304 ps=2.83 w=1.12 l=0.15
X3089 VDPWR a_6149_23770# sar9b_0.clknet_1_1__leaf_CLK VDPWR sky130_fd_pr__pfet_01v8_hvt ad=0.14 pd=1.28 as=0.14 ps=1.28 w=1 l=0.15
X3090 ua[0] single_9b_cdac_1.cdac_sw_9b_0.cdac_sw_3_6.tg_sw_3_3.SWN ua[0] VGND sky130_fd_pr__nfet_01v8 ad=0.145 pd=1.58 as=0 ps=0 w=0.5 l=0.5
X3091 th_dif_sw_0.VCP single_9b_cdac_1.cdac_sw_9b_0.S[0] sky130_fd_pr__cap_mim_m3_1 l=2 w=2
X3092 th_dif_sw_0.VCP single_9b_cdac_1.cdac_sw_9b_0.S[2] sky130_fd_pr__cap_mim_m3_1 l=2 w=2
X3093 a_10254_2858# th_dif_sw_0.th_sw_1.CKB VDPWR VDPWR sky130_fd_pr__pfet_01v8 ad=0.2175 pd=2.08 as=0.2175 ps=2.08 w=0.75 l=0.15
X3094 a_7161_23086# a_6171_22714# a_7035_22708# VGND sky130_fd_pr__special_nfet_01v8 ad=0.066 pd=0.745 as=0.0684 ps=0.74 w=0.36 l=0.15
X3095 th_dif_sw_0.VCN single_9b_cdac_0.cdac_sw_9b_0.S[1] sky130_fd_pr__cap_mim_m3_1 l=2 w=2
X3096 VGND single_9b_cdac_0.cdac_sw_9b_0.cdac_sw_3_7.nooverlap_clk_0.x10.A single_9b_cdac_0.cdac_sw_9b_0.cdac_sw_3_7.tg_sw_3_3.SWN VGND sky130_fd_pr__nfet_01v8_lvt ad=0.1295 pd=1.09 as=0.1036 ps=1.02 w=0.74 l=0.15
X3097 ua[0] single_9b_cdac_0.cdac_sw_9b_0.cdac_sw_3_6.tg_sw_3_3.SWN ua[0] VGND sky130_fd_pr__nfet_01v8 ad=0.145 pd=1.58 as=0 ps=0 w=0.5 l=0.5
X3098 VGND single_9b_cdac_1.cdac_sw_9b_0.cdac_sw_3_8.nooverlap_clk_0.x8.A single_9b_cdac_1.cdac_sw_9b_0.cdac_sw_3_8.nooverlap_clk_0.x10.A VGND sky130_fd_pr__nfet_01v8_lvt ad=0.2109 pd=2.05 as=0.1036 ps=1.02 w=0.74 l=0.15
X3099 VDPWR a_9132_7271# th_dif_sw_0.th_sw_1.CK VDPWR sky130_fd_pr__pfet_01v8 ad=0.168 pd=1.42 as=0.168 ps=1.42 w=1.12 l=0.15
X3100 VGND sar9b_0._12_ a_7813_22316# VGND sky130_fd_pr__nfet_01v8 ad=0.1092 pd=1.36 as=0.0567 ps=0.69 w=0.42 l=0.15
X3101 th_dif_sw_0.VCP single_9b_cdac_1.cdac_sw_9b_0.S[1] sky130_fd_pr__cap_mim_m3_1 l=2 w=2
X3102 VDPWR single_9b_cdac_0.cdac_sw_9b_0.cdac_sw_3_0.nooverlap_clk_0.x3.Y single_9b_cdac_0.cdac_sw_9b_0.cdac_sw_3_0.nooverlap_clk_0.x4.A VDPWR sky130_fd_pr__pfet_01v8 ad=0.3192 pd=2.81 as=0.168 ps=1.42 w=1.12 l=0.15
X3103 single_9b_cdac_0.cdac_sw_9b_0.S[1] single_9b_cdac_0.cdac_sw_9b_0.cdac_sw_3_1.tg_sw_3_3.SWN single_9b_cdac_0.cdac_sw_9b_0.S[1] VGND sky130_fd_pr__nfet_01v8 ad=0.145 pd=1.58 as=0 ps=0 w=0.5 l=0.5
X3104 a_10923_25262# a_10477_24890# a_10827_25262# VGND sky130_fd_pr__special_nfet_01v8 ad=0.1401 pd=1.1 as=0.0594 ps=0.69 w=0.36 l=0.15
X3105 th_dif_sw_0.VCN single_9b_cdac_0.cdac_sw_9b_0.S[0] sky130_fd_pr__cap_mim_m3_1 l=2 w=2
X3106 VGND VDPWR VGND VGND sky130_fd_pr__nfet_01v8 ad=0.143 pd=1.62 as=0 ps=0 w=0.55 l=0.59
X3107 single_9b_cdac_1.cdac_sw_9b_0.S[0] single_9b_cdac_1.cdac_sw_9b_0.cdac_sw_3_2.tg_sw_3_3.SWN single_9b_cdac_1.cdac_sw_9b_0.S[0] VGND sky130_fd_pr__nfet_01v8 ad=0.145 pd=1.58 as=0 ps=0 w=0.5 l=0.5
X3108 single_9b_cdac_0.cdac_sw_9b_0.cdac_sw_3_0.nooverlap_clk_0.x4.A single_9b_cdac_0.cdac_sw_9b_0.cdac_sw_3_0.nooverlap_clk_0.x1.A VDPWR VDPWR sky130_fd_pr__pfet_01v8 ad=0.168 pd=1.42 as=0.3192 ps=2.81 w=1.12 l=0.15
X3109 single_9b_cdac_1.CF[3] a_14175_21620# VDPWR VDPWR sky130_fd_pr__pfet_01v8_hvt ad=0.2054 pd=2.1 as=0.11455 ps=1.08 w=0.79 l=0.15
X3110 VGND single_9b_cdac_1.cdac_sw_9b_0.cdac_sw_3_8.nooverlap_clk_0.x10.A single_9b_cdac_1.cdac_sw_9b_0.cdac_sw_3_8.tg_sw_3_3.SWN VGND sky130_fd_pr__nfet_01v8_lvt ad=0.1554 pd=1.16 as=0.1036 ps=1.02 w=0.74 l=0.15
X3111 single_9b_cdac_1.cdac_sw_9b_0.cdac_sw_3_7.nooverlap_clk_0.CLK0 single_9b_cdac_1.cdac_sw_9b_0.cdac_sw_3_7.nooverlap_clk_0.CLKB0 VGND VGND sky130_fd_pr__nfet_01v8_lvt ad=0.1036 pd=1.02 as=0.1554 ps=1.16 w=0.74 l=0.15
X3112 single_9b_cdac_1.cdac_sw_9b_0.S[7] single_9b_cdac_1.cdac_sw_9b_0.cdac_sw_3_7.tg_sw_3_3.SWN single_9b_cdac_1.cdac_sw_9b_0.S[7] VGND sky130_fd_pr__nfet_01v8 ad=0.145 pd=1.58 as=0 ps=0 w=0.5 l=0.5
X3113 th_dif_sw_0.VCN single_9b_cdac_0.cdac_sw_9b_0.S[0] sky130_fd_pr__cap_mim_m3_1 l=2 w=2
X3114 th_dif_sw_0.VCP single_9b_cdac_1.cdac_sw_9b_0.S[3] sky130_fd_pr__cap_mim_m3_1 l=2 w=2
X3115 th_dif_sw_0.VCP single_9b_cdac_1.cdac_sw_9b_0.S[5] sky130_fd_pr__cap_mim_m3_1 l=2 w=2
X3116 th_dif_sw_0.VCN single_9b_cdac_0.cdac_sw_9b_0.S[1] sky130_fd_pr__cap_mim_m3_1 l=2 w=2
X3117 single_9b_cdac_0.cdac_sw_9b_0.cdac_sw_3_1.nooverlap_clk_0.CLK0 single_9b_cdac_0.cdac_sw_9b_0.cdac_sw_3_1.nooverlap_clk_0.CLKB0 VGND VGND sky130_fd_pr__nfet_01v8_lvt ad=0.1036 pd=1.02 as=0.2146 ps=2.06 w=0.74 l=0.15
X3118 th_dif_sw_0.VCP single_9b_cdac_1.cdac_sw_9b_0.S[1] sky130_fd_pr__cap_mim_m3_1 l=2 w=2
X3119 a_11579_26882# a_10955_26516# a_11471_26516# VDPWR sky130_fd_pr__pfet_01v8_hvt ad=0.1155 pd=0.97 as=0.07245 ps=0.765 w=0.42 l=0.15
X3120 single_9b_cdac_0.cdac_sw_9b_0.S[7] single_9b_cdac_0.cdac_sw_9b_0.cdac_sw_3_7.nooverlap_clk_0.CLKB0 a_29134_26999# VDPWR sky130_fd_pr__pfet_01v8 ad=0.435 pd=3.58 as=0.435 ps=3.58 w=1.5 l=0.5
X3121 VDPWR a_13968_25428# a_14143_25402# VDPWR sky130_fd_pr__pfet_01v8_hvt ad=0.1134 pd=1.38 as=0.0567 ps=0.69 w=0.42 l=0.15
X3122 sar9b_0.net7 a_12211_18874# VGND VGND sky130_fd_pr__nfet_01v8 ad=0.169 pd=1.82 as=0.2087 ps=2.02 w=0.65 l=0.15
X3123 ua[0] single_9b_cdac_1.cdac_sw_9b_0.cdac_sw_3_8.tg_sw_3_3.SWN ua[0] VGND sky130_fd_pr__nfet_01v8 ad=0.145 pd=1.58 as=0 ps=0 w=0.5 l=0.5
X3124 single_9b_cdac_1.cdac_sw_9b_0.cdac_sw_3_7.tg_sw_3_3.SWN single_9b_cdac_1.cdac_sw_9b_0.cdac_sw_3_7.nooverlap_clk_0.x10.A VGND VGND sky130_fd_pr__nfet_01v8_lvt ad=0.1036 pd=1.02 as=0.2109 ps=2.05 w=0.74 l=0.15
X3125 single_9b_cdac_1.cdac_sw_9b_0.S[2] single_9b_cdac_1.cdac_sw_9b_0.cdac_sw_3_0.tg_sw_3_3.SWN ua[0] VDPWR sky130_fd_pr__pfet_01v8 ad=0.435 pd=3.58 as=0.435 ps=3.58 w=1.5 l=0.5
X3126 a_10254_2858# th_dif_sw_0.th_sw_1.CKB a_10166_3438# VGND sky130_fd_pr__nfet_01v8 ad=0.145 pd=1.58 as=0.145 ps=1.58 w=0.5 l=0.15
X3127 VDPWR single_9b_cdac_0.cdac_sw_9b_0.cdac_sw_3_6.nooverlap_clk_0.CLKB0 single_9b_cdac_0.cdac_sw_9b_0.cdac_sw_3_6.nooverlap_clk_0.CLK0 VDPWR sky130_fd_pr__pfet_01v8 ad=0.196 pd=1.47 as=0.168 ps=1.42 w=1.12 l=0.15
X3128 single_9b_cdac_0.cdac_sw_9b_0.S[0] single_9b_cdac_0.cdac_sw_9b_0.cdac_sw_3_2.tg_sw_3_3.SWP ua[0] VGND sky130_fd_pr__nfet_01v8 ad=0.145 pd=1.58 as=0.145 ps=1.58 w=0.5 l=0.5
X3129 a_8951_22950# sar9b_0.net4 VGND VGND sky130_fd_pr__nfet_01v8 ad=0.1092 pd=1.36 as=0.0567 ps=0.69 w=0.42 l=0.15
X3130 VGND VDPWR VGND VGND sky130_fd_pr__nfet_01v8 ad=0.143 pd=1.62 as=0 ps=0 w=0.55 l=0.59
X3131 a_33936_16877# single_9b_cdac_1.SW[6] VDPWR VDPWR sky130_fd_pr__pfet_01v8 ad=0.435 pd=3.58 as=0.435 ps=3.58 w=1.5 l=0.5
X3132 th_dif_sw_0.VCP single_9b_cdac_1.cdac_sw_9b_0.S[3] sky130_fd_pr__cap_mim_m3_1 l=2 w=2
X3133 th_dif_sw_0.VCN single_9b_cdac_0.cdac_sw_9b_0.S[2] sky130_fd_pr__cap_mim_m3_1 l=2 w=2
X3134 VGND sar9b_0.net29 a_14451_24340# VGND sky130_fd_pr__nfet_01v8 ad=0.0754 pd=0.81 as=0.1352 ps=1.56 w=0.52 l=0.15
X3135 th_dif_sw_0.VCP single_9b_cdac_1.cdac_sw_9b_0.S[2] sky130_fd_pr__cap_mim_m3_1 l=2 w=2
X3136 a_8340_27426# sar9b_0.net39 VDPWR VDPWR sky130_fd_pr__pfet_01v8_hvt ad=0.0651 pd=0.73 as=0.1092 ps=1.36 w=0.42 l=0.15
X3137 VGND single_9b_cdac_0.cdac_sw_9b_0.cdac_sw_3_0.tg_sw_3_3.SWN single_9b_cdac_0.cdac_sw_9b_0.cdac_sw_3_0.tg_sw_3_3.SWP VGND sky130_fd_pr__nfet_01v8_lvt ad=0.1036 pd=1.02 as=0.1036 ps=1.02 w=0.74 l=0.15
X3138 VDPWR single_9b_cdac_1.cdac_sw_9b_0.cdac_sw_3_7.nooverlap_clk_0.sky130_fd_sc_hs__inv_8_0.A single_9b_cdac_1.cdac_sw_9b_0.cdac_sw_3_7.nooverlap_clk_0.CLKB0 VDPWR sky130_fd_pr__pfet_01v8 ad=0.3864 pd=2.93 as=0.168 ps=1.42 w=1.12 l=0.15
X3139 single_9b_cdac_0.cdac_sw_9b_0.cdac_sw_3_6.nooverlap_clk_0.CLK0 single_9b_cdac_0.cdac_sw_9b_0.cdac_sw_3_6.nooverlap_clk_0.CLKB0 VDPWR VDPWR sky130_fd_pr__pfet_01v8 ad=0.168 pd=1.42 as=0.168 ps=1.42 w=1.12 l=0.15
X3140 VDPWR single_9b_cdac_0.cdac_sw_9b_0.cdac_sw_3_3.nooverlap_clk_0.x1.A single_9b_cdac_0.cdac_sw_9b_0.cdac_sw_3_3.nooverlap_clk_0.sky130_fd_sc_hs__inv_8_0.A VDPWR sky130_fd_pr__pfet_01v8 ad=0.3304 pd=2.83 as=0.168 ps=1.42 w=1.12 l=0.15
X3141 a_10774_20354# a_10055_20130# a_10211_20225# VGND sky130_fd_pr__special_nfet_01v8 ad=0.066 pd=0.745 as=0.0594 ps=0.69 w=0.36 l=0.15
X3142 sar9b_0.clknet_1_1__leaf_CLK a_6149_23770# VDPWR VDPWR sky130_fd_pr__pfet_01v8_hvt ad=0.14 pd=1.28 as=0.14 ps=1.28 w=1 l=0.15
X3143 single_9b_cdac_1.cdac_sw_9b_0.cdac_sw_3_7.nooverlap_clk_0.CLKB0 single_9b_cdac_1.cdac_sw_9b_0.cdac_sw_3_7.nooverlap_clk_0.sky130_fd_sc_hs__inv_8_0.A VDPWR VDPWR sky130_fd_pr__pfet_01v8 ad=0.168 pd=1.42 as=0.196 ps=1.47 w=1.12 l=0.15
X3144 th_dif_sw_0.VCP single_9b_cdac_1.cdac_sw_9b_0.S[0] sky130_fd_pr__cap_mim_m3_1 l=2 w=2
X3145 sar9b_0._05_ a_7735_21076# VDPWR VDPWR sky130_fd_pr__pfet_01v8_hvt ad=0.26 pd=2.52 as=0.14222 ps=1.335 w=1 l=0.15
X3146 th_dif_sw_0.VCN single_9b_cdac_0.cdac_sw_9b_0.S[0] sky130_fd_pr__cap_mim_m3_1 l=2 w=2
X3147 VDPWR single_9b_cdac_0.cdac_sw_9b_0.cdac_sw_3_6.nooverlap_clk_0.CLKB0 single_9b_cdac_0.cdac_sw_9b_0.cdac_sw_3_6.nooverlap_clk_0.CLK0 VDPWR sky130_fd_pr__pfet_01v8 ad=0.168 pd=1.42 as=0.168 ps=1.42 w=1.12 l=0.15
X3148 VGND VDPWR VGND VGND sky130_fd_pr__nfet_01v8 ad=0.143 pd=1.62 as=0 ps=0 w=0.55 l=0.59
X3149 a_13665_23074# a_13621_22682# a_13499_23086# VGND sky130_fd_pr__nfet_01v8 ad=0.0441 pd=0.63 as=0.1401 ps=1.1 w=0.42 l=0.15
X3150 VDPWR a_10187_22138# a_10174_22530# VDPWR sky130_fd_pr__pfet_01v8_hvt ad=0.0819 pd=0.81 as=0.0567 ps=0.69 w=0.42 l=0.15
X3151 single_9b_cdac_1.cdac_sw_9b_0.cdac_sw_3_3.tg_sw_3_3.SWP single_9b_cdac_1.cdac_sw_9b_0.cdac_sw_3_3.tg_sw_3_3.SWN VGND VGND sky130_fd_pr__nfet_01v8_lvt ad=0.1036 pd=1.02 as=0.1295 ps=1.09 w=0.74 l=0.15
X3152 VDPWR single_9b_cdac_0.cdac_sw_9b_0.cdac_sw_3_5.nooverlap_clk_0.x10.A single_9b_cdac_0.cdac_sw_9b_0.cdac_sw_3_5.tg_sw_3_3.SWN VDPWR sky130_fd_pr__pfet_01v8 ad=0.196 pd=1.47 as=0.168 ps=1.42 w=1.12 l=0.15
X3153 a_8800_24340# sar9b_0.net11 VDPWR VDPWR sky130_fd_pr__pfet_01v8_hvt ad=0.0651 pd=0.73 as=0.1092 ps=1.36 w=0.42 l=0.15
X3154 a_11397_20538# a_11231_20538# VDPWR VDPWR sky130_fd_pr__pfet_01v8_hvt ad=0.1664 pd=1.8 as=0.0864 ps=0.91 w=0.64 l=0.15
X3155 VDPWR sar9b_0.net39 a_13623_20532# VDPWR sky130_fd_pr__pfet_01v8_hvt ad=0.11455 pd=1.08 as=0.2054 ps=2.1 w=0.79 l=0.15
X3156 th_dif_sw_0.VCP single_9b_cdac_1.cdac_sw_9b_0.S[4] sky130_fd_pr__cap_mim_m3_1 l=2 w=2
X3157 sar9b_0.net21 a_9175_27364# VGND VGND sky130_fd_pr__nfet_01v8 ad=0.169 pd=1.82 as=0.2087 ps=2.02 w=0.65 l=0.15
X3158 a_12211_21050# sar9b_0.net15 VDPWR VDPWR sky130_fd_pr__pfet_01v8_hvt ad=0.0567 pd=0.69 as=0.0819 ps=0.81 w=0.42 l=0.15
X3159 a_13511_19266# a_12887_18900# a_13403_18900# VDPWR sky130_fd_pr__pfet_01v8_hvt ad=0.1155 pd=0.97 as=0.07245 ps=0.765 w=0.42 l=0.15
X3160 VDPWR single_9b_cdac_1.cdac_sw_9b_0.cdac_sw_3_7.tg_sw_3_3.SWN single_9b_cdac_1.cdac_sw_9b_0.cdac_sw_3_7.tg_sw_3_3.SWP VDPWR sky130_fd_pr__pfet_01v8 ad=0.196 pd=1.47 as=0.168 ps=1.42 w=1.12 l=0.15
X3161 VDPWR single_9b_cdac_1.cdac_sw_9b_0.cdac_sw_3_0.nooverlap_clk_0.x8.A single_9b_cdac_1.cdac_sw_9b_0.cdac_sw_3_0.nooverlap_clk_0.x10.A VDPWR sky130_fd_pr__pfet_01v8 ad=0.3304 pd=2.83 as=0.168 ps=1.42 w=1.12 l=0.15
X3162 single_9b_cdac_0.cdac_sw_9b_0.cdac_sw_3_5.tg_sw_3_3.SWN single_9b_cdac_0.cdac_sw_9b_0.cdac_sw_3_5.nooverlap_clk_0.x10.A VDPWR VDPWR sky130_fd_pr__pfet_01v8 ad=0.168 pd=1.42 as=0.3864 ps=2.93 w=1.12 l=0.15
X3163 VDPWR single_9b_cdac_0.cdac_sw_9b_0.cdac_sw_3_0.tg_sw_3_3.SWN single_9b_cdac_0.cdac_sw_9b_0.cdac_sw_3_0.tg_sw_3_3.SWP VDPWR sky130_fd_pr__pfet_01v8 ad=0.196 pd=1.47 as=0.168 ps=1.42 w=1.12 l=0.15
X3164 a_9095_23618# sar9b_0.net15 VDPWR VDPWR sky130_fd_pr__pfet_01v8_hvt ad=0.1092 pd=1.36 as=0.07035 ps=0.755 w=0.42 l=0.15
X3165 single_9b_cdac_1.cdac_sw_9b_0.S[7] single_9b_cdac_1.cdac_sw_9b_0.cdac_sw_3_7.tg_sw_3_3.SWP single_9b_cdac_1.cdac_sw_9b_0.S[7] VDPWR sky130_fd_pr__pfet_01v8 ad=0.435 pd=3.58 as=0 ps=0 w=1.5 l=0.5
X3166 VGND a_12937_27279# uo_out[2] VGND sky130_fd_pr__nfet_01v8 ad=0.0754 pd=0.81 as=0.1352 ps=1.56 w=0.52 l=0.15
X3167 th_dif_sw_0.VCP single_9b_cdac_1.cdac_sw_9b_0.S[3] sky130_fd_pr__cap_mim_m3_1 l=2 w=2
X3168 th_dif_sw_0.VCN single_9b_cdac_0.cdac_sw_9b_0.S[0] sky130_fd_pr__cap_mim_m3_1 l=2 w=2
X3169 VDPWR VGND VDPWR VDPWR sky130_fd_pr__pfet_01v8_hvt ad=0.2262 pd=2.26 as=0 ps=0 w=0.87 l=0.59
X3170 single_9b_cdac_1.cdac_sw_9b_0.cdac_sw_3_0.nooverlap_clk_0.x10.A single_9b_cdac_1.cdac_sw_9b_0.cdac_sw_3_0.nooverlap_clk_0.x8.A VDPWR VDPWR sky130_fd_pr__pfet_01v8 ad=0.168 pd=1.42 as=0.168 ps=1.42 w=1.12 l=0.15
X3171 a_11471_24174# a_11121_23802# a_11376_24162# VDPWR sky130_fd_pr__pfet_01v8_hvt ad=0.07245 pd=0.765 as=0.0651 ps=0.73 w=0.42 l=0.15
X3172 single_9b_cdac_1.cdac_sw_9b_0.cdac_sw_3_7.tg_sw_3_3.SWP single_9b_cdac_1.cdac_sw_9b_0.cdac_sw_3_7.tg_sw_3_3.SWN VDPWR VDPWR sky130_fd_pr__pfet_01v8 ad=0.168 pd=1.42 as=0.3304 ps=2.83 w=1.12 l=0.15
X3173 single_9b_cdac_1.cdac_sw_9b_0.S[5] single_9b_cdac_1.cdac_sw_9b_0.cdac_sw_3_5.tg_sw_3_3.SWN ua[0] VDPWR sky130_fd_pr__pfet_01v8 ad=0.435 pd=3.58 as=0.435 ps=3.58 w=1.5 l=0.5
X3174 th_dif_sw_0.VCN single_9b_cdac_0.cdac_sw_9b_0.S[2] sky130_fd_pr__cap_mim_m3_1 l=2 w=2
X3175 a_14143_22138# sar9b_0.net15 VDPWR VDPWR sky130_fd_pr__pfet_01v8_hvt ad=0.0567 pd=0.69 as=0.0819 ps=0.81 w=0.42 l=0.15
X3176 th_dif_sw_0.VCP single_9b_cdac_1.cdac_sw_9b_0.S[2] sky130_fd_pr__cap_mim_m3_1 l=2 w=2
X3177 VGND sar9b_0.net13 a_10955_23802# VGND sky130_fd_pr__nfet_01v8 ad=0.0567 pd=0.69 as=0.1092 ps=1.36 w=0.42 l=0.15
X3178 VDPWR single_9b_cdac_1.cdac_sw_9b_0.cdac_sw_3_0.nooverlap_clk_0.x8.A single_9b_cdac_1.cdac_sw_9b_0.cdac_sw_3_0.nooverlap_clk_0.x10.A VDPWR sky130_fd_pr__pfet_01v8 ad=0.168 pd=1.42 as=0.168 ps=1.42 w=1.12 l=0.15
X3179 th_dif_sw_0.VCP single_9b_cdac_1.cdac_sw_9b_0.S[5] sky130_fd_pr__cap_mim_m3_1 l=2 w=2
X3180 th_dif_sw_0.VCP single_9b_cdac_1.cdac_sw_9b_0.S[3] sky130_fd_pr__cap_mim_m3_1 l=2 w=2
X3181 a_13403_25262# a_13053_24890# a_13308_25250# VDPWR sky130_fd_pr__pfet_01v8_hvt ad=0.07245 pd=0.765 as=0.0651 ps=0.73 w=0.42 l=0.15
X3182 dw_17224_1400# a_21368_4076# sky130_fd_pr__cap_mim_m3_1 l=2 w=2
X3183 VGND single_9b_cdac_0.cdac_sw_9b_0.cdac_sw_3_8.nooverlap_clk_0.x1.A single_9b_cdac_0.cdac_sw_9b_0.cdac_sw_3_8.nooverlap_clk_0.sky130_fd_sc_hs__inv_8_0.A VGND sky130_fd_pr__nfet_01v8_lvt ad=0.1221 pd=1.07 as=0.1036 ps=1.02 w=0.74 l=0.15
X3184 a_57946_26999# single_9b_cdac_0.SW[1] VDPWR VDPWR sky130_fd_pr__pfet_01v8 ad=0.435 pd=3.58 as=0.435 ps=3.58 w=1.5 l=0.5
X3185 VDPWR VGND VDPWR VDPWR sky130_fd_pr__pfet_01v8_hvt ad=0.2262 pd=2.26 as=0 ps=0 w=0.87 l=0.59
X3186 VGND VDPWR VGND VGND sky130_fd_pr__nfet_01v8 ad=0.143 pd=1.62 as=0 ps=0 w=0.55 l=0.59
X3187 VDPWR VGND VDPWR VDPWR sky130_fd_pr__pfet_01v8_hvt ad=0.2262 pd=2.26 as=0 ps=0 w=0.87 l=0.59
X3188 th_dif_sw_0.VCN single_9b_cdac_0.cdac_sw_9b_0.S[0] sky130_fd_pr__cap_mim_m3_1 l=2 w=2
X3189 a_12683_18356# a_12059_18362# a_12575_18734# VDPWR sky130_fd_pr__pfet_01v8_hvt ad=0.1155 pd=0.97 as=0.07245 ps=0.765 w=0.42 l=0.15
X3190 single_9b_cdac_1.cdac_sw_9b_0.cdac_sw_3_0.nooverlap_clk_0.x10.A single_9b_cdac_1.cdac_sw_9b_0.cdac_sw_3_0.nooverlap_clk_0.x8.A VDPWR VDPWR sky130_fd_pr__pfet_01v8 ad=0.168 pd=1.42 as=0.3304 ps=2.83 w=1.12 l=0.15
X3191 th_dif_sw_0.VCP single_9b_cdac_1.cdac_sw_9b_0.S[3] sky130_fd_pr__cap_mim_m3_1 l=2 w=2
X3192 VGND single_9b_cdac_0.cdac_sw_9b_0.cdac_sw_3_7.nooverlap_clk_0.x10.A single_9b_cdac_0.cdac_sw_9b_0.cdac_sw_3_7.tg_sw_3_3.SWN VGND sky130_fd_pr__nfet_01v8_lvt ad=0.2109 pd=2.05 as=0.1036 ps=1.02 w=0.74 l=0.15
X3193 a_8340_27426# sar9b_0.net39 VGND VGND sky130_fd_pr__nfet_01v8 ad=0.066 pd=0.745 as=0.2205 ps=1.89 w=0.42 l=0.15
X3194 tdc_0.phase_detector_0.INP a_15151_10456# VDPWR VDPWR sky130_fd_pr__pfet_01v8 ad=0.3304 pd=2.83 as=0.1988 ps=1.505 w=1.12 l=0.15
X3195 VDPWR single_9b_cdac_0.cdac_sw_9b_0.cdac_sw_3_5.nooverlap_clk_0.CLKB0 single_9b_cdac_0.cdac_sw_9b_0.cdac_sw_3_5.nooverlap_clk_0.CLK0 VDPWR sky130_fd_pr__pfet_01v8 ad=0.196 pd=1.47 as=0.168 ps=1.42 w=1.12 l=0.15
X3196 VDPWR VGND VDPWR VDPWR sky130_fd_pr__pfet_01v8_hvt ad=0.2262 pd=2.26 as=0 ps=0 w=0.87 l=0.59
X3197 VDPWR VGND VDPWR VDPWR sky130_fd_pr__pfet_01v8_hvt ad=0.2262 pd=2.26 as=0 ps=0 w=0.87 l=0.59
X3198 a_9132_7271# th_dif_sw_0.CK VDPWR VDPWR sky130_fd_pr__pfet_01v8 ad=0.168 pd=1.42 as=0.168 ps=1.42 w=1.12 l=0.15
X3199 a_13053_19450# a_12887_19450# VGND VGND sky130_fd_pr__nfet_01v8 ad=0.1092 pd=1.36 as=0.0567 ps=0.69 w=0.42 l=0.15
X3200 th_dif_sw_0.VCN single_9b_cdac_0.cdac_sw_9b_0.S[0] sky130_fd_pr__cap_mim_m3_1 l=2 w=2
X3201 single_9b_cdac_0.cdac_sw_9b_0.cdac_sw_3_5.nooverlap_clk_0.CLK0 single_9b_cdac_0.cdac_sw_9b_0.cdac_sw_3_5.nooverlap_clk_0.CLKB0 VDPWR VDPWR sky130_fd_pr__pfet_01v8 ad=0.168 pd=1.42 as=0.168 ps=1.42 w=1.12 l=0.15
X3202 VGND single_9b_cdac_1.cdac_sw_9b_0.cdac_sw_3_5.nooverlap_clk_0.x8.A single_9b_cdac_1.cdac_sw_9b_0.cdac_sw_3_5.nooverlap_clk_0.x10.A VGND sky130_fd_pr__nfet_01v8_lvt ad=0.2109 pd=2.05 as=0.1036 ps=1.02 w=0.74 l=0.15
X3203 VGND single_9b_cdac_1.cdac_sw_9b_0.cdac_sw_3_4.tg_sw_3_3.SWN single_9b_cdac_1.cdac_sw_9b_0.cdac_sw_3_4.tg_sw_3_3.SWP VGND sky130_fd_pr__nfet_01v8_lvt ad=0.2146 pd=2.06 as=0.1036 ps=1.02 w=0.74 l=0.15
X3204 single_9b_cdac_1.cdac_sw_9b_0.S[1] single_9b_cdac_1.cdac_sw_9b_0.cdac_sw_3_1.nooverlap_clk_0.CLKB0 a_57946_16877# VDPWR sky130_fd_pr__pfet_01v8 ad=0.435 pd=3.58 as=0.435 ps=3.58 w=1.5 l=0.5
X3205 single_9b_cdac_0.cdac_sw_9b_0.S[0] single_9b_cdac_0.cdac_sw_9b_0.cdac_sw_3_2.nooverlap_clk_0.CLKB0 a_62748_26999# VDPWR sky130_fd_pr__pfet_01v8 ad=0.435 pd=3.58 as=0.435 ps=3.58 w=1.5 l=0.5
X3206 VGND sar9b_0.net15 a_12837_18722# VGND sky130_fd_pr__nfet_01v8 ad=0.1346 pd=1.15 as=0.0441 ps=0.63 w=0.42 l=0.15
X3207 single_9b_cdac_0.cdac_sw_9b_0.S[7] single_9b_cdac_0.cdac_sw_9b_0.cdac_sw_3_7.tg_sw_3_3.SWP ua[0] VGND sky130_fd_pr__nfet_01v8 ad=0.145 pd=1.58 as=0.145 ps=1.58 w=0.5 l=0.5
X3208 VDPWR single_9b_cdac_1.cdac_sw_9b_0.cdac_sw_3_3.nooverlap_clk_0.x8.A single_9b_cdac_1.cdac_sw_9b_0.cdac_sw_3_3.nooverlap_clk_0.sky130_fd_sc_hs__nand2_1_0.Y VDPWR sky130_fd_pr__pfet_01v8 ad=0.3192 pd=2.81 as=0.168 ps=1.42 w=1.12 l=0.15
X3209 th_dif_sw_0.VCN single_9b_cdac_0.cdac_sw_9b_0.S[1] sky130_fd_pr__cap_mim_m3_1 l=2 w=2
X3210 VDPWR single_9b_cdac_0.cdac_sw_9b_0.cdac_sw_3_5.nooverlap_clk_0.CLKB0 single_9b_cdac_0.cdac_sw_9b_0.cdac_sw_3_5.nooverlap_clk_0.CLK0 VDPWR sky130_fd_pr__pfet_01v8 ad=0.168 pd=1.42 as=0.168 ps=1.42 w=1.12 l=0.15
X3211 VGND VDPWR VGND VGND sky130_fd_pr__nfet_01v8 ad=0.143 pd=1.62 as=0 ps=0 w=0.55 l=0.59
X3212 VDPWR single_9b_cdac_1.cdac_sw_9b_0.cdac_sw_3_6.tg_sw_3_3.SWN single_9b_cdac_1.cdac_sw_9b_0.cdac_sw_3_6.tg_sw_3_3.SWP VDPWR sky130_fd_pr__pfet_01v8 ad=0.3864 pd=2.93 as=0.168 ps=1.42 w=1.12 l=0.15
X3213 VGND single_9b_cdac_1.cdac_sw_9b_0.cdac_sw_3_5.nooverlap_clk_0.x10.A single_9b_cdac_1.cdac_sw_9b_0.cdac_sw_3_5.tg_sw_3_3.SWN VGND sky130_fd_pr__nfet_01v8_lvt ad=0.1554 pd=1.16 as=0.1036 ps=1.02 w=0.74 l=0.15
X3214 th_dif_sw_0.VCN single_9b_cdac_0.cdac_sw_9b_0.S[0] sky130_fd_pr__cap_mim_m3_1 l=2 w=2
X3215 single_9b_cdac_1.cdac_sw_9b_0.cdac_sw_3_3.nooverlap_clk_0.sky130_fd_sc_hs__nand2_1_0.Y single_9b_cdac_1.CF[4] VDPWR VDPWR sky130_fd_pr__pfet_01v8 ad=0.168 pd=1.42 as=0.3192 ps=2.81 w=1.12 l=0.15
X3216 VGND single_9b_cdac_1.SW[2] a_54032_17740# VGND sky130_fd_pr__nfet_01v8 ad=0.145 pd=1.58 as=0.145 ps=1.58 w=0.5 l=0.5
X3217 th_dif_sw_0.VCP single_9b_cdac_1.cdac_sw_9b_0.S[0] sky130_fd_pr__cap_mim_m3_1 l=2 w=2
X3218 single_9b_cdac_0.cdac_sw_9b_0.cdac_sw_3_2.tg_sw_3_3.SWP single_9b_cdac_0.cdac_sw_9b_0.cdac_sw_3_2.tg_sw_3_3.SWN VGND VGND sky130_fd_pr__nfet_01v8_lvt ad=0.1036 pd=1.02 as=0.2146 ps=2.06 w=0.74 l=0.15
X3219 a_21684_3438# VDPWR th_dif_sw_0.th_sw_0.th_sw_main_0.VGS VGND sky130_fd_pr__nfet_01v8 ad=2.175 pd=15.58 as=2.175 ps=15.58 w=7.5 l=0.15
X3220 VGND sar9b_0.net15 a_11089_23252# VGND sky130_fd_pr__nfet_01v8 ad=0.1346 pd=1.15 as=0.0441 ps=0.63 w=0.42 l=0.15
X3221 single_9b_cdac_1.cdac_sw_9b_0.cdac_sw_3_6.tg_sw_3_3.SWP single_9b_cdac_1.cdac_sw_9b_0.cdac_sw_3_6.tg_sw_3_3.SWN VDPWR VDPWR sky130_fd_pr__pfet_01v8 ad=0.168 pd=1.42 as=0.196 ps=1.47 w=1.12 l=0.15
X3222 th_dif_sw_0.VCN single_9b_cdac_0.cdac_sw_9b_0.S[2] sky130_fd_pr__cap_mim_m3_1 l=2 w=2
X3223 single_9b_cdac_0.cdac_sw_9b_0.cdac_sw_3_4.nooverlap_clk_0.sky130_fd_sc_hs__nand2_1_0.Y single_9b_cdac_1.CF[3] a_50962_29911# VGND sky130_fd_pr__nfet_01v8_lvt ad=0.2109 pd=2.05 as=0.0888 ps=0.98 w=0.74 l=0.15
X3224 VGND single_9b_cdac_0.cdac_sw_9b_0.cdac_sw_3_4.nooverlap_clk_0.x4.A single_9b_cdac_0.cdac_sw_9b_0.cdac_sw_3_4.nooverlap_clk_0.x6.A VGND sky130_fd_pr__nfet_01v8_lvt ad=0.2627 pd=2.19 as=0.2109 ps=2.05 w=0.74 l=0.15
X3225 single_9b_cdac_0.cdac_sw_9b_0.cdac_sw_3_4.nooverlap_clk_0.CLK0 single_9b_cdac_0.cdac_sw_9b_0.cdac_sw_3_4.nooverlap_clk_0.CLKB0 VGND VGND sky130_fd_pr__nfet_01v8_lvt ad=0.1036 pd=1.02 as=0.1036 ps=1.02 w=0.74 l=0.15
X3226 a_7795_26276# a_7620_26350# a_7974_26338# VGND sky130_fd_pr__nfet_01v8 ad=0.1092 pd=1.36 as=0.06405 ps=0.725 w=0.42 l=0.15
X3227 th_dif_sw_0.VCN single_9b_cdac_0.cdac_sw_9b_0.S[1] sky130_fd_pr__cap_mim_m3_1 l=2 w=2
X3228 VGND th_dif_sw_0.VCN a_14897_9355# VGND sky130_fd_pr__nfet_01v8 ad=0.145 pd=1.29 as=0.145 ps=1.29 w=1 l=1
X3229 VDPWR single_9b_cdac_0.cdac_sw_9b_0.cdac_sw_3_6.nooverlap_clk_0.sky130_fd_sc_hs__nand2_1_0.Y single_9b_cdac_0.cdac_sw_9b_0.cdac_sw_3_6.nooverlap_clk_0.sky130_fd_sc_hs__inv_1_1.A VDPWR sky130_fd_pr__pfet_01v8 ad=0.3864 pd=2.93 as=0.3304 ps=2.83 w=1.12 l=0.15
X3230 VGND single_9b_cdac_0.cdac_sw_9b_0.cdac_sw_3_5.nooverlap_clk_0.x1.A single_9b_cdac_0.cdac_sw_9b_0.cdac_sw_3_5.nooverlap_clk_0.sky130_fd_sc_hs__inv_8_0.A VGND sky130_fd_pr__nfet_01v8_lvt ad=0.2331 pd=2.11 as=0.1184 ps=1.06 w=0.74 l=0.15
X3231 th_dif_sw_0.VCN single_9b_cdac_0.cdac_sw_9b_0.S[0] sky130_fd_pr__cap_mim_m3_1 l=2 w=2
X3232 VDPWR single_9b_cdac_0.cdac_sw_9b_0.cdac_sw_3_1.nooverlap_clk_0.x1.A single_9b_cdac_0.cdac_sw_9b_0.cdac_sw_3_1.nooverlap_clk_0.sky130_fd_sc_hs__inv_8_0.A VDPWR sky130_fd_pr__pfet_01v8 ad=0.3304 pd=2.83 as=0.168 ps=1.42 w=1.12 l=0.15
X3233 single_9b_cdac_1.CF[3] a_14175_21620# VGND VGND sky130_fd_pr__nfet_01v8 ad=0.1352 pd=1.56 as=0.0754 ps=0.81 w=0.52 l=0.15
X3234 VDPWR a_11965_20506# a_11855_20532# VDPWR sky130_fd_pr__pfet_01v8_hvt ad=0.07035 pd=0.755 as=0.1155 ps=0.97 w=0.42 l=0.15
X3235 a_9368_19822# a_8287_19450# a_9021_19418# VDPWR sky130_fd_pr__pfet_01v8_hvt ad=0.0588 pd=0.7 as=0.12915 ps=1.185 w=0.42 l=0.15
X3236 single_9b_cdac_1.cdac_sw_9b_0.cdac_sw_3_4.nooverlap_clk_0.x8.A single_9b_cdac_1.cdac_sw_9b_0.cdac_sw_3_4.nooverlap_clk_0.x6.A VGND VGND sky130_fd_pr__nfet_01v8_lvt ad=0.2109 pd=2.05 as=0.2627 ps=2.19 w=0.74 l=0.15
X3237 th_dif_sw_0.VCP single_9b_cdac_1.cdac_sw_9b_0.S[2] sky130_fd_pr__cap_mim_m3_1 l=2 w=2
X3238 th_dif_sw_0.VCN single_9b_cdac_0.cdac_sw_9b_0.S[0] sky130_fd_pr__cap_mim_m3_1 l=2 w=2
X3239 th_dif_sw_0.VCP single_9b_cdac_1.cdac_sw_9b_0.S[0] sky130_fd_pr__cap_mim_m3_1 l=2 w=2
X3240 single_9b_cdac_1.cdac_sw_9b_0.S[0] single_9b_cdac_1.cdac_sw_9b_0.cdac_sw_3_2.tg_sw_3_3.SWP single_9b_cdac_1.cdac_sw_9b_0.S[0] VDPWR sky130_fd_pr__pfet_01v8 ad=0.435 pd=3.58 as=0 ps=0 w=1.5 l=0.5
X3241 ua[0] single_9b_cdac_0.cdac_sw_9b_0.cdac_sw_3_2.tg_sw_3_3.SWP ua[0] VDPWR sky130_fd_pr__pfet_01v8 ad=0.435 pd=3.58 as=0 ps=0 w=1.5 l=0.5
X3242 VGND VDPWR VGND VGND sky130_fd_pr__nfet_01v8 ad=0.143 pd=1.62 as=0 ps=0 w=0.55 l=0.59
X3243 a_12036_24174# a_10955_23802# a_11689_23770# VDPWR sky130_fd_pr__pfet_01v8_hvt ad=0.0588 pd=0.7 as=0.12915 ps=1.185 w=0.42 l=0.15
X3244 single_9b_cdac_1.CF[5] a_13623_23252# VDPWR VDPWR sky130_fd_pr__pfet_01v8_hvt ad=0.2054 pd=2.1 as=0.11455 ps=1.08 w=0.79 l=0.15
X3245 VDPWR a_10055_20130# a_10016_20256# VDPWR sky130_fd_pr__pfet_01v8_hvt ad=0.0864 pd=0.91 as=0.1664 ps=1.8 w=0.64 l=0.15
X3246 th_dif_sw_0.VCP single_9b_cdac_1.cdac_sw_9b_0.S[4] sky130_fd_pr__cap_mim_m3_1 l=2 w=2
X3247 VGND VDPWR VGND VGND sky130_fd_pr__nfet_01v8 ad=0.143 pd=1.62 as=0 ps=0 w=0.55 l=0.59
X3248 a_6453_22164# sar9b_0._12_ a_6381_22164# VGND sky130_fd_pr__nfet_01v8 ad=0.0441 pd=0.63 as=0.0441 ps=0.63 w=0.42 l=0.15
X3249 th_dif_sw_0.VCN single_9b_cdac_0.cdac_sw_9b_0.S[2] sky130_fd_pr__cap_mim_m3_1 l=2 w=2
X3250 a_9739_21442# sar9b_0.net15 VDPWR VDPWR sky130_fd_pr__pfet_01v8_hvt ad=0.1092 pd=1.36 as=0.07035 ps=0.755 w=0.42 l=0.15
X3251 th_dif_sw_0.VCN single_9b_cdac_0.cdac_sw_9b_0.S[3] sky130_fd_pr__cap_mim_m3_1 l=2 w=2
X3252 single_9b_cdac_0.cdac_sw_9b_0.cdac_sw_3_8.tg_sw_3_3.SWN single_9b_cdac_0.cdac_sw_9b_0.cdac_sw_3_8.nooverlap_clk_0.x10.A VGND VGND sky130_fd_pr__nfet_01v8_lvt ad=0.1036 pd=1.02 as=0.2146 ps=2.06 w=0.74 l=0.15
X3253 single_9b_cdac_0.cdac_sw_9b_0.S[7] single_9b_cdac_0.cdac_sw_9b_0.cdac_sw_3_7.tg_sw_3_3.SWN single_9b_cdac_0.cdac_sw_9b_0.S[7] VGND sky130_fd_pr__nfet_01v8 ad=0.145 pd=1.58 as=0 ps=0 w=0.5 l=0.5
X3254 th_dif_sw_0.VCP single_9b_cdac_1.cdac_sw_9b_0.S[1] sky130_fd_pr__cap_mim_m3_1 l=2 w=2
X3255 VDPWR a_5487_27034# sar9b_0.net17 VDPWR sky130_fd_pr__pfet_01v8_hvt ad=0.3012 pd=2.66 as=0.26 ps=2.52 w=1 l=0.15
X3256 a_10153_18900# a_9774_19266# a_10081_18900# VGND sky130_fd_pr__nfet_01v8 ad=0.1401 pd=1.1 as=0.0441 ps=0.63 w=0.42 l=0.15
X3257 VDPWR VGND VDPWR VDPWR sky130_fd_pr__pfet_01v8_hvt ad=0.2262 pd=2.26 as=0 ps=0 w=0.87 l=0.59
X3258 single_9b_cdac_1.cdac_sw_9b_0.S[6] single_9b_cdac_1.cdac_sw_9b_0.cdac_sw_3_6.tg_sw_3_3.SWN single_9b_cdac_1.cdac_sw_9b_0.S[6] VGND sky130_fd_pr__nfet_01v8 ad=0.145 pd=1.58 as=0 ps=0 w=0.5 l=0.5
X3259 single_9b_cdac_1.SW[2] a_13071_20532# VDPWR VDPWR sky130_fd_pr__pfet_01v8_hvt ad=0.2054 pd=2.1 as=0.11455 ps=1.08 w=0.79 l=0.15
X3260 VGND single_9b_cdac_1.cdac_sw_9b_0.cdac_sw_3_8.nooverlap_clk_0.CLKB0 single_9b_cdac_1.cdac_sw_9b_0.cdac_sw_3_8.nooverlap_clk_0.CLK0 VGND sky130_fd_pr__nfet_01v8_lvt ad=0.1295 pd=1.09 as=0.1036 ps=1.02 w=0.74 l=0.15
X3261 th_dif_sw_0.VCN single_9b_cdac_0.cdac_sw_9b_0.S[1] sky130_fd_pr__cap_mim_m3_1 l=2 w=2
X3262 th_dif_sw_0.VCN single_9b_cdac_0.cdac_sw_9b_0.S[0] sky130_fd_pr__cap_mim_m3_1 l=2 w=2
X3263 single_9b_cdac_0.cdac_sw_9b_0.S[1] single_9b_cdac_0.cdac_sw_9b_0.cdac_sw_3_1.tg_sw_3_3.SWP ua[0] VGND sky130_fd_pr__nfet_01v8 ad=0.145 pd=1.58 as=0.145 ps=1.58 w=0.5 l=0.5
X3264 single_9b_cdac_0.cdac_sw_9b_0.cdac_sw_3_7.nooverlap_clk_0.CLK0 single_9b_cdac_0.cdac_sw_9b_0.cdac_sw_3_7.nooverlap_clk_0.CLKB0 VGND VGND sky130_fd_pr__nfet_01v8_lvt ad=0.1036 pd=1.02 as=0.2146 ps=2.06 w=0.74 l=0.15
X3265 single_9b_cdac_0.cdac_sw_9b_0.cdac_sw_3_6.nooverlap_clk_0.CLK0 single_9b_cdac_0.cdac_sw_9b_0.cdac_sw_3_6.nooverlap_clk_0.CLKB0 VDPWR VDPWR sky130_fd_pr__pfet_01v8 ad=0.168 pd=1.42 as=0.3864 ps=2.93 w=1.12 l=0.15
X3266 dw_17224_1400# a_21368_4076# sky130_fd_pr__cap_mim_m3_1 l=2 w=2
X3267 sar9b_0.clkload0.X a_6907_19444# VGND VGND sky130_fd_pr__nfet_01v8 ad=0.0588 pd=0.7 as=0.07035 ps=0.755 w=0.42 l=0.15
X3268 th_dif_sw_0.VCN single_9b_cdac_0.cdac_sw_9b_0.S[3] sky130_fd_pr__cap_mim_m3_1 l=2 w=2
X3269 a_8613_26681# sar9b_0.net20 VGND VGND sky130_fd_pr__nfet_01v8 ad=0.1352 pd=1.56 as=0.0754 ps=0.81 w=0.52 l=0.15
X3270 single_9b_cdac_0.cdac_sw_9b_0.S[6] single_9b_cdac_0.cdac_sw_9b_0.cdac_sw_3_6.tg_sw_3_3.SWP ua[0] VGND sky130_fd_pr__nfet_01v8 ad=0.145 pd=1.58 as=0.145 ps=1.58 w=0.5 l=0.5
X3271 th_dif_sw_0.VCP single_9b_cdac_1.cdac_sw_9b_0.S[0] sky130_fd_pr__cap_mim_m3_1 l=2 w=2
X3272 VGND single_9b_cdac_1.CF[0] single_9b_cdac_0.cdac_sw_9b_0.cdac_sw_3_2.nooverlap_clk_0.x3.Y VGND sky130_fd_pr__nfet_01v8_lvt ad=0.2627 pd=2.19 as=0.2109 ps=2.05 w=0.74 l=0.15
X3273 VDPWR VGND VDPWR VDPWR sky130_fd_pr__pfet_01v8_hvt ad=0.2262 pd=2.26 as=0 ps=0 w=0.87 l=0.59
X3274 dw_17224_1400# a_21368_4076# sky130_fd_pr__cap_mim_m3_1 l=2 w=2
X3275 th_dif_sw_0.VCN single_9b_cdac_0.cdac_sw_9b_0.S[0] sky130_fd_pr__cap_mim_m3_1 l=2 w=2
X3276 VGND VDPWR VGND VGND sky130_fd_pr__nfet_01v8 ad=0.143 pd=1.62 as=0 ps=0 w=0.55 l=0.59
X3277 dw_17224_1400# a_21368_4076# sky130_fd_pr__cap_mim_m3_1 l=2 w=2
X3278 th_dif_sw_0.VCN single_9b_cdac_0.cdac_sw_9b_0.S[0] sky130_fd_pr__cap_mim_m3_1 l=2 w=2
X3279 a_14143_23012# sar9b_0.net15 VDPWR VDPWR sky130_fd_pr__pfet_01v8_hvt ad=0.0567 pd=0.69 as=0.0819 ps=0.81 w=0.42 l=0.15
X3280 VDPWR sar9b_0.net10 a_8931_22164# VDPWR sky130_fd_pr__pfet_01v8_hvt ad=0.0864 pd=0.91 as=0.1664 ps=1.8 w=0.64 l=0.15
X3281 VGND sar9b_0.net39 a_13623_20532# VGND sky130_fd_pr__nfet_01v8 ad=0.0754 pd=0.81 as=0.1352 ps=1.56 w=0.52 l=0.15
X3282 VGND single_9b_cdac_0.cdac_sw_9b_0.cdac_sw_3_7.nooverlap_clk_0.x10.A single_9b_cdac_0.cdac_sw_9b_0.cdac_sw_3_7.tg_sw_3_3.SWN VGND sky130_fd_pr__nfet_01v8_lvt ad=0.1036 pd=1.02 as=0.1036 ps=1.02 w=0.74 l=0.15
X3283 VGND single_9b_cdac_0.cdac_sw_9b_0.cdac_sw_3_4.tg_sw_3_3.SWN single_9b_cdac_0.cdac_sw_9b_0.cdac_sw_3_4.tg_sw_3_3.SWP VGND sky130_fd_pr__nfet_01v8_lvt ad=0.2109 pd=2.05 as=0.1036 ps=1.02 w=0.74 l=0.15
X3284 VGND single_9b_cdac_0.cdac_sw_9b_0.cdac_sw_3_0.nooverlap_clk_0.sky130_fd_sc_hs__inv_8_0.A single_9b_cdac_0.cdac_sw_9b_0.cdac_sw_3_0.nooverlap_clk_0.CLKB0 VGND sky130_fd_pr__nfet_01v8_lvt ad=0.1295 pd=1.09 as=0.1036 ps=1.02 w=0.74 l=0.15
X3285 a_9447_22164# a_8931_22164# a_9352_22164# VGND sky130_fd_pr__special_nfet_01v8 ad=0.0594 pd=0.69 as=0.066 ps=0.745 w=0.36 l=0.15
X3286 VDPWR single_9b_cdac_1.cdac_sw_9b_0.cdac_sw_3_0.nooverlap_clk_0.x10.A single_9b_cdac_1.cdac_sw_9b_0.cdac_sw_3_0.tg_sw_3_3.SWN VDPWR sky130_fd_pr__pfet_01v8 ad=0.196 pd=1.47 as=0.168 ps=1.42 w=1.12 l=0.15
X3287 a_10196_21076# a_9115_21076# a_9849_21318# VDPWR sky130_fd_pr__pfet_01v8_hvt ad=0.0588 pd=0.7 as=0.12915 ps=1.185 w=0.42 l=0.15
X3288 a_9113_25946# a_8895_26350# VGND VGND sky130_fd_pr__nfet_01v8 ad=0.0999 pd=0.985 as=0.1346 ps=1.15 w=0.64 l=0.15
X3289 sar9b_0.clknet_0_CLK a_7345_21594# VGND VGND sky130_fd_pr__nfet_01v8 ad=0.0588 pd=0.7 as=0.05775 ps=0.695 w=0.42 l=0.15
X3290 a_7448_23252# sar9b_0.clk_div_0.COUNT\[0\] a_7145_23226# VGND sky130_fd_pr__nfet_01v8 ad=0.091 pd=0.93 as=0.08937 ps=0.925 w=0.65 l=0.15
X3291 single_9b_cdac_1.cdac_sw_9b_0.cdac_sw_3_8.nooverlap_clk_0.x6.A single_9b_cdac_1.cdac_sw_9b_0.cdac_sw_3_8.nooverlap_clk_0.x4.A VDPWR VDPWR sky130_fd_pr__pfet_01v8 ad=0.3304 pd=2.83 as=0.3864 ps=2.93 w=1.12 l=0.15
X3292 VDPWR single_9b_cdac_1.cdac_sw_9b_0.cdac_sw_3_0.nooverlap_clk_0.CLKB0 single_9b_cdac_1.cdac_sw_9b_0.cdac_sw_3_0.nooverlap_clk_0.CLK0 VDPWR sky130_fd_pr__pfet_01v8 ad=0.3864 pd=2.93 as=0.168 ps=1.42 w=1.12 l=0.15
X3293 tdc_0.OUTN tdc_0.OUTP a_16555_12412# VGND sky130_fd_pr__nfet_01v8_lvt ad=0.2109 pd=2.05 as=0.0888 ps=0.98 w=0.74 l=0.15
X3294 a_8634_22840# a_8912_22824# a_8868_22708# VDPWR sky130_fd_pr__pfet_01v8_hvt ad=0.0588 pd=0.7 as=0.0567 ps=0.69 w=0.42 l=0.15
X3295 th_dif_sw_0.VCP single_9b_cdac_1.cdac_sw_9b_0.S[2] sky130_fd_pr__cap_mim_m3_1 l=2 w=2
X3296 VDPWR single_9b_cdac_0.cdac_sw_9b_0.cdac_sw_3_5.nooverlap_clk_0.sky130_fd_sc_hs__nand2_1_0.Y single_9b_cdac_0.cdac_sw_9b_0.cdac_sw_3_5.nooverlap_clk_0.sky130_fd_sc_hs__inv_1_1.A VDPWR sky130_fd_pr__pfet_01v8 ad=0.3864 pd=2.93 as=0.3304 ps=2.83 w=1.12 l=0.15
X3297 a_43540_26999# single_9b_cdac_0.SW[4] VDPWR VDPWR sky130_fd_pr__pfet_01v8 ad=0.435 pd=3.58 as=0.435 ps=3.58 w=1.5 l=0.5
X3298 ua[0] single_9b_cdac_0.cdac_sw_9b_0.cdac_sw_3_1.tg_sw_3_3.SWN ua[0] VGND sky130_fd_pr__nfet_01v8 ad=0.145 pd=1.58 as=0 ps=0 w=0.5 l=0.5
X3299 VDPWR a_12036_24174# a_12211_24100# VDPWR sky130_fd_pr__pfet_01v8_hvt ad=0.1134 pd=1.38 as=0.0567 ps=0.69 w=0.42 l=0.15
X3300 sar9b_0.net28 a_14143_21050# VDPWR VDPWR sky130_fd_pr__pfet_01v8_hvt ad=0.26 pd=2.52 as=0.3012 ps=2.66 w=1 l=0.15
X3301 th_dif_sw_0.VCN single_9b_cdac_0.cdac_sw_9b_0.S[0] sky130_fd_pr__cap_mim_m3_1 l=2 w=2
X3302 th_dif_sw_0.th_sw_1.CK a_9132_7271# VGND VGND sky130_fd_pr__nfet_01v8_lvt ad=0.1036 pd=1.02 as=0.1554 ps=1.16 w=0.74 l=0.15
X3303 sar9b_0._12_ sar9b_0.clk_div_0.COUNT\[0\] VDPWR VDPWR sky130_fd_pr__pfet_01v8_hvt ad=0.26 pd=2.52 as=0.165 ps=1.33 w=1 l=0.15
X3304 single_9b_cdac_1.cdac_sw_9b_0.cdac_sw_3_0.nooverlap_clk_0.CLK0 single_9b_cdac_1.cdac_sw_9b_0.cdac_sw_3_0.nooverlap_clk_0.CLKB0 VDPWR VDPWR sky130_fd_pr__pfet_01v8 ad=0.168 pd=1.42 as=0.196 ps=1.47 w=1.12 l=0.15
X3305 ua[0] single_9b_cdac_0.cdac_sw_9b_0.cdac_sw_3_2.tg_sw_3_3.SWP ua[0] VDPWR sky130_fd_pr__pfet_01v8 ad=0.435 pd=3.58 as=0 ps=0 w=1.5 l=0.5
X3306 a_15151_10456# tdc_0.delay_gate_ori_0.sky130_fd_sc_hs__and2_1_0.A VDPWR VDPWR sky130_fd_pr__pfet_01v8 ad=0.147 pd=1.19 as=0.252 ps=2.28 w=0.84 l=0.15
X3307 VGND VDPWR VGND VGND sky130_fd_pr__nfet_01v8 ad=0.143 pd=1.62 as=0 ps=0 w=0.55 l=0.59
X3308 VDPWR VGND VDPWR VDPWR sky130_fd_pr__pfet_01v8_hvt ad=0.2262 pd=2.26 as=0 ps=0 w=0.87 l=0.59
X3309 a_13311_24174# a_12795_23802# a_13216_24162# VGND sky130_fd_pr__special_nfet_01v8 ad=0.0594 pd=0.69 as=0.066 ps=0.745 w=0.36 l=0.15
X3310 th_dif_sw_0.VCP single_9b_cdac_1.cdac_sw_9b_0.S[0] sky130_fd_pr__cap_mim_m3_1 l=2 w=2
X3311 VGND single_9b_cdac_0.cdac_sw_9b_0.cdac_sw_3_6.nooverlap_clk_0.x10.A single_9b_cdac_0.cdac_sw_9b_0.cdac_sw_3_6.tg_sw_3_3.SWN VGND sky130_fd_pr__nfet_01v8_lvt ad=0.1554 pd=1.16 as=0.1036 ps=1.02 w=0.74 l=0.15
X3312 VDPWR a_13968_25262# a_14143_25188# VDPWR sky130_fd_pr__pfet_01v8_hvt ad=0.1134 pd=1.38 as=0.0567 ps=0.69 w=0.42 l=0.15
X3313 single_9b_cdac_1.cdac_sw_9b_0.cdac_sw_3_0.nooverlap_clk_0.CLKB0 single_9b_cdac_1.cdac_sw_9b_0.cdac_sw_3_0.nooverlap_clk_0.sky130_fd_sc_hs__inv_8_0.A VGND VGND sky130_fd_pr__nfet_01v8_lvt ad=0.1036 pd=1.02 as=0.2109 ps=2.05 w=0.74 l=0.15
X3314 VDPWR single_9b_cdac_1.cdac_sw_9b_0.cdac_sw_3_1.nooverlap_clk_0.x8.A single_9b_cdac_1.cdac_sw_9b_0.cdac_sw_3_1.nooverlap_clk_0.sky130_fd_sc_hs__nand2_1_0.Y VDPWR sky130_fd_pr__pfet_01v8 ad=0.3192 pd=2.81 as=0.168 ps=1.42 w=1.12 l=0.15
X3315 a_8637_23252# a_8471_23252# VDPWR VDPWR sky130_fd_pr__pfet_01v8_hvt ad=0.1664 pd=1.8 as=0.0864 ps=0.91 w=0.64 l=0.15
X3316 a_11961_22164# a_10771_22164# a_11852_22164# VGND sky130_fd_pr__special_nfet_01v8 ad=0.0669 pd=0.75 as=0.0711 ps=0.755 w=0.36 l=0.15
X3317 VDPWR a_6701_20506# sar9b_0.clknet_1_0__leaf_CLK VDPWR sky130_fd_pr__pfet_01v8_hvt ad=0.14 pd=1.28 as=0.14 ps=1.28 w=1 l=0.15
X3318 a_10477_19450# a_10311_19450# VGND VGND sky130_fd_pr__nfet_01v8 ad=0.1092 pd=1.36 as=0.0567 ps=0.69 w=0.42 l=0.15
X3319 VDPWR clk a_7345_21594# VDPWR sky130_fd_pr__pfet_01v8_hvt ad=0.265 pd=2.53 as=0.14 ps=1.28 w=1 l=0.15
X3320 VGND VDPWR VGND VGND sky130_fd_pr__nfet_01v8 ad=0.143 pd=1.62 as=0 ps=0 w=0.55 l=0.59
X3321 a_11733_21076# a_11689_21318# a_11567_21076# VGND sky130_fd_pr__nfet_01v8 ad=0.0441 pd=0.63 as=0.1401 ps=1.1 w=0.42 l=0.15
X3322 th_dif_sw_0.VCP single_9b_cdac_1.cdac_sw_9b_0.S[2] sky130_fd_pr__cap_mim_m3_1 l=2 w=2
X3323 single_9b_cdac_1.cdac_sw_9b_0.cdac_sw_3_1.nooverlap_clk_0.sky130_fd_sc_hs__nand2_1_0.Y single_9b_cdac_1.CF[1] VDPWR VDPWR sky130_fd_pr__pfet_01v8 ad=0.168 pd=1.42 as=0.3192 ps=2.81 w=1.12 l=0.15
X3324 VDPWR a_11567_19748# a_11554_19444# VDPWR sky130_fd_pr__pfet_01v8_hvt ad=0.0819 pd=0.81 as=0.0567 ps=0.69 w=0.42 l=0.15
X3325 single_9b_cdac_1.cdac_sw_9b_0.cdac_sw_3_6.nooverlap_clk_0.x10.A single_9b_cdac_1.cdac_sw_9b_0.cdac_sw_3_6.nooverlap_clk_0.x8.A VGND VGND sky130_fd_pr__nfet_01v8_lvt ad=0.1184 pd=1.06 as=0.2331 ps=2.11 w=0.74 l=0.15
X3326 VGND single_9b_cdac_1.cdac_sw_9b_0.cdac_sw_3_6.nooverlap_clk_0.x10.A single_9b_cdac_1.cdac_sw_9b_0.cdac_sw_3_6.tg_sw_3_3.SWN VGND sky130_fd_pr__nfet_01v8_lvt ad=0.1295 pd=1.09 as=0.1036 ps=1.02 w=0.74 l=0.15
X3327 a_6007_27302# sar9b_0.FINAL VGND VGND sky130_fd_pr__nfet_01v8 ad=0.1092 pd=1.36 as=0.0567 ps=0.69 w=0.42 l=0.15
X3328 VGND single_9b_cdac_0.cdac_sw_9b_0.cdac_sw_3_3.nooverlap_clk_0.x8.A single_9b_cdac_0.cdac_sw_9b_0.cdac_sw_3_3.nooverlap_clk_0.x10.A VGND sky130_fd_pr__nfet_01v8_lvt ad=0.2331 pd=2.11 as=0.1184 ps=1.06 w=0.74 l=0.15
X3329 single_9b_cdac_0.cdac_sw_9b_0.cdac_sw_3_5.nooverlap_clk_0.CLK0 single_9b_cdac_0.cdac_sw_9b_0.cdac_sw_3_5.nooverlap_clk_0.CLKB0 VDPWR VDPWR sky130_fd_pr__pfet_01v8 ad=0.168 pd=1.42 as=0.3864 ps=2.93 w=1.12 l=0.15
X3330 single_9b_cdac_0.cdac_sw_9b_0.S[2] single_9b_cdac_0.cdac_sw_9b_0.cdac_sw_3_0.tg_sw_3_3.SWP single_9b_cdac_0.cdac_sw_9b_0.S[2] VDPWR sky130_fd_pr__pfet_01v8 ad=0.435 pd=3.58 as=6.96 ps=57.28 w=1.5 l=0.5
X3331 a_13665_22164# a_13621_22406# a_13499_22164# VGND sky130_fd_pr__nfet_01v8 ad=0.0441 pd=0.63 as=0.1401 ps=1.1 w=0.42 l=0.15
X3332 VDPWR a_6483_23618# a_6651_23520# VDPWR sky130_fd_pr__pfet_01v8_hvt ad=0.135 pd=1.27 as=0.27 ps=2.54 w=1 l=0.15
X3333 a_13499_21076# a_13053_21076# a_13403_21076# VGND sky130_fd_pr__special_nfet_01v8 ad=0.1401 pd=1.1 as=0.0594 ps=0.69 w=0.36 l=0.15
X3334 th_dif_sw_0.VCP single_9b_cdac_1.cdac_sw_9b_0.S[0] sky130_fd_pr__cap_mim_m3_1 l=2 w=2
X3335 single_9b_cdac_1.cdac_sw_9b_0.S[1] single_9b_cdac_1.cdac_sw_9b_0.cdac_sw_3_1.nooverlap_clk_0.CLKB0 a_57946_16877# VDPWR sky130_fd_pr__pfet_01v8 ad=0.435 pd=3.58 as=0.435 ps=3.58 w=1.5 l=0.5
X3336 th_dif_sw_0.VCP single_9b_cdac_1.cdac_sw_9b_0.S[1] sky130_fd_pr__cap_mim_m3_1 l=2 w=2
X3337 VDPWR VGND VDPWR VDPWR sky130_fd_pr__pfet_01v8_hvt ad=0.2262 pd=2.26 as=0 ps=0 w=0.87 l=0.59
X3338 VGND VDPWR VGND VGND sky130_fd_pr__nfet_01v8 ad=0.143 pd=1.62 as=0 ps=0 w=0.55 l=0.59
X3339 VDPWR a_10196_21076# a_10371_21050# VDPWR sky130_fd_pr__pfet_01v8_hvt ad=0.1134 pd=1.38 as=0.0567 ps=0.69 w=0.42 l=0.15
X3340 a_6440_19988# a_6061_19988# a_6343_20354# VGND sky130_fd_pr__special_nfet_01v8 ad=0.0687 pd=0.76 as=0.0594 ps=0.69 w=0.36 l=0.15
X3341 VDPWR a_9021_19418# a_8911_19444# VDPWR sky130_fd_pr__pfet_01v8_hvt ad=0.07035 pd=0.755 as=0.1155 ps=0.97 w=0.42 l=0.15
X3342 VDPWR VGND VDPWR VDPWR sky130_fd_pr__pfet_01v8_hvt ad=0.2262 pd=2.26 as=0 ps=0 w=0.87 l=0.59
X3343 th_dif_sw_0.VCP single_9b_cdac_1.cdac_sw_9b_0.S[0] sky130_fd_pr__cap_mim_m3_1 l=2 w=2
X3344 VGND single_9b_cdac_0.cdac_sw_9b_0.cdac_sw_3_3.nooverlap_clk_0.sky130_fd_sc_hs__inv_8_0.A single_9b_cdac_0.cdac_sw_9b_0.cdac_sw_3_3.nooverlap_clk_0.CLKB0 VGND sky130_fd_pr__nfet_01v8_lvt ad=0.1295 pd=1.09 as=0.1036 ps=1.02 w=0.74 l=0.15
X3345 single_9b_cdac_0.cdac_sw_9b_0.cdac_sw_3_1.nooverlap_clk_0.x10.A single_9b_cdac_0.cdac_sw_9b_0.cdac_sw_3_1.nooverlap_clk_0.x8.A VDPWR VDPWR sky130_fd_pr__pfet_01v8 ad=0.168 pd=1.42 as=0.168 ps=1.42 w=1.12 l=0.15
X3346 a_9113_24582# a_8895_24340# VDPWR VDPWR sky130_fd_pr__pfet_01v8_hvt ad=0.12915 pd=1.185 as=0.2184 ps=2.2 w=0.84 l=0.15
X3347 single_9b_cdac_1.CF[1] a_13623_21620# VDPWR VDPWR sky130_fd_pr__pfet_01v8_hvt ad=0.2054 pd=2.1 as=0.11455 ps=1.08 w=0.79 l=0.15
X3348 a_9849_21318# a_9631_21076# VGND VGND sky130_fd_pr__nfet_01v8 ad=0.0999 pd=0.985 as=0.1346 ps=1.15 w=0.64 l=0.15
X3349 VGND a_5945_26191# uio_out[1] VGND sky130_fd_pr__nfet_01v8 ad=0.0754 pd=0.81 as=0.1352 ps=1.56 w=0.52 l=0.15
X3350 a_7273_25946# a_7055_26350# VDPWR VDPWR sky130_fd_pr__pfet_01v8_hvt ad=0.12915 pd=1.185 as=0.2184 ps=2.2 w=0.84 l=0.15
X3351 a_9645_18900# a_9167_18874# VGND VGND sky130_fd_pr__nfet_01v8 ad=0.0669 pd=0.75 as=0.12495 ps=1.015 w=0.42 l=0.15
X3352 th_dif_sw_0.VCN single_9b_cdac_0.cdac_sw_9b_0.S[0] sky130_fd_pr__cap_mim_m3_1 l=2 w=2
X3353 single_9b_cdac_1.cdac_sw_9b_0.S[7] single_9b_cdac_1.cdac_sw_9b_0.cdac_sw_3_7.nooverlap_clk_0.CLKB0 a_29134_16877# VDPWR sky130_fd_pr__pfet_01v8 ad=0.435 pd=3.58 as=0.435 ps=3.58 w=1.5 l=0.5
X3354 th_dif_sw_0.VCP single_9b_cdac_1.cdac_sw_9b_0.S[0] sky130_fd_pr__cap_mim_m3_1 l=2 w=2
X3355 th_dif_sw_0.VCN single_9b_cdac_0.cdac_sw_9b_0.S[0] sky130_fd_pr__cap_mim_m3_1 l=2 w=2
X3356 single_9b_cdac_0.cdac_sw_9b_0.S[6] single_9b_cdac_0.cdac_sw_9b_0.cdac_sw_3_6.nooverlap_clk_0.CLKB0 a_33936_26999# VDPWR sky130_fd_pr__pfet_01v8 ad=0.435 pd=3.58 as=0.435 ps=3.58 w=1.5 l=0.5
X3357 VDPWR single_9b_cdac_0.cdac_sw_9b_0.cdac_sw_3_1.nooverlap_clk_0.x8.A single_9b_cdac_0.cdac_sw_9b_0.cdac_sw_3_1.nooverlap_clk_0.x10.A VDPWR sky130_fd_pr__pfet_01v8 ad=0.168 pd=1.42 as=0.168 ps=1.42 w=1.12 l=0.15
X3358 VDPWR single_9b_cdac_0.cdac_sw_9b_0.cdac_sw_3_6.nooverlap_clk_0.sky130_fd_sc_hs__inv_1_1.A single_9b_cdac_0.cdac_sw_9b_0.cdac_sw_3_6.nooverlap_clk_0.x1.A VDPWR sky130_fd_pr__pfet_01v8 ad=0.3864 pd=2.93 as=0.3304 ps=2.83 w=1.12 l=0.15
X3359 single_9b_cdac_0.cdac_sw_9b_0.cdac_sw_3_5.tg_sw_3_3.SWN single_9b_cdac_0.cdac_sw_9b_0.cdac_sw_3_5.nooverlap_clk_0.x10.A VGND VGND sky130_fd_pr__nfet_01v8_lvt ad=0.1036 pd=1.02 as=0.2146 ps=2.06 w=0.74 l=0.15
X3360 VGND single_9b_cdac_0.cdac_sw_9b_0.cdac_sw_3_2.nooverlap_clk_0.x3.Y a_64331_29917# VGND sky130_fd_pr__nfet_01v8_lvt ad=0.2109 pd=2.05 as=0.0888 ps=0.98 w=0.74 l=0.15
X3361 th_dif_sw_0.VCN single_9b_cdac_0.cdac_sw_9b_0.S[2] sky130_fd_pr__cap_mim_m3_1 l=2 w=2
X3362 a_9569_26350# a_8379_25978# a_9460_26350# VGND sky130_fd_pr__special_nfet_01v8 ad=0.0669 pd=0.75 as=0.0711 ps=0.755 w=0.36 l=0.15
X3363 VGND a_6674_21050# a_6315_21050# VGND sky130_fd_pr__nfet_01v8 ad=0.1359 pd=1.1 as=0.08775 ps=0.92 w=0.65 l=0.15
X3364 VDPWR VGND VDPWR VDPWR sky130_fd_pr__pfet_01v8_hvt ad=0.2262 pd=2.26 as=0 ps=0 w=0.87 l=0.59
X3365 VGND single_9b_cdac_0.cdac_sw_9b_0.cdac_sw_3_1.nooverlap_clk_0.sky130_fd_sc_hs__inv_1_1.A single_9b_cdac_0.cdac_sw_9b_0.cdac_sw_3_1.nooverlap_clk_0.x1.A VGND sky130_fd_pr__nfet_01v8_lvt ad=0.2627 pd=2.19 as=0.2109 ps=2.05 w=0.74 l=0.15
X3366 single_9b_cdac_0.cdac_sw_9b_0.cdac_sw_3_1.nooverlap_clk_0.x10.A single_9b_cdac_0.cdac_sw_9b_0.cdac_sw_3_1.nooverlap_clk_0.x8.A VDPWR VDPWR sky130_fd_pr__pfet_01v8 ad=0.168 pd=1.42 as=0.3304 ps=2.83 w=1.12 l=0.15
X3367 VGND sar9b_0.net27 a_13899_24340# VGND sky130_fd_pr__nfet_01v8 ad=0.0754 pd=0.81 as=0.1352 ps=1.56 w=0.52 l=0.15
X3368 VDPWR sar9b_0.clk_div_0.COUNT\[0\] a_5977_22708# VDPWR sky130_fd_pr__pfet_01v8_hvt ad=0.26 pd=2.52 as=0.105 ps=1.21 w=1 l=0.15
X3369 th_dif_sw_0.VCP single_9b_cdac_1.cdac_sw_9b_0.S[2] sky130_fd_pr__cap_mim_m3_1 l=2 w=2
X3370 VGND sar9b_0.net15 a_13665_23074# VGND sky130_fd_pr__nfet_01v8 ad=0.1346 pd=1.15 as=0.0441 ps=0.63 w=0.42 l=0.15
X3371 single_9b_cdac_0.cdac_sw_9b_0.cdac_sw_3_0.tg_sw_3_3.SWN single_9b_cdac_0.cdac_sw_9b_0.cdac_sw_3_0.nooverlap_clk_0.x10.A VDPWR VDPWR sky130_fd_pr__pfet_01v8 ad=0.168 pd=1.42 as=0.196 ps=1.47 w=1.12 l=0.15
X3372 a_12425_25946# a_12207_26350# VGND VGND sky130_fd_pr__nfet_01v8 ad=0.0999 pd=0.985 as=0.1346 ps=1.15 w=0.64 l=0.15
X3373 VDPWR a_6149_23770# sar9b_0.clknet_1_1__leaf_CLK VDPWR sky130_fd_pr__pfet_01v8_hvt ad=0.14 pd=1.28 as=0.14 ps=1.28 w=1 l=0.15
X3374 a_9773_19988# a_9738_20240# a_9535_19962# VGND sky130_fd_pr__nfet_01v8 ad=0.06405 pd=0.725 as=0.1092 ps=1.36 w=0.42 l=0.15
X3375 single_9b_cdac_1.cdac_sw_9b_0.cdac_sw_3_3.nooverlap_clk_0.CLKB0 single_9b_cdac_1.cdac_sw_9b_0.cdac_sw_3_3.nooverlap_clk_0.sky130_fd_sc_hs__inv_8_0.A VGND VGND sky130_fd_pr__nfet_01v8_lvt ad=0.1036 pd=1.02 as=0.2109 ps=2.05 w=0.74 l=0.15
X3376 VGND single_9b_cdac_0.cdac_sw_9b_0.cdac_sw_3_0.nooverlap_clk_0.sky130_fd_sc_hs__inv_8_0.A single_9b_cdac_0.cdac_sw_9b_0.cdac_sw_3_0.nooverlap_clk_0.CLKB0 VGND sky130_fd_pr__nfet_01v8_lvt ad=0.2109 pd=2.05 as=0.1036 ps=1.02 w=0.74 l=0.15
X3377 VGND VDPWR VGND VGND sky130_fd_pr__nfet_01v8 ad=0.143 pd=1.62 as=0 ps=0 w=0.55 l=0.59
X3378 VDPWR a_6149_23770# sar9b_0.clknet_1_1__leaf_CLK VDPWR sky130_fd_pr__pfet_01v8_hvt ad=0.14 pd=1.28 as=0.14 ps=1.28 w=1 l=0.15
X3379 VGND VDPWR VGND VGND sky130_fd_pr__nfet_01v8 ad=0.143 pd=1.62 as=0 ps=0 w=0.55 l=0.59
X3380 th_dif_sw_0.VCN single_9b_cdac_0.cdac_sw_9b_0.S[0] sky130_fd_pr__cap_mim_m3_1 l=2 w=2
X3381 th_dif_sw_0.VCN single_9b_cdac_0.cdac_sw_9b_0.S[0] sky130_fd_pr__cap_mim_m3_1 l=2 w=2
X3382 single_9b_cdac_1.cdac_sw_9b_0.S[0] single_9b_cdac_1.cdac_sw_9b_0.cdac_sw_3_2.tg_sw_3_3.SWP single_9b_cdac_1.cdac_sw_9b_0.S[0] VDPWR sky130_fd_pr__pfet_01v8 ad=0.435 pd=3.58 as=0 ps=0 w=1.5 l=0.5
X3383 VDPWR VGND VDPWR VDPWR sky130_fd_pr__pfet_01v8_hvt ad=0.2262 pd=2.26 as=0 ps=0 w=0.87 l=0.59
X3384 single_9b_cdac_0.cdac_sw_9b_0.cdac_sw_3_8.nooverlap_clk_0.sky130_fd_sc_hs__inv_8_0.A single_9b_cdac_0.cdac_sw_9b_0.cdac_sw_3_8.nooverlap_clk_0.x1.A VGND VGND sky130_fd_pr__nfet_01v8_lvt ad=0.1184 pd=1.06 as=0.1221 ps=1.07 w=0.74 l=0.15
X3385 a_7317_26338# a_7273_25946# a_7151_26350# VGND sky130_fd_pr__nfet_01v8 ad=0.0441 pd=0.63 as=0.1401 ps=1.1 w=0.42 l=0.15
X3386 VDPWR single_9b_cdac_1.cdac_sw_9b_0.cdac_sw_3_4.tg_sw_3_3.SWN single_9b_cdac_1.cdac_sw_9b_0.cdac_sw_3_4.tg_sw_3_3.SWP VDPWR sky130_fd_pr__pfet_01v8 ad=0.196 pd=1.47 as=0.168 ps=1.42 w=1.12 l=0.15
X3387 VGND single_9b_cdac_0.cdac_sw_9b_0.cdac_sw_3_4.tg_sw_3_3.SWN single_9b_cdac_0.cdac_sw_9b_0.cdac_sw_3_4.tg_sw_3_3.SWP VGND sky130_fd_pr__nfet_01v8_lvt ad=0.1036 pd=1.02 as=0.1036 ps=1.02 w=0.74 l=0.15
X3388 dw_17224_1400# a_21368_4076# sky130_fd_pr__cap_mim_m3_1 l=2 w=2
X3389 th_dif_sw_0.VCP single_9b_cdac_1.cdac_sw_9b_0.S[0] sky130_fd_pr__cap_mim_m3_1 l=2 w=2
X3390 VDPWR single_9b_cdac_0.cdac_sw_9b_0.cdac_sw_3_7.nooverlap_clk_0.x1.A single_9b_cdac_0.cdac_sw_9b_0.cdac_sw_3_7.nooverlap_clk_0.sky130_fd_sc_hs__inv_8_0.A VDPWR sky130_fd_pr__pfet_01v8 ad=0.3304 pd=2.83 as=0.168 ps=1.42 w=1.12 l=0.15
X3391 VGND single_9b_cdac_0.cdac_sw_9b_0.cdac_sw_3_0.tg_sw_3_3.SWN single_9b_cdac_0.cdac_sw_9b_0.cdac_sw_3_0.tg_sw_3_3.SWP VGND sky130_fd_pr__nfet_01v8_lvt ad=0.1554 pd=1.16 as=0.1036 ps=1.02 w=0.74 l=0.15
X3392 single_9b_cdac_1.SW[2] a_13071_20532# VGND VGND sky130_fd_pr__nfet_01v8 ad=0.1352 pd=1.56 as=0.0754 ps=0.81 w=0.52 l=0.15
X3393 VDPWR tdc_0.OUTN a_10311_17812# VDPWR sky130_fd_pr__pfet_01v8_hvt ad=0.1625 pd=1.325 as=0.265 ps=2.53 w=1 l=0.15
X3394 th_dif_sw_0.VCN single_9b_cdac_0.cdac_sw_9b_0.S[1] sky130_fd_pr__cap_mim_m3_1 l=2 w=2
X3395 a_11121_21076# a_10955_21076# VDPWR VDPWR sky130_fd_pr__pfet_01v8_hvt ad=0.1664 pd=1.8 as=0.0864 ps=0.91 w=0.64 l=0.15
X3396 VDPWR sar9b_0.net5 a_12887_19450# VDPWR sky130_fd_pr__pfet_01v8_hvt ad=0.0864 pd=0.91 as=0.1664 ps=1.8 w=0.64 l=0.15
X3397 a_13053_18900# a_12887_18900# VGND VGND sky130_fd_pr__nfet_01v8 ad=0.1092 pd=1.36 as=0.0567 ps=0.69 w=0.42 l=0.15
X3398 single_9b_cdac_1.cdac_sw_9b_0.S[6] single_9b_cdac_1.cdac_sw_9b_0.cdac_sw_3_6.tg_sw_3_3.SWP single_9b_cdac_1.cdac_sw_9b_0.S[6] VDPWR sky130_fd_pr__pfet_01v8 ad=0.435 pd=3.58 as=0 ps=0 w=1.5 l=0.5
X3399 single_9b_cdac_1.cdac_sw_9b_0.cdac_sw_3_4.tg_sw_3_3.SWP single_9b_cdac_1.cdac_sw_9b_0.cdac_sw_3_4.tg_sw_3_3.SWN VDPWR VDPWR sky130_fd_pr__pfet_01v8 ad=0.168 pd=1.42 as=0.168 ps=1.42 w=1.12 l=0.15
X3400 ua[0] single_9b_cdac_0.cdac_sw_9b_0.cdac_sw_3_6.tg_sw_3_3.SWP ua[0] VDPWR sky130_fd_pr__pfet_01v8 ad=0.435 pd=3.58 as=0 ps=0 w=1.5 l=0.5
X3401 VDPWR VGND VDPWR VDPWR sky130_fd_pr__pfet_01v8_hvt ad=0.2262 pd=2.26 as=0 ps=0 w=0.87 l=0.59
X3402 th_dif_sw_0.VCP single_9b_cdac_1.cdac_sw_9b_0.S[0] sky130_fd_pr__cap_mim_m3_1 l=2 w=2
X3403 sar9b_0.net23 a_10371_26490# VGND VGND sky130_fd_pr__nfet_01v8 ad=0.169 pd=1.82 as=0.2087 ps=2.02 w=0.65 l=0.15
X3404 VGND VDPWR VGND VGND sky130_fd_pr__nfet_01v8 ad=0.143 pd=1.62 as=0 ps=0 w=0.55 l=0.59
X3405 single_9b_cdac_1.cdac_sw_9b_0.cdac_sw_3_7.tg_sw_3_3.SWP single_9b_cdac_1.cdac_sw_9b_0.cdac_sw_3_7.tg_sw_3_3.SWN VGND VGND sky130_fd_pr__nfet_01v8_lvt ad=0.1036 pd=1.02 as=0.2109 ps=2.05 w=0.74 l=0.15
X3406 th_dif_sw_0.VCP single_9b_cdac_1.cdac_sw_9b_0.S[1] sky130_fd_pr__cap_mim_m3_1 l=2 w=2
X3407 th_dif_sw_0.VCP single_9b_cdac_1.cdac_sw_9b_0.S[1] sky130_fd_pr__cap_mim_m3_1 l=2 w=2
X3408 VDPWR single_9b_cdac_1.cdac_sw_9b_0.cdac_sw_3_4.tg_sw_3_3.SWN single_9b_cdac_1.cdac_sw_9b_0.cdac_sw_3_4.tg_sw_3_3.SWP VDPWR sky130_fd_pr__pfet_01v8 ad=0.168 pd=1.42 as=0.168 ps=1.42 w=1.12 l=0.15
X3409 single_9b_cdac_1.cdac_sw_9b_0.S[2] single_9b_cdac_1.cdac_sw_9b_0.cdac_sw_3_0.tg_sw_3_3.SWP single_9b_cdac_1.cdac_sw_9b_0.S[2] VDPWR sky130_fd_pr__pfet_01v8 ad=0.435 pd=3.58 as=6.96 ps=57.28 w=1.5 l=0.5
X3410 th_dif_sw_0.VCN single_9b_cdac_0.cdac_sw_9b_0.S[1] sky130_fd_pr__cap_mim_m3_1 l=2 w=2
X3411 VDPWR sar9b_0.net3 a_5487_27034# VDPWR sky130_fd_pr__pfet_01v8_hvt ad=0.0819 pd=0.81 as=0.0567 ps=0.69 w=0.42 l=0.15
X3412 VDPWR single_9b_cdac_0.cdac_sw_9b_0.cdac_sw_3_8.nooverlap_clk_0.sky130_fd_sc_hs__inv_8_0.A single_9b_cdac_0.cdac_sw_9b_0.cdac_sw_3_8.nooverlap_clk_0.CLKB0 VDPWR sky130_fd_pr__pfet_01v8 ad=0.196 pd=1.47 as=0.168 ps=1.42 w=1.12 l=0.15
X3413 a_8545_25978# a_8379_25978# VGND VGND sky130_fd_pr__nfet_01v8 ad=0.1092 pd=1.36 as=0.0567 ps=0.69 w=0.42 l=0.15
X3414 single_9b_cdac_1.CF[8] a_14451_23252# VDPWR VDPWR sky130_fd_pr__pfet_01v8_hvt ad=0.2054 pd=2.1 as=0.11455 ps=1.08 w=0.79 l=0.15
X3415 VGND single_9b_cdac_1.cdac_sw_9b_0.cdac_sw_3_0.nooverlap_clk_0.x8.A single_9b_cdac_1.cdac_sw_9b_0.cdac_sw_3_0.nooverlap_clk_0.x10.A VGND sky130_fd_pr__nfet_01v8_lvt ad=0.1221 pd=1.07 as=0.1184 ps=1.06 w=0.74 l=0.15
X3416 th_dif_sw_0.VCP single_9b_cdac_1.cdac_sw_9b_0.S[4] sky130_fd_pr__cap_mim_m3_1 l=2 w=2
X3417 th_dif_sw_0.VCN single_9b_cdac_0.cdac_sw_9b_0.S[1] sky130_fd_pr__cap_mim_m3_1 l=2 w=2
X3418 a_57946_16877# single_9b_cdac_1.SW[1] VDPWR VDPWR sky130_fd_pr__pfet_01v8 ad=0.435 pd=3.58 as=0.435 ps=3.58 w=1.5 l=0.5
X3419 VDPWR VGND VDPWR VDPWR sky130_fd_pr__pfet_01v8_hvt ad=0.2262 pd=2.26 as=0 ps=0 w=0.87 l=0.59
X3420 single_9b_cdac_1.cdac_sw_9b_0.cdac_sw_3_4.tg_sw_3_3.SWP single_9b_cdac_1.cdac_sw_9b_0.cdac_sw_3_4.tg_sw_3_3.SWN VDPWR VDPWR sky130_fd_pr__pfet_01v8 ad=0.168 pd=1.42 as=0.196 ps=1.47 w=1.12 l=0.15
X3421 VGND single_9b_cdac_1.cdac_sw_9b_0.cdac_sw_3_0.nooverlap_clk_0.x8.A a_55773_15501# VGND sky130_fd_pr__nfet_01v8_lvt ad=0.2109 pd=2.05 as=0.0888 ps=0.98 w=0.74 l=0.15
X3422 single_9b_cdac_0.cdac_sw_9b_0.cdac_sw_3_8.nooverlap_clk_0.CLKB0 single_9b_cdac_0.cdac_sw_9b_0.cdac_sw_3_8.nooverlap_clk_0.sky130_fd_sc_hs__inv_8_0.A VDPWR VDPWR sky130_fd_pr__pfet_01v8 ad=0.168 pd=1.42 as=0.3864 ps=2.93 w=1.12 l=0.15
X3423 a_62748_26999# single_9b_cdac_0.SW[0] VDPWR VDPWR sky130_fd_pr__pfet_01v8 ad=0.435 pd=3.58 as=0.435 ps=3.58 w=1.5 l=0.5
X3424 a_10923_19822# a_10477_19450# a_10827_19822# VGND sky130_fd_pr__special_nfet_01v8 ad=0.1401 pd=1.1 as=0.0594 ps=0.69 w=0.36 l=0.15
X3425 VDPWR VGND VDPWR VDPWR sky130_fd_pr__pfet_01v8_hvt ad=0.2262 pd=2.26 as=0 ps=0 w=0.87 l=0.59
X3426 ua[0] single_9b_cdac_1.cdac_sw_9b_0.cdac_sw_3_0.tg_sw_3_3.SWP ua[0] VDPWR sky130_fd_pr__pfet_01v8 ad=0.435 pd=3.58 as=0 ps=0 w=1.5 l=0.5
X3427 a_5951_26516# a_5435_26516# a_5856_26516# VGND sky130_fd_pr__special_nfet_01v8 ad=0.0594 pd=0.69 as=0.066 ps=0.745 w=0.36 l=0.15
X3428 a_54737_29917# single_9b_cdac_0.cdac_sw_9b_0.cdac_sw_3_0.nooverlap_clk_0.x1.A single_9b_cdac_0.cdac_sw_9b_0.cdac_sw_3_0.nooverlap_clk_0.x4.A VGND sky130_fd_pr__nfet_01v8_lvt ad=0.0888 pd=0.98 as=0.2109 ps=2.05 w=0.74 l=0.15
X3429 VGND th_dif_sw_0.VCP a_17125_9355# VGND sky130_fd_pr__nfet_01v8 ad=0.145 pd=1.29 as=0.145 ps=1.29 w=1 l=1
X3430 th_dif_sw_0.VCP single_9b_cdac_1.cdac_sw_9b_0.S[3] sky130_fd_pr__cap_mim_m3_1 l=2 w=2
X3431 th_dif_sw_0.VCN single_9b_cdac_0.cdac_sw_9b_0.S[0] sky130_fd_pr__cap_mim_m3_1 l=2 w=2
X3432 VDPWR single_9b_cdac_0.cdac_sw_9b_0.cdac_sw_3_5.nooverlap_clk_0.sky130_fd_sc_hs__inv_1_1.A single_9b_cdac_0.cdac_sw_9b_0.cdac_sw_3_5.nooverlap_clk_0.x1.A VDPWR sky130_fd_pr__pfet_01v8 ad=0.3864 pd=2.93 as=0.3304 ps=2.83 w=1.12 l=0.15
X3433 single_9b_cdac_1.cdac_sw_9b_0.cdac_sw_3_8.nooverlap_clk_0.x3.Y single_9b_cdac_1.CF[8] VGND VGND sky130_fd_pr__nfet_01v8_lvt ad=0.2109 pd=2.05 as=0.2627 ps=2.19 w=0.74 l=0.15
X3434 sar9b_0.clknet_1_1__leaf_CLK a_6149_23770# VDPWR VDPWR sky130_fd_pr__pfet_01v8_hvt ad=0.14 pd=1.28 as=0.14 ps=1.28 w=1 l=0.15
X3435 sar9b_0.net30 a_14143_23012# VDPWR VDPWR sky130_fd_pr__pfet_01v8_hvt ad=0.26 pd=2.52 as=0.3012 ps=2.66 w=1 l=0.15
X3436 a_11192_22164# sar9b_0.net9 VDPWR VDPWR sky130_fd_pr__pfet_01v8_hvt ad=0.0651 pd=0.73 as=0.1092 ps=1.36 w=0.42 l=0.15
X3437 VGND single_9b_cdac_1.cdac_sw_9b_0.cdac_sw_3_6.nooverlap_clk_0.x10.A single_9b_cdac_1.cdac_sw_9b_0.cdac_sw_3_6.tg_sw_3_3.SWN VGND sky130_fd_pr__nfet_01v8_lvt ad=0.1036 pd=1.02 as=0.1036 ps=1.02 w=0.74 l=0.15
X3438 single_9b_cdac_1.cdac_sw_9b_0.cdac_sw_3_0.tg_sw_3_3.SWN single_9b_cdac_1.cdac_sw_9b_0.cdac_sw_3_0.nooverlap_clk_0.x10.A VGND VGND sky130_fd_pr__nfet_01v8_lvt ad=0.1036 pd=1.02 as=0.1036 ps=1.02 w=0.74 l=0.15
X3439 a_16357_9613# th_dif_sw_0.VCN VDPWR VDPWR sky130_fd_pr__pfet_01v8 ad=0.435 pd=3.29 as=0.435 ps=3.29 w=3 l=1
X3440 VGND single_9b_cdac_0.cdac_sw_9b_0.cdac_sw_3_3.nooverlap_clk_0.sky130_fd_sc_hs__inv_8_0.A single_9b_cdac_0.cdac_sw_9b_0.cdac_sw_3_3.nooverlap_clk_0.CLKB0 VGND sky130_fd_pr__nfet_01v8_lvt ad=0.2109 pd=2.05 as=0.1036 ps=1.02 w=0.74 l=0.15
X3441 a_43540_26999# single_9b_cdac_0.SW[4] VDPWR VDPWR sky130_fd_pr__pfet_01v8 ad=0.435 pd=3.58 as=0.435 ps=3.58 w=1.5 l=0.5
X3442 VDPWR VGND VDPWR VDPWR sky130_fd_pr__pfet_01v8_hvt ad=0.2262 pd=2.26 as=0 ps=0 w=0.87 l=0.59
X3443 a_11303_25794# a_10679_25428# a_11195_25428# VDPWR sky130_fd_pr__pfet_01v8_hvt ad=0.1155 pd=0.97 as=0.07245 ps=0.765 w=0.42 l=0.15
X3444 a_9078_20506# a_8910_20532# VGND VGND sky130_fd_pr__nfet_01v8 ad=0.0989 pd=0.995 as=0.12095 ps=1.085 w=0.64 l=0.15
X3445 th_dif_sw_0.VCN single_9b_cdac_0.cdac_sw_9b_0.S[1] sky130_fd_pr__cap_mim_m3_1 l=2 w=2
X3446 single_9b_cdac_1.cdac_sw_9b_0.cdac_sw_3_5.nooverlap_clk_0.x3.Y single_9b_cdac_1.CF[5] VDPWR VDPWR sky130_fd_pr__pfet_01v8 ad=0.3304 pd=2.83 as=0.3864 ps=2.93 w=1.12 l=0.15
X3447 VDPWR single_9b_cdac_0.cdac_sw_9b_0.cdac_sw_3_3.tg_sw_3_3.SWN single_9b_cdac_0.cdac_sw_9b_0.cdac_sw_3_3.tg_sw_3_3.SWP VDPWR sky130_fd_pr__pfet_01v8 ad=0.196 pd=1.47 as=0.168 ps=1.42 w=1.12 l=0.15
X3448 VGND ui_in[0] a_5343_25972# VGND sky130_fd_pr__nfet_01v8 ad=0.07035 pd=0.755 as=0.1113 ps=1.37 w=0.42 l=0.15
X3449 ua[0] single_9b_cdac_1.cdac_sw_9b_0.cdac_sw_3_2.tg_sw_3_3.SWP ua[0] VDPWR sky130_fd_pr__pfet_01v8 ad=0.435 pd=3.58 as=0 ps=0 w=1.5 l=0.5
X3450 VGND VDPWR VGND VGND sky130_fd_pr__nfet_01v8 ad=0.143 pd=1.62 as=0 ps=0 w=0.55 l=0.59
X3451 VDPWR single_9b_cdac_1.cdac_sw_9b_0.cdac_sw_3_5.nooverlap_clk_0.x10.A single_9b_cdac_1.cdac_sw_9b_0.cdac_sw_3_5.tg_sw_3_3.SWN VDPWR sky130_fd_pr__pfet_01v8 ad=0.3864 pd=2.93 as=0.168 ps=1.42 w=1.12 l=0.15
X3452 single_9b_cdac_0.cdac_sw_9b_0.cdac_sw_3_3.tg_sw_3_3.SWP single_9b_cdac_0.cdac_sw_9b_0.cdac_sw_3_3.tg_sw_3_3.SWN VDPWR VDPWR sky130_fd_pr__pfet_01v8 ad=0.168 pd=1.42 as=0.168 ps=1.42 w=1.12 l=0.15
X3453 single_9b_cdac_1.CF[7] a_14175_23252# VGND VGND sky130_fd_pr__nfet_01v8 ad=0.1352 pd=1.56 as=0.0754 ps=0.81 w=0.52 l=0.15
X3454 VGND VDPWR VGND VGND sky130_fd_pr__nfet_01v8 ad=0.143 pd=1.62 as=0 ps=0 w=0.55 l=0.59
X3455 ua[0] single_9b_cdac_0.cdac_sw_9b_0.cdac_sw_3_6.tg_sw_3_3.SWP ua[0] VDPWR sky130_fd_pr__pfet_01v8 ad=0.435 pd=3.58 as=0 ps=0 w=1.5 l=0.5
X3456 single_9b_cdac_0.cdac_sw_9b_0.cdac_sw_3_1.tg_sw_3_3.SWP single_9b_cdac_0.cdac_sw_9b_0.cdac_sw_3_1.tg_sw_3_3.SWN VGND VGND sky130_fd_pr__nfet_01v8_lvt ad=0.1036 pd=1.02 as=0.1036 ps=1.02 w=0.74 l=0.15
X3457 VGND single_9b_cdac_1.cdac_sw_9b_0.cdac_sw_3_8.nooverlap_clk_0.CLKB0 single_9b_cdac_1.cdac_sw_9b_0.cdac_sw_3_8.nooverlap_clk_0.CLK0 VGND sky130_fd_pr__nfet_01v8_lvt ad=0.1554 pd=1.16 as=0.1036 ps=1.02 w=0.74 l=0.15
X3458 single_9b_cdac_1.cdac_sw_9b_0.cdac_sw_3_5.tg_sw_3_3.SWN single_9b_cdac_1.cdac_sw_9b_0.cdac_sw_3_5.nooverlap_clk_0.x10.A VDPWR VDPWR sky130_fd_pr__pfet_01v8 ad=0.168 pd=1.42 as=0.196 ps=1.47 w=1.12 l=0.15
X3459 single_9b_cdac_0.cdac_sw_9b_0.S[1] single_9b_cdac_0.cdac_sw_9b_0.cdac_sw_3_1.tg_sw_3_3.SWN ua[0] VDPWR sky130_fd_pr__pfet_01v8 ad=0.435 pd=3.58 as=0.435 ps=3.58 w=1.5 l=0.5
X3460 a_13621_19418# a_13403_19822# VGND VGND sky130_fd_pr__nfet_01v8 ad=0.0999 pd=0.985 as=0.1346 ps=1.15 w=0.64 l=0.15
X3461 single_9b_cdac_1.cdac_sw_9b_0.cdac_sw_3_7.nooverlap_clk_0.x6.A single_9b_cdac_1.cdac_sw_9b_0.cdac_sw_3_7.nooverlap_clk_0.x4.A VGND VGND sky130_fd_pr__nfet_01v8_lvt ad=0.2109 pd=2.05 as=0.2627 ps=2.19 w=0.74 l=0.15
X3462 tdc_0.RDY a_16159_13315# a_16185_13034# VDPWR sky130_fd_pr__pfet_01v8 ad=0.3864 pd=2.93 as=0.196 ps=1.47 w=1.12 l=0.15
X3463 VDPWR single_9b_cdac_0.cdac_sw_9b_0.cdac_sw_3_3.tg_sw_3_3.SWN single_9b_cdac_0.cdac_sw_9b_0.cdac_sw_3_3.tg_sw_3_3.SWP VDPWR sky130_fd_pr__pfet_01v8 ad=0.168 pd=1.42 as=0.168 ps=1.42 w=1.12 l=0.15
X3464 VDPWR VGND VDPWR VDPWR sky130_fd_pr__pfet_01v8_hvt ad=0.2262 pd=2.26 as=0 ps=0 w=0.87 l=0.59
X3465 th_dif_sw_0.VCN single_9b_cdac_0.cdac_sw_9b_0.S[1] sky130_fd_pr__cap_mim_m3_1 l=2 w=2
X3466 single_9b_cdac_0.cdac_sw_9b_0.S[1] single_9b_cdac_0.cdac_sw_9b_0.cdac_sw_3_1.tg_sw_3_3.SWP single_9b_cdac_0.cdac_sw_9b_0.S[1] VDPWR sky130_fd_pr__pfet_01v8 ad=0.435 pd=3.58 as=0 ps=0 w=1.5 l=0.5
X3467 a_7795_26276# sar9b_0.net3 VDPWR VDPWR sky130_fd_pr__pfet_01v8_hvt ad=0.0567 pd=0.69 as=0.0819 ps=0.81 w=0.42 l=0.15
X3468 VDPWR single_9b_cdac_1.cdac_sw_9b_0.cdac_sw_3_7.nooverlap_clk_0.x8.A single_9b_cdac_1.cdac_sw_9b_0.cdac_sw_3_7.nooverlap_clk_0.sky130_fd_sc_hs__nand2_1_0.Y VDPWR sky130_fd_pr__pfet_01v8 ad=0.3192 pd=2.81 as=0.168 ps=1.42 w=1.12 l=0.15
X3469 th_dif_sw_0.VCP single_9b_cdac_1.cdac_sw_9b_0.S[0] sky130_fd_pr__cap_mim_m3_1 l=2 w=2
X3470 single_9b_cdac_1.cdac_sw_9b_0.cdac_sw_3_2.nooverlap_clk_0.CLK0 single_9b_cdac_1.cdac_sw_9b_0.cdac_sw_3_2.nooverlap_clk_0.CLKB0 VGND VGND sky130_fd_pr__nfet_01v8_lvt ad=0.1036 pd=1.02 as=0.1295 ps=1.09 w=0.74 l=0.15
X3471 VGND sar9b_0.FINAL a_13465_27398# VGND sky130_fd_pr__nfet_01v8 ad=0.1118 pd=1.04 as=0.0567 ps=0.69 w=0.42 l=0.15
X3472 VGND single_9b_cdac_0.cdac_sw_9b_0.cdac_sw_3_2.nooverlap_clk_0.x6.A single_9b_cdac_0.cdac_sw_9b_0.cdac_sw_3_2.nooverlap_clk_0.x8.A VGND sky130_fd_pr__nfet_01v8_lvt ad=0.2627 pd=2.19 as=0.2109 ps=2.05 w=0.74 l=0.15
X3473 single_9b_cdac_1.cdac_sw_9b_0.cdac_sw_3_3.nooverlap_clk_0.sky130_fd_sc_hs__inv_1_1.A single_9b_cdac_1.cdac_sw_9b_0.cdac_sw_3_3.nooverlap_clk_0.sky130_fd_sc_hs__nand2_1_0.Y VDPWR VDPWR sky130_fd_pr__pfet_01v8 ad=0.3304 pd=2.83 as=0.3864 ps=2.93 w=1.12 l=0.15
X3474 VGND single_9b_cdac_1.SW[3] a_49221_17740# VGND sky130_fd_pr__nfet_01v8 ad=0.145 pd=1.58 as=0.145 ps=1.58 w=0.5 l=0.5
X3475 th_dif_sw_0.VCP single_9b_cdac_1.cdac_sw_9b_0.S[6] sky130_fd_pr__cap_mim_m3_1 l=2 w=2
X3476 a_8637_20538# a_8471_20538# VDPWR VDPWR sky130_fd_pr__pfet_01v8_hvt ad=0.1664 pd=1.8 as=0.0864 ps=0.91 w=0.64 l=0.15
X3477 th_dif_sw_0.VCN single_9b_cdac_0.cdac_sw_9b_0.S[0] sky130_fd_pr__cap_mim_m3_1 l=2 w=2
X3478 a_13308_19988# sar9b_0.net1 VDPWR VDPWR sky130_fd_pr__pfet_01v8_hvt ad=0.0651 pd=0.73 as=0.1092 ps=1.36 w=0.42 l=0.15
X3479 single_9b_cdac_1.cdac_sw_9b_0.cdac_sw_3_7.nooverlap_clk_0.sky130_fd_sc_hs__nand2_1_0.Y single_9b_cdac_1.CF[7] VDPWR VDPWR sky130_fd_pr__pfet_01v8 ad=0.168 pd=1.42 as=0.3192 ps=2.81 w=1.12 l=0.15
X3480 VGND single_9b_cdac_1.cdac_sw_9b_0.cdac_sw_3_3.nooverlap_clk_0.x8.A a_46159_15501# VGND sky130_fd_pr__nfet_01v8_lvt ad=0.2109 pd=2.05 as=0.0888 ps=0.98 w=0.74 l=0.15
X3481 VGND single_9b_cdac_0.cdac_sw_9b_0.cdac_sw_3_0.nooverlap_clk_0.sky130_fd_sc_hs__inv_8_0.A single_9b_cdac_0.cdac_sw_9b_0.cdac_sw_3_0.nooverlap_clk_0.CLKB0 VGND sky130_fd_pr__nfet_01v8_lvt ad=0.1036 pd=1.02 as=0.1036 ps=1.02 w=0.74 l=0.15
X3482 single_9b_cdac_1.CF[1] a_13623_21620# VGND VGND sky130_fd_pr__nfet_01v8 ad=0.1352 pd=1.56 as=0.0754 ps=0.81 w=0.52 l=0.15
X3483 VGND VDPWR VGND VGND sky130_fd_pr__nfet_01v8 ad=0.143 pd=1.62 as=0 ps=0 w=0.55 l=0.59
X3484 a_11376_24162# sar9b_0.net2 VGND VGND sky130_fd_pr__nfet_01v8 ad=0.066 pd=0.745 as=0.2205 ps=1.89 w=0.42 l=0.15
X3485 VDPWR single_9b_cdac_1.CF[4] single_9b_cdac_0.cdac_sw_9b_0.cdac_sw_3_3.nooverlap_clk_0.x3.Y VDPWR sky130_fd_pr__pfet_01v8 ad=0.3864 pd=2.93 as=0.3304 ps=2.83 w=1.12 l=0.15
X3486 VDPWR sar9b_0.clknet_1_0__leaf_CLK a_5895_19988# VDPWR sky130_fd_pr__pfet_01v8_hvt ad=0.0864 pd=0.91 as=0.1664 ps=1.8 w=0.64 l=0.15
X3487 VDPWR single_9b_cdac_1.CF[6] single_9b_cdac_0.cdac_sw_9b_0.cdac_sw_3_6.nooverlap_clk_0.sky130_fd_sc_hs__nand2_1_0.Y VDPWR sky130_fd_pr__pfet_01v8 ad=0.3192 pd=2.81 as=0.168 ps=1.42 w=1.12 l=0.15
X3488 VGND VDPWR VGND VGND sky130_fd_pr__nfet_01v8 ad=0.143 pd=1.62 as=0 ps=0 w=0.55 l=0.59
X3489 VDPWR VGND VDPWR VDPWR sky130_fd_pr__pfet_01v8_hvt ad=0.2262 pd=2.26 as=0 ps=0 w=0.87 l=0.59
X3490 th_dif_sw_0.VCN single_9b_cdac_0.cdac_sw_9b_0.S[5] sky130_fd_pr__cap_mim_m3_1 l=2 w=2
X3491 a_11857_25978# a_11691_25978# VGND VGND sky130_fd_pr__nfet_01v8 ad=0.1092 pd=1.36 as=0.0567 ps=0.69 w=0.42 l=0.15
X3492 VDPWR VGND VDPWR VDPWR sky130_fd_pr__pfet_01v8_hvt ad=0.2262 pd=2.26 as=0 ps=0 w=0.87 l=0.59
X3493 VGND sar9b_0.net10 a_8931_22164# VGND sky130_fd_pr__nfet_01v8 ad=0.0567 pd=0.69 as=0.1092 ps=1.36 w=0.42 l=0.15
X3494 single_9b_cdac_1.cdac_sw_9b_0.S[7] single_9b_cdac_1.cdac_sw_9b_0.cdac_sw_3_7.nooverlap_clk_0.CLKB0 a_29134_16877# VDPWR sky130_fd_pr__pfet_01v8 ad=0.435 pd=3.58 as=0.435 ps=3.58 w=1.5 l=0.5
X3495 a_13379_27398# sar9b_0.net15 VDPWR VDPWR sky130_fd_pr__pfet_01v8_hvt ad=0.0567 pd=0.69 as=0.1176 ps=1.4 w=0.42 l=0.15
X3496 single_9b_cdac_0.cdac_sw_9b_0.cdac_sw_3_6.nooverlap_clk_0.sky130_fd_sc_hs__nand2_1_0.Y single_9b_cdac_0.cdac_sw_9b_0.cdac_sw_3_6.nooverlap_clk_0.x8.A VDPWR VDPWR sky130_fd_pr__pfet_01v8 ad=0.168 pd=1.42 as=0.3192 ps=2.81 w=1.12 l=0.15
X3497 VDPWR VGND VDPWR VDPWR sky130_fd_pr__pfet_01v8_hvt ad=0.2262 pd=2.26 as=0 ps=0 w=0.87 l=0.59
X3498 a_13308_25250# sar9b_0.net1 VGND VGND sky130_fd_pr__nfet_01v8 ad=0.066 pd=0.745 as=0.2205 ps=1.89 w=0.42 l=0.15
X3499 a_6058_23618# a_5785_23252# a_5973_23252# VDPWR sky130_fd_pr__pfet_01v8_hvt ad=0.06825 pd=0.745 as=0.05775 ps=0.695 w=0.42 l=0.15
X3500 a_29134_26999# single_9b_cdac_0.SW[7] VDPWR VDPWR sky130_fd_pr__pfet_01v8 ad=0.435 pd=3.58 as=0.435 ps=3.58 w=1.5 l=0.5
X3501 a_9065_19810# a_9021_19418# a_8899_19822# VGND sky130_fd_pr__nfet_01v8 ad=0.0441 pd=0.63 as=0.1401 ps=1.1 w=0.42 l=0.15
X3502 th_dif_sw_0.VCN single_9b_cdac_0.cdac_sw_9b_0.S[1] sky130_fd_pr__cap_mim_m3_1 l=2 w=2
X3503 th_dif_sw_0.VCN single_9b_cdac_0.cdac_sw_9b_0.S[0] sky130_fd_pr__cap_mim_m3_1 l=2 w=2
X3504 VDPWR a_9809_27279# uo_out[5] VDPWR sky130_fd_pr__pfet_01v8_hvt ad=0.11455 pd=1.08 as=0.2054 ps=2.1 w=0.79 l=0.15
X3505 single_9b_cdac_0.cdac_sw_9b_0.cdac_sw_3_7.nooverlap_clk_0.x10.A single_9b_cdac_0.cdac_sw_9b_0.cdac_sw_3_7.nooverlap_clk_0.x8.A VGND VGND sky130_fd_pr__nfet_01v8_lvt ad=0.1036 pd=1.02 as=0.2109 ps=2.05 w=0.74 l=0.15
X3506 VDPWR sar9b_0.net34 a_14451_27060# VDPWR sky130_fd_pr__pfet_01v8_hvt ad=0.11455 pd=1.08 as=0.2054 ps=2.1 w=0.79 l=0.15
X3507 a_8435_27438# a_7919_27066# a_8340_27426# VGND sky130_fd_pr__special_nfet_01v8 ad=0.0594 pd=0.69 as=0.066 ps=0.745 w=0.36 l=0.15
X3508 single_9b_cdac_1.cdac_sw_9b_0.cdac_sw_3_4.nooverlap_clk_0.x8.A single_9b_cdac_1.cdac_sw_9b_0.cdac_sw_3_4.nooverlap_clk_0.x6.A VDPWR VDPWR sky130_fd_pr__pfet_01v8 ad=0.3304 pd=2.83 as=0.3864 ps=2.93 w=1.12 l=0.15
X3509 ua[0] single_9b_cdac_1.cdac_sw_9b_0.cdac_sw_3_1.tg_sw_3_3.SWN ua[0] VGND sky130_fd_pr__nfet_01v8 ad=0.145 pd=1.58 as=0 ps=0 w=0.5 l=0.5
X3510 th_dif_sw_0.VCN single_9b_cdac_0.cdac_sw_9b_0.S[4] sky130_fd_pr__cap_mim_m3_1 l=2 w=2
X3511 VGND single_9b_cdac_0.cdac_sw_9b_0.cdac_sw_3_4.nooverlap_clk_0.sky130_fd_sc_hs__inv_8_0.A single_9b_cdac_0.cdac_sw_9b_0.cdac_sw_3_4.nooverlap_clk_0.CLKB0 VGND sky130_fd_pr__nfet_01v8_lvt ad=0.1554 pd=1.16 as=0.1036 ps=1.02 w=0.74 l=0.15
X3512 a_5969_25428# a_5803_25428# VDPWR VDPWR sky130_fd_pr__pfet_01v8_hvt ad=0.1664 pd=1.8 as=0.0864 ps=0.91 w=0.64 l=0.15
X3513 a_11760_25428# a_10845_25428# a_11413_25670# VGND sky130_fd_pr__special_nfet_01v8 ad=0.0711 pd=0.755 as=0.0999 ps=0.985 w=0.36 l=0.15
X3514 single_9b_cdac_1.CF[4] a_14451_21620# VDPWR VDPWR sky130_fd_pr__pfet_01v8_hvt ad=0.2054 pd=2.1 as=0.11455 ps=1.08 w=0.79 l=0.15
X3515 th_dif_sw_0.VCP single_9b_cdac_1.cdac_sw_9b_0.S[0] sky130_fd_pr__cap_mim_m3_1 l=2 w=2
X3516 a_11852_22164# a_10937_22164# a_11505_22406# VGND sky130_fd_pr__special_nfet_01v8 ad=0.0711 pd=0.755 as=0.0999 ps=0.985 w=0.36 l=0.15
X3517 VGND single_9b_cdac_0.cdac_sw_9b_0.cdac_sw_3_7.nooverlap_clk_0.sky130_fd_sc_hs__inv_1_1.A single_9b_cdac_0.cdac_sw_9b_0.cdac_sw_3_7.nooverlap_clk_0.x1.A VGND sky130_fd_pr__nfet_01v8_lvt ad=0.2627 pd=2.19 as=0.2109 ps=2.05 w=0.74 l=0.15
X3518 ua[0] single_9b_cdac_0.cdac_sw_9b_0.cdac_sw_3_1.tg_sw_3_3.SWN ua[0] VGND sky130_fd_pr__nfet_01v8 ad=0.145 pd=1.58 as=0 ps=0 w=0.5 l=0.5
X3519 th_dif_sw_0.VCN single_9b_cdac_0.cdac_sw_9b_0.S[4] sky130_fd_pr__cap_mim_m3_1 l=2 w=2
X3520 VDPWR th_dif_sw_0.CK a_9132_7271# VDPWR sky130_fd_pr__pfet_01v8 ad=0.196 pd=1.47 as=0.168 ps=1.42 w=1.12 l=0.15
X3521 VGND single_9b_cdac_0.cdac_sw_9b_0.cdac_sw_3_6.tg_sw_3_3.SWN single_9b_cdac_0.cdac_sw_9b_0.cdac_sw_3_6.tg_sw_3_3.SWP VGND sky130_fd_pr__nfet_01v8_lvt ad=0.1295 pd=1.09 as=0.1036 ps=1.02 w=0.74 l=0.15
X3522 VGND VDPWR VGND VGND sky130_fd_pr__nfet_01v8 ad=0.143 pd=1.62 as=0 ps=0 w=0.55 l=0.59
X3523 th_dif_sw_0.VCP single_9b_cdac_1.cdac_sw_9b_0.S[3] sky130_fd_pr__cap_mim_m3_1 l=2 w=2
X3524 th_dif_sw_0.VCN single_9b_cdac_0.cdac_sw_9b_0.S[1] sky130_fd_pr__cap_mim_m3_1 l=2 w=2
X3525 VGND single_9b_cdac_1.cdac_sw_9b_0.cdac_sw_3_1.nooverlap_clk_0.x1.A single_9b_cdac_1.cdac_sw_9b_0.cdac_sw_3_1.nooverlap_clk_0.sky130_fd_sc_hs__inv_8_0.A VGND sky130_fd_pr__nfet_01v8_lvt ad=0.2109 pd=2.05 as=0.1036 ps=1.02 w=0.74 l=0.15
X3526 single_9b_cdac_1.cdac_sw_9b_0.cdac_sw_3_4.nooverlap_clk_0.sky130_fd_sc_hs__inv_8_0.A single_9b_cdac_1.cdac_sw_9b_0.cdac_sw_3_4.nooverlap_clk_0.x1.A VGND VGND sky130_fd_pr__nfet_01v8_lvt ad=0.1184 pd=1.06 as=0.2331 ps=2.11 w=0.74 l=0.15
X3527 th_dif_sw_0.VCP single_9b_cdac_1.cdac_sw_9b_0.S[0] sky130_fd_pr__cap_mim_m3_1 l=2 w=2
X3528 sar9b_0.net18 a_6691_26490# VGND VGND sky130_fd_pr__nfet_01v8 ad=0.169 pd=1.82 as=0.2087 ps=2.02 w=0.65 l=0.15
X3529 VGND VDPWR VGND VGND sky130_fd_pr__nfet_01v8 ad=0.143 pd=1.62 as=0 ps=0 w=0.55 l=0.59
X3530 VDPWR VGND VDPWR VDPWR sky130_fd_pr__pfet_01v8_hvt ad=0.2262 pd=2.26 as=0 ps=0 w=0.87 l=0.59
X3531 VGND single_9b_cdac_1.cdac_sw_9b_0.cdac_sw_3_4.nooverlap_clk_0.sky130_fd_sc_hs__inv_8_0.A single_9b_cdac_1.cdac_sw_9b_0.cdac_sw_3_4.nooverlap_clk_0.CLKB0 VGND sky130_fd_pr__nfet_01v8_lvt ad=0.1295 pd=1.09 as=0.1036 ps=1.02 w=0.74 l=0.15
X3532 VDPWR a_6691_26490# a_6678_26882# VDPWR sky130_fd_pr__pfet_01v8_hvt ad=0.0819 pd=0.81 as=0.0567 ps=0.69 w=0.42 l=0.15
X3533 single_9b_cdac_1.cdac_sw_9b_0.S[6] single_9b_cdac_1.cdac_sw_9b_0.cdac_sw_3_6.tg_sw_3_3.SWP single_9b_cdac_1.cdac_sw_9b_0.S[6] VDPWR sky130_fd_pr__pfet_01v8 ad=0.435 pd=3.58 as=0 ps=0 w=1.5 l=0.5
X3534 th_dif_sw_0.VCP single_9b_cdac_1.cdac_sw_9b_0.S[2] sky130_fd_pr__cap_mim_m3_1 l=2 w=2
X3535 single_9b_cdac_1.cdac_sw_9b_0.cdac_sw_3_5.nooverlap_clk_0.x3.Y single_9b_cdac_1.CF[5] VGND VGND sky130_fd_pr__nfet_01v8_lvt ad=0.2109 pd=2.05 as=0.2627 ps=2.19 w=0.74 l=0.15
X3536 VGND single_9b_cdac_1.cdac_sw_9b_0.cdac_sw_3_1.nooverlap_clk_0.sky130_fd_sc_hs__inv_8_0.A single_9b_cdac_1.cdac_sw_9b_0.cdac_sw_3_1.nooverlap_clk_0.CLKB0 VGND sky130_fd_pr__nfet_01v8_lvt ad=0.1554 pd=1.16 as=0.1036 ps=1.02 w=0.74 l=0.15
X3537 VGND single_9b_cdac_0.cdac_sw_9b_0.cdac_sw_3_3.nooverlap_clk_0.sky130_fd_sc_hs__inv_8_0.A single_9b_cdac_0.cdac_sw_9b_0.cdac_sw_3_3.nooverlap_clk_0.CLKB0 VGND sky130_fd_pr__nfet_01v8_lvt ad=0.1036 pd=1.02 as=0.1036 ps=1.02 w=0.74 l=0.15
X3538 single_9b_cdac_1.cdac_sw_9b_0.S[0] single_9b_cdac_1.cdac_sw_9b_0.cdac_sw_3_2.tg_sw_3_3.SWN single_9b_cdac_1.cdac_sw_9b_0.S[0] VGND sky130_fd_pr__nfet_01v8 ad=0.145 pd=1.58 as=0 ps=0 w=0.5 l=0.5
X3539 VDPWR single_9b_cdac_0.cdac_sw_9b_0.cdac_sw_3_6.nooverlap_clk_0.CLKB0 single_9b_cdac_0.cdac_sw_9b_0.cdac_sw_3_6.nooverlap_clk_0.CLK0 VDPWR sky130_fd_pr__pfet_01v8 ad=0.196 pd=1.47 as=0.168 ps=1.42 w=1.12 l=0.15
X3540 a_7163_25972# sar9b_0.net3 VDPWR VDPWR sky130_fd_pr__pfet_01v8_hvt ad=0.1092 pd=1.36 as=0.07035 ps=0.755 w=0.42 l=0.15
X3541 VDPWR a_12772_26350# a_12947_26276# VDPWR sky130_fd_pr__pfet_01v8_hvt ad=0.1134 pd=1.38 as=0.0567 ps=0.69 w=0.42 l=0.15
X3542 VDPWR single_9b_cdac_1.cdac_sw_9b_0.cdac_sw_3_6.nooverlap_clk_0.x1.A single_9b_cdac_1.cdac_sw_9b_0.cdac_sw_3_6.nooverlap_clk_0.sky130_fd_sc_hs__inv_8_0.A VDPWR sky130_fd_pr__pfet_01v8 ad=0.3304 pd=2.83 as=0.168 ps=1.42 w=1.12 l=0.15
X3543 single_9b_cdac_0.SW[5] a_14175_25972# VDPWR VDPWR sky130_fd_pr__pfet_01v8_hvt ad=0.2054 pd=2.1 as=0.11455 ps=1.08 w=0.79 l=0.15
X3544 VDPWR single_9b_cdac_0.cdac_sw_9b_0.cdac_sw_3_3.nooverlap_clk_0.x4.A single_9b_cdac_0.cdac_sw_9b_0.cdac_sw_3_3.nooverlap_clk_0.x6.A VDPWR sky130_fd_pr__pfet_01v8 ad=0.3864 pd=2.93 as=0.3304 ps=2.83 w=1.12 l=0.15
X3545 th_dif_sw_0.VCP single_9b_cdac_1.cdac_sw_9b_0.S[2] sky130_fd_pr__cap_mim_m3_1 l=2 w=2
X3546 a_10637_27279# sar9b_0.net22 VGND VGND sky130_fd_pr__nfet_01v8 ad=0.1352 pd=1.56 as=0.0754 ps=0.81 w=0.52 l=0.15
X3547 a_8634_22840# a_8951_22950# a_8909_23074# VGND sky130_fd_pr__special_nfet_01v8 ad=0.0711 pd=0.755 as=0.0669 ps=0.75 w=0.36 l=0.15
X3548 single_9b_cdac_1.cdac_sw_9b_0.cdac_sw_3_6.nooverlap_clk_0.sky130_fd_sc_hs__inv_8_0.A single_9b_cdac_1.cdac_sw_9b_0.cdac_sw_3_6.nooverlap_clk_0.x1.A VDPWR VDPWR sky130_fd_pr__pfet_01v8 ad=0.168 pd=1.42 as=0.168 ps=1.42 w=1.12 l=0.15
X3549 a_57946_16877# single_9b_cdac_1.SW[1] VDPWR VDPWR sky130_fd_pr__pfet_01v8 ad=0.435 pd=3.58 as=0.435 ps=3.58 w=1.5 l=0.5
X3550 VDPWR single_9b_cdac_1.CF[5] single_9b_cdac_0.cdac_sw_9b_0.cdac_sw_3_5.nooverlap_clk_0.sky130_fd_sc_hs__nand2_1_0.Y VDPWR sky130_fd_pr__pfet_01v8 ad=0.3192 pd=2.81 as=0.168 ps=1.42 w=1.12 l=0.15
X3551 VGND single_9b_cdac_0.SW[6] a_34814_26990# VGND sky130_fd_pr__nfet_01v8 ad=0.145 pd=1.58 as=0.145 ps=1.58 w=0.5 l=0.5
X3552 ua[0] single_9b_cdac_1.cdac_sw_9b_0.cdac_sw_3_8.tg_sw_3_3.SWN ua[0] VGND sky130_fd_pr__nfet_01v8 ad=0.145 pd=1.58 as=0 ps=0 w=0.5 l=0.5
X3553 ua[0] single_9b_cdac_1.cdac_sw_9b_0.cdac_sw_3_0.tg_sw_3_3.SWP ua[0] VDPWR sky130_fd_pr__pfet_01v8 ad=0.435 pd=3.58 as=0 ps=0 w=1.5 l=0.5
X3554 single_9b_cdac_0.cdac_sw_9b_0.S[0] single_9b_cdac_0.cdac_sw_9b_0.cdac_sw_3_2.tg_sw_3_3.SWP ua[0] VGND sky130_fd_pr__nfet_01v8 ad=0.145 pd=1.58 as=0.145 ps=1.58 w=0.5 l=0.5
X3555 sar9b_0.clknet_1_0__leaf_CLK a_6701_20506# VDPWR VDPWR sky130_fd_pr__pfet_01v8_hvt ad=0.14 pd=1.28 as=0.1375 ps=1.275 w=1 l=0.15
X3556 th_dif_sw_0.VCN single_9b_cdac_0.cdac_sw_9b_0.S[3] sky130_fd_pr__cap_mim_m3_1 l=2 w=2
X3557 VGND sar9b_0.net15 a_13665_22164# VGND sky130_fd_pr__nfet_01v8 ad=0.1346 pd=1.15 as=0.0441 ps=0.63 w=0.42 l=0.15
X3558 VDPWR single_9b_cdac_1.cdac_sw_9b_0.cdac_sw_3_6.nooverlap_clk_0.x1.A single_9b_cdac_1.cdac_sw_9b_0.cdac_sw_3_6.nooverlap_clk_0.sky130_fd_sc_hs__inv_8_0.A VDPWR sky130_fd_pr__pfet_01v8 ad=0.168 pd=1.42 as=0.168 ps=1.42 w=1.12 l=0.15
X3559 single_9b_cdac_0.cdac_sw_9b_0.cdac_sw_3_5.nooverlap_clk_0.sky130_fd_sc_hs__nand2_1_0.Y single_9b_cdac_0.cdac_sw_9b_0.cdac_sw_3_5.nooverlap_clk_0.x8.A VDPWR VDPWR sky130_fd_pr__pfet_01v8 ad=0.168 pd=1.42 as=0.3192 ps=2.81 w=1.12 l=0.15
X3560 VGND a_6163_27034# a_6094_27060# VGND sky130_fd_pr__nfet_01v8 ad=0.1346 pd=1.15 as=0.0999 ps=0.985 w=0.64 l=0.15
X3561 a_33936_26999# single_9b_cdac_0.SW[6] VDPWR VDPWR sky130_fd_pr__pfet_01v8 ad=0.435 pd=3.58 as=0.435 ps=3.58 w=1.5 l=0.5
X3562 VDPWR VGND VDPWR VDPWR sky130_fd_pr__pfet_01v8_hvt ad=0.2262 pd=2.26 as=0 ps=0 w=0.87 l=0.59
X3563 th_dif_sw_0.VCP single_9b_cdac_1.cdac_sw_9b_0.S[0] sky130_fd_pr__cap_mim_m3_1 l=2 w=2
X3564 a_10366_22164# sar9b_0.net15 VGND VGND sky130_fd_pr__nfet_01v8 ad=0.06405 pd=0.725 as=0.12495 ps=1.015 w=0.42 l=0.15
X3565 single_9b_cdac_1.cdac_sw_9b_0.cdac_sw_3_6.nooverlap_clk_0.sky130_fd_sc_hs__inv_8_0.A single_9b_cdac_1.cdac_sw_9b_0.cdac_sw_3_6.nooverlap_clk_0.x1.A VDPWR VDPWR sky130_fd_pr__pfet_01v8 ad=0.168 pd=1.42 as=0.3304 ps=2.83 w=1.12 l=0.15
X3566 th_dif_sw_0.VCP single_9b_cdac_1.cdac_sw_9b_0.S[0] sky130_fd_pr__cap_mim_m3_1 l=2 w=2
X3567 VDPWR single_9b_cdac_0.cdac_sw_9b_0.cdac_sw_3_2.nooverlap_clk_0.x10.A single_9b_cdac_0.cdac_sw_9b_0.cdac_sw_3_2.tg_sw_3_3.SWN VDPWR sky130_fd_pr__pfet_01v8 ad=0.196 pd=1.47 as=0.168 ps=1.42 w=1.12 l=0.15
X3568 a_11471_18900# a_11121_18900# a_11376_18900# VDPWR sky130_fd_pr__pfet_01v8_hvt ad=0.07245 pd=0.765 as=0.0651 ps=0.73 w=0.42 l=0.15
X3569 single_9b_cdac_1.cdac_sw_9b_0.S[3] single_9b_cdac_1.cdac_sw_9b_0.cdac_sw_3_4.tg_sw_3_3.SWN ua[0] VDPWR sky130_fd_pr__pfet_01v8 ad=0.435 pd=3.58 as=0.435 ps=3.58 w=1.5 l=0.5
X3570 th_dif_sw_0.VCP single_9b_cdac_1.cdac_sw_9b_0.S[0] sky130_fd_pr__cap_mim_m3_1 l=2 w=2
X3571 single_9b_cdac_1.cdac_sw_9b_0.cdac_sw_3_1.nooverlap_clk_0.sky130_fd_sc_hs__inv_1_1.A single_9b_cdac_1.cdac_sw_9b_0.cdac_sw_3_1.nooverlap_clk_0.sky130_fd_sc_hs__nand2_1_0.Y VDPWR VDPWR sky130_fd_pr__pfet_01v8 ad=0.3304 pd=2.83 as=0.3864 ps=2.93 w=1.12 l=0.15
X3572 single_9b_cdac_1.cdac_sw_9b_0.S[0] single_9b_cdac_1.cdac_sw_9b_0.cdac_sw_3_2.nooverlap_clk_0.CLKB0 a_62748_16877# VDPWR sky130_fd_pr__pfet_01v8 ad=0.435 pd=3.58 as=0.435 ps=3.58 w=1.5 l=0.5
X3573 th_dif_sw_0.VCP single_9b_cdac_1.cdac_sw_9b_0.S[0] sky130_fd_pr__cap_mim_m3_1 l=2 w=2
X3574 th_dif_sw_0.VCN single_9b_cdac_0.cdac_sw_9b_0.S[3] sky130_fd_pr__cap_mim_m3_1 l=2 w=2
X3575 single_9b_cdac_0.cdac_sw_9b_0.cdac_sw_3_2.tg_sw_3_3.SWN single_9b_cdac_0.cdac_sw_9b_0.cdac_sw_3_2.nooverlap_clk_0.x10.A VDPWR VDPWR sky130_fd_pr__pfet_01v8 ad=0.168 pd=1.42 as=0.3864 ps=2.93 w=1.12 l=0.15
X3576 sar9b_0.clknet_1_0__leaf_CLK a_6701_20506# VGND VGND sky130_fd_pr__nfet_01v8 ad=0.0588 pd=0.7 as=0.0588 ps=0.7 w=0.42 l=0.15
X3577 single_9b_cdac_0.cdac_sw_9b_0.cdac_sw_3_3.tg_sw_3_3.SWP single_9b_cdac_0.cdac_sw_9b_0.cdac_sw_3_3.tg_sw_3_3.SWN VDPWR VDPWR sky130_fd_pr__pfet_01v8 ad=0.168 pd=1.42 as=0.3864 ps=2.93 w=1.12 l=0.15
X3578 VDPWR VGND VDPWR VDPWR sky130_fd_pr__pfet_01v8_hvt ad=0.2262 pd=2.26 as=0 ps=0 w=0.87 l=0.59
X3579 VGND VDPWR VGND VGND sky130_fd_pr__nfet_01v8 ad=0.143 pd=1.62 as=0 ps=0 w=0.55 l=0.59
X3580 single_9b_cdac_1.cdac_sw_9b_0.cdac_sw_3_8.nooverlap_clk_0.x4.A single_9b_cdac_1.cdac_sw_9b_0.cdac_sw_3_8.nooverlap_clk_0.x1.A a_25915_15495# VGND sky130_fd_pr__nfet_01v8_lvt ad=0.2109 pd=2.05 as=0.0888 ps=0.98 w=0.74 l=0.15
X3581 single_9b_cdac_1.cdac_sw_9b_0.cdac_sw_3_7.tg_sw_3_3.SWP single_9b_cdac_1.cdac_sw_9b_0.cdac_sw_3_7.tg_sw_3_3.SWN VGND VGND sky130_fd_pr__nfet_01v8_lvt ad=0.1036 pd=1.02 as=0.1036 ps=1.02 w=0.74 l=0.15
X3582 VDPWR a_7417_27279# uo_out[7] VDPWR sky130_fd_pr__pfet_01v8_hvt ad=0.11455 pd=1.08 as=0.2054 ps=2.1 w=0.79 l=0.15
X3583 VGND sar9b_0.clknet_1_0__leaf_CLK a_6907_19444# VGND sky130_fd_pr__nfet_01v8 ad=0.07035 pd=0.755 as=0.1113 ps=1.37 w=0.42 l=0.15
X3584 single_9b_cdac_0.cdac_sw_9b_0.S[3] single_9b_cdac_0.cdac_sw_9b_0.cdac_sw_3_4.tg_sw_3_3.SWP single_9b_cdac_0.cdac_sw_9b_0.S[3] VDPWR sky130_fd_pr__pfet_01v8 ad=0.435 pd=3.58 as=6.96 ps=57.28 w=1.5 l=0.5
X3585 th_dif_sw_0.VCN single_9b_cdac_0.cdac_sw_9b_0.S[0] sky130_fd_pr__cap_mim_m3_1 l=2 w=2
X3586 a_11471_26516# a_10955_26516# a_11376_26516# VGND sky130_fd_pr__special_nfet_01v8 ad=0.0594 pd=0.69 as=0.066 ps=0.745 w=0.36 l=0.15
X3587 single_9b_cdac_1.cdac_sw_9b_0.cdac_sw_3_0.nooverlap_clk_0.CLK0 single_9b_cdac_1.cdac_sw_9b_0.cdac_sw_3_0.nooverlap_clk_0.CLKB0 VGND VGND sky130_fd_pr__nfet_01v8_lvt ad=0.1036 pd=1.02 as=0.2109 ps=2.05 w=0.74 l=0.15
X3588 th_dif_sw_0.VCP single_9b_cdac_1.cdac_sw_9b_0.S[2] sky130_fd_pr__cap_mim_m3_1 l=2 w=2
X3589 single_9b_cdac_1.cdac_sw_9b_0.S[8] single_9b_cdac_1.cdac_sw_9b_0.cdac_sw_3_8.tg_sw_3_3.SWP ua[0] VGND sky130_fd_pr__nfet_01v8 ad=0.145 pd=1.58 as=0.145 ps=1.58 w=0.5 l=0.5
X3590 ua[0] single_9b_cdac_1.cdac_sw_9b_0.cdac_sw_3_6.tg_sw_3_3.SWP ua[0] VDPWR sky130_fd_pr__pfet_01v8 ad=0.435 pd=3.58 as=0 ps=0 w=1.5 l=0.5
X3591 a_8868_22708# a_8431_22682# VDPWR VDPWR sky130_fd_pr__pfet_01v8_hvt ad=0.0567 pd=0.69 as=0.0819 ps=0.81 w=0.42 l=0.15
X3592 a_12014_22530# a_10937_22164# a_11852_22164# VDPWR sky130_fd_pr__pfet_01v8_hvt ad=0.0567 pd=0.69 as=0.0588 ps=0.7 w=0.42 l=0.15
X3593 a_6722_21736# sar9b_0._07_ VDPWR VDPWR sky130_fd_pr__pfet_01v8_hvt ad=0.06825 pd=0.745 as=0.14825 ps=1.34 w=0.42 l=0.15
X3594 a_11121_21076# a_10955_21076# VGND VGND sky130_fd_pr__nfet_01v8 ad=0.1092 pd=1.36 as=0.0567 ps=0.69 w=0.42 l=0.15
X3595 a_11855_20532# a_11231_20538# a_11747_20910# VDPWR sky130_fd_pr__pfet_01v8_hvt ad=0.1155 pd=0.97 as=0.07245 ps=0.765 w=0.42 l=0.15
X3596 th_dif_sw_0.VCP single_9b_cdac_1.cdac_sw_9b_0.S[0] sky130_fd_pr__cap_mim_m3_1 l=2 w=2
X3597 th_dif_sw_0.VCN single_9b_cdac_0.cdac_sw_9b_0.S[3] sky130_fd_pr__cap_mim_m3_1 l=2 w=2
X3598 VGND sar9b_0._12_ a_8553_22164# VGND sky130_fd_pr__nfet_01v8 ad=0.169 pd=1.82 as=0.08775 ps=0.92 w=0.65 l=0.15
X3599 VDPWR VGND VDPWR VDPWR sky130_fd_pr__pfet_01v8_hvt ad=0.2262 pd=2.26 as=0 ps=0 w=0.87 l=0.59
X3600 th_dif_sw_0.VCN single_9b_cdac_0.cdac_sw_9b_0.S[0] sky130_fd_pr__cap_mim_m3_1 l=2 w=2
X3601 a_14143_26490# sar9b_0.net15 VDPWR VDPWR sky130_fd_pr__pfet_01v8_hvt ad=0.0567 pd=0.69 as=0.0819 ps=0.81 w=0.42 l=0.15
X3602 a_13308_25428# sar9b_0.net1 VGND VGND sky130_fd_pr__nfet_01v8 ad=0.066 pd=0.745 as=0.2205 ps=1.89 w=0.42 l=0.15
X3603 dw_12589_1395# a_10166_3438# sky130_fd_pr__cap_mim_m3_1 l=2 w=2
X3604 single_9b_cdac_0.cdac_sw_9b_0.cdac_sw_3_5.nooverlap_clk_0.sky130_fd_sc_hs__nand2_1_0.Y single_9b_cdac_1.CF[5] a_41357_29911# VGND sky130_fd_pr__nfet_01v8_lvt ad=0.2109 pd=2.05 as=0.0888 ps=0.98 w=0.74 l=0.15
X3605 VGND sar9b_0.net3 a_7317_26338# VGND sky130_fd_pr__nfet_01v8 ad=0.1346 pd=1.15 as=0.0441 ps=0.63 w=0.42 l=0.15
X3606 VDPWR a_7345_21594# sar9b_0.clknet_0_CLK VDPWR sky130_fd_pr__pfet_01v8_hvt ad=0.1375 pd=1.275 as=0.14 ps=1.28 w=1 l=0.15
X3607 VDPWR VGND VDPWR VDPWR sky130_fd_pr__pfet_01v8_hvt ad=0.2262 pd=2.26 as=0 ps=0 w=0.87 l=0.59
X3608 VDPWR single_9b_cdac_1.cdac_sw_9b_0.cdac_sw_3_5.nooverlap_clk_0.x1.A single_9b_cdac_1.cdac_sw_9b_0.cdac_sw_3_5.nooverlap_clk_0.sky130_fd_sc_hs__inv_8_0.A VDPWR sky130_fd_pr__pfet_01v8 ad=0.3304 pd=2.83 as=0.168 ps=1.42 w=1.12 l=0.15
X3609 single_9b_cdac_1.cdac_sw_9b_0.cdac_sw_3_0.nooverlap_clk_0.x10.A single_9b_cdac_1.cdac_sw_9b_0.cdac_sw_3_0.nooverlap_clk_0.x8.A VGND VGND sky130_fd_pr__nfet_01v8_lvt ad=0.1036 pd=1.02 as=0.1221 ps=1.07 w=0.74 l=0.15
X3610 single_9b_cdac_0.cdac_sw_9b_0.cdac_sw_3_5.nooverlap_clk_0.CLK0 single_9b_cdac_0.cdac_sw_9b_0.cdac_sw_3_5.nooverlap_clk_0.CLKB0 VGND VGND sky130_fd_pr__nfet_01v8_lvt ad=0.1036 pd=1.02 as=0.1036 ps=1.02 w=0.74 l=0.15
X3611 VDPWR single_9b_cdac_0.cdac_sw_9b_0.cdac_sw_3_5.nooverlap_clk_0.CLKB0 single_9b_cdac_0.cdac_sw_9b_0.cdac_sw_3_5.nooverlap_clk_0.CLK0 VDPWR sky130_fd_pr__pfet_01v8 ad=0.196 pd=1.47 as=0.168 ps=1.42 w=1.12 l=0.15
X3612 a_14077_23086# a_12887_22714# a_13968_23086# VGND sky130_fd_pr__special_nfet_01v8 ad=0.0669 pd=0.75 as=0.0711 ps=0.755 w=0.36 l=0.15
X3613 a_63626_26990# single_9b_cdac_0.cdac_sw_9b_0.cdac_sw_3_2.nooverlap_clk_0.CLK0 single_9b_cdac_0.cdac_sw_9b_0.S[0] VGND sky130_fd_pr__nfet_01v8 ad=0.145 pd=1.58 as=0.145 ps=1.58 w=0.5 l=0.5
X3614 sar9b_0.clknet_1_1__leaf_CLK a_6149_23770# VDPWR VDPWR sky130_fd_pr__pfet_01v8_hvt ad=0.14 pd=1.28 as=0.14 ps=1.28 w=1 l=0.15
X3615 single_9b_cdac_1.cdac_sw_9b_0.cdac_sw_3_6.nooverlap_clk_0.CLK0 single_9b_cdac_1.cdac_sw_9b_0.cdac_sw_3_6.nooverlap_clk_0.CLKB0 VGND VGND sky130_fd_pr__nfet_01v8_lvt ad=0.1036 pd=1.02 as=0.1295 ps=1.09 w=0.74 l=0.15
X3616 dw_12589_1395# a_10166_3438# sky130_fd_pr__cap_mim_m3_1 l=2 w=2
X3617 th_dif_sw_0.VCP single_9b_cdac_1.cdac_sw_9b_0.S[0] sky130_fd_pr__cap_mim_m3_1 l=2 w=2
X3618 th_dif_sw_0.VCN single_9b_cdac_0.cdac_sw_9b_0.S[0] sky130_fd_pr__cap_mim_m3_1 l=2 w=2
X3619 single_9b_cdac_1.cdac_sw_9b_0.S[0] single_9b_cdac_1.cdac_sw_9b_0.cdac_sw_3_2.tg_sw_3_3.SWP ua[0] VGND sky130_fd_pr__nfet_01v8 ad=0.145 pd=1.58 as=0.145 ps=1.58 w=0.5 l=0.5
X3620 single_9b_cdac_0.cdac_sw_9b_0.S[7] single_9b_cdac_0.cdac_sw_9b_0.cdac_sw_3_7.tg_sw_3_3.SWP single_9b_cdac_0.cdac_sw_9b_0.S[7] VDPWR sky130_fd_pr__pfet_01v8 ad=0.435 pd=3.58 as=0 ps=0 w=1.5 l=0.5
X3621 VDPWR single_9b_cdac_0.cdac_sw_9b_0.cdac_sw_3_2.nooverlap_clk_0.CLKB0 single_9b_cdac_0.cdac_sw_9b_0.cdac_sw_3_2.nooverlap_clk_0.CLK0 VDPWR sky130_fd_pr__pfet_01v8 ad=0.196 pd=1.47 as=0.168 ps=1.42 w=1.12 l=0.15
X3622 single_9b_cdac_0.cdac_sw_9b_0.cdac_sw_3_0.tg_sw_3_3.SWP single_9b_cdac_0.cdac_sw_9b_0.cdac_sw_3_0.tg_sw_3_3.SWN VGND VGND sky130_fd_pr__nfet_01v8_lvt ad=0.1036 pd=1.02 as=0.1554 ps=1.16 w=0.74 l=0.15
X3623 single_9b_cdac_1.cdac_sw_9b_0.cdac_sw_3_5.nooverlap_clk_0.sky130_fd_sc_hs__inv_8_0.A single_9b_cdac_1.cdac_sw_9b_0.cdac_sw_3_5.nooverlap_clk_0.x1.A VDPWR VDPWR sky130_fd_pr__pfet_01v8 ad=0.168 pd=1.42 as=0.168 ps=1.42 w=1.12 l=0.15
X3624 VDPWR VGND VDPWR VDPWR sky130_fd_pr__pfet_01v8_hvt ad=0.2262 pd=2.26 as=0 ps=0 w=0.87 l=0.59
X3625 a_7151_26350# a_6705_25978# a_7055_26350# VGND sky130_fd_pr__special_nfet_01v8 ad=0.1401 pd=1.1 as=0.0594 ps=0.69 w=0.36 l=0.15
X3626 a_6417_19822# a_5870_19566# a_6070_19721# VDPWR sky130_fd_pr__pfet_01v8_hvt ad=0.05775 pd=0.695 as=0.06825 ps=0.745 w=0.42 l=0.15
X3627 single_9b_cdac_1.cdac_sw_9b_0.cdac_sw_3_0.tg_sw_3_3.SWN single_9b_cdac_1.cdac_sw_9b_0.cdac_sw_3_0.nooverlap_clk_0.x10.A VGND VGND sky130_fd_pr__nfet_01v8_lvt ad=0.1036 pd=1.02 as=0.1295 ps=1.09 w=0.74 l=0.15
X3628 th_dif_sw_0.VCP single_9b_cdac_1.cdac_sw_9b_0.S[0] sky130_fd_pr__cap_mim_m3_1 l=2 w=2
X3629 single_9b_cdac_0.cdac_sw_9b_0.cdac_sw_3_2.nooverlap_clk_0.CLK0 single_9b_cdac_0.cdac_sw_9b_0.cdac_sw_3_2.nooverlap_clk_0.CLKB0 VDPWR VDPWR sky130_fd_pr__pfet_01v8 ad=0.168 pd=1.42 as=0.168 ps=1.42 w=1.12 l=0.15
X3630 VGND single_9b_cdac_1.cdac_sw_9b_0.cdac_sw_3_2.nooverlap_clk_0.x8.A single_9b_cdac_1.cdac_sw_9b_0.cdac_sw_3_2.nooverlap_clk_0.x10.A VGND sky130_fd_pr__nfet_01v8_lvt ad=0.2109 pd=2.05 as=0.1036 ps=1.02 w=0.74 l=0.15
X3631 VDPWR single_9b_cdac_0.cdac_sw_9b_0.cdac_sw_3_0.nooverlap_clk_0.x10.A single_9b_cdac_0.cdac_sw_9b_0.cdac_sw_3_0.tg_sw_3_3.SWN VDPWR sky130_fd_pr__pfet_01v8 ad=0.196 pd=1.47 as=0.168 ps=1.42 w=1.12 l=0.15
X3632 VDPWR single_9b_cdac_1.cdac_sw_9b_0.cdac_sw_3_5.nooverlap_clk_0.x1.A single_9b_cdac_1.cdac_sw_9b_0.cdac_sw_3_5.nooverlap_clk_0.sky130_fd_sc_hs__inv_8_0.A VDPWR sky130_fd_pr__pfet_01v8 ad=0.168 pd=1.42 as=0.168 ps=1.42 w=1.12 l=0.15
X3633 VGND single_9b_cdac_1.cdac_sw_9b_0.cdac_sw_3_4.nooverlap_clk_0.sky130_fd_sc_hs__inv_8_0.A single_9b_cdac_1.cdac_sw_9b_0.cdac_sw_3_4.nooverlap_clk_0.CLKB0 VGND sky130_fd_pr__nfet_01v8_lvt ad=0.1036 pd=1.02 as=0.1036 ps=1.02 w=0.74 l=0.15
X3634 VDPWR a_11567_23226# a_11554_23618# VDPWR sky130_fd_pr__pfet_01v8_hvt ad=0.0819 pd=0.81 as=0.0567 ps=0.69 w=0.42 l=0.15
X3635 single_9b_cdac_0.cdac_sw_9b_0.S[0] single_9b_cdac_0.cdac_sw_9b_0.cdac_sw_3_2.tg_sw_3_3.SWN ua[0] VDPWR sky130_fd_pr__pfet_01v8 ad=0.435 pd=3.58 as=0.435 ps=3.58 w=1.5 l=0.5
X3636 VDPWR VGND VDPWR VDPWR sky130_fd_pr__pfet_01v8_hvt ad=0.2262 pd=2.26 as=0 ps=0 w=0.87 l=0.59
X3637 a_7925_23502# sar9b_0.clk_div_0.COUNT\[1\] sar9b_0._11_ VDPWR sky130_fd_pr__pfet_01v8_hvt ad=0.105 pd=1.21 as=0.174 ps=1.39 w=1 l=0.15
X3638 th_dif_sw_0.VCP single_9b_cdac_1.cdac_sw_9b_0.S[0] sky130_fd_pr__cap_mim_m3_1 l=2 w=2
X3639 single_9b_cdac_0.cdac_sw_9b_0.cdac_sw_3_0.tg_sw_3_3.SWN single_9b_cdac_0.cdac_sw_9b_0.cdac_sw_3_0.nooverlap_clk_0.x10.A VDPWR VDPWR sky130_fd_pr__pfet_01v8 ad=0.168 pd=1.42 as=0.168 ps=1.42 w=1.12 l=0.15
X3640 VDPWR single_9b_cdac_0.cdac_sw_9b_0.cdac_sw_3_2.nooverlap_clk_0.CLKB0 single_9b_cdac_0.cdac_sw_9b_0.cdac_sw_3_2.nooverlap_clk_0.CLK0 VDPWR sky130_fd_pr__pfet_01v8 ad=0.168 pd=1.42 as=0.168 ps=1.42 w=1.12 l=0.15
X3641 VGND a_6701_20506# sar9b_0.clknet_1_0__leaf_CLK VGND sky130_fd_pr__nfet_01v8 ad=0.0588 pd=0.7 as=0.0588 ps=0.7 w=0.42 l=0.15
X3642 th_dif_sw_0.VCP single_9b_cdac_1.cdac_sw_9b_0.S[0] sky130_fd_pr__cap_mim_m3_1 l=2 w=2
X3643 single_9b_cdac_1.cdac_sw_9b_0.cdac_sw_3_5.nooverlap_clk_0.sky130_fd_sc_hs__inv_8_0.A single_9b_cdac_1.cdac_sw_9b_0.cdac_sw_3_5.nooverlap_clk_0.x1.A VDPWR VDPWR sky130_fd_pr__pfet_01v8 ad=0.168 pd=1.42 as=0.3304 ps=2.83 w=1.12 l=0.15
X3644 VGND single_9b_cdac_1.cdac_sw_9b_0.cdac_sw_3_2.nooverlap_clk_0.x10.A single_9b_cdac_1.cdac_sw_9b_0.cdac_sw_3_2.tg_sw_3_3.SWN VGND sky130_fd_pr__nfet_01v8_lvt ad=0.1554 pd=1.16 as=0.1036 ps=1.02 w=0.74 l=0.15
X3645 VDPWR single_9b_cdac_1.cdac_sw_9b_0.cdac_sw_3_1.tg_sw_3_3.SWN single_9b_cdac_1.cdac_sw_9b_0.cdac_sw_3_1.tg_sw_3_3.SWP VDPWR sky130_fd_pr__pfet_01v8 ad=0.3864 pd=2.93 as=0.168 ps=1.42 w=1.12 l=0.15
X3646 single_9b_cdac_0.cdac_sw_9b_0.S[7] single_9b_cdac_0.cdac_sw_9b_0.cdac_sw_3_7.tg_sw_3_3.SWP ua[0] VGND sky130_fd_pr__nfet_01v8 ad=0.145 pd=1.58 as=0.145 ps=1.58 w=0.5 l=0.5
X3647 single_9b_cdac_1.CF[4] a_14451_21620# VGND VGND sky130_fd_pr__nfet_01v8 ad=0.1352 pd=1.56 as=0.0754 ps=0.81 w=0.52 l=0.15
X3648 VGND single_9b_cdac_0.cdac_sw_9b_0.cdac_sw_3_4.tg_sw_3_3.SWN single_9b_cdac_0.cdac_sw_9b_0.cdac_sw_3_4.tg_sw_3_3.SWP VGND sky130_fd_pr__nfet_01v8_lvt ad=0.1554 pd=1.16 as=0.1036 ps=1.02 w=0.74 l=0.15
X3649 VDPWR single_9b_cdac_0.cdac_sw_9b_0.cdac_sw_3_0.nooverlap_clk_0.x10.A single_9b_cdac_0.cdac_sw_9b_0.cdac_sw_3_0.tg_sw_3_3.SWN VDPWR sky130_fd_pr__pfet_01v8 ad=0.168 pd=1.42 as=0.168 ps=1.42 w=1.12 l=0.15
X3650 VDPWR a_11505_22406# a_11395_22530# VDPWR sky130_fd_pr__pfet_01v8_hvt ad=0.07035 pd=0.755 as=0.1155 ps=0.97 w=0.42 l=0.15
X3651 th_dif_sw_0.VCP single_9b_cdac_1.cdac_sw_9b_0.S[0] sky130_fd_pr__cap_mim_m3_1 l=2 w=2
X3652 single_9b_cdac_1.cdac_sw_9b_0.cdac_sw_3_1.tg_sw_3_3.SWP single_9b_cdac_1.cdac_sw_9b_0.cdac_sw_3_1.tg_sw_3_3.SWN VDPWR VDPWR sky130_fd_pr__pfet_01v8 ad=0.168 pd=1.42 as=0.196 ps=1.47 w=1.12 l=0.15
X3653 a_6537_25670# a_6319_25428# VDPWR VDPWR sky130_fd_pr__pfet_01v8_hvt ad=0.12915 pd=1.185 as=0.2184 ps=2.2 w=0.84 l=0.15
X3654 a_12036_18900# a_10955_18900# a_11689_19142# VDPWR sky130_fd_pr__pfet_01v8_hvt ad=0.0588 pd=0.7 as=0.12915 ps=1.185 w=0.42 l=0.15
X3655 single_9b_cdac_1.cdac_sw_9b_0.cdac_sw_3_0.nooverlap_clk_0.sky130_fd_sc_hs__inv_1_1.A single_9b_cdac_1.cdac_sw_9b_0.cdac_sw_3_0.nooverlap_clk_0.sky130_fd_sc_hs__nand2_1_0.Y VGND VGND sky130_fd_pr__nfet_01v8_lvt ad=0.2109 pd=2.05 as=0.2627 ps=2.19 w=0.74 l=0.15
X3656 single_9b_cdac_1.cdac_sw_9b_0.cdac_sw_3_3.nooverlap_clk_0.CLK0 single_9b_cdac_1.cdac_sw_9b_0.cdac_sw_3_3.nooverlap_clk_0.CLKB0 VGND VGND sky130_fd_pr__nfet_01v8_lvt ad=0.1036 pd=1.02 as=0.2109 ps=2.05 w=0.74 l=0.15
X3657 ua[0] single_9b_cdac_1.cdac_sw_9b_0.cdac_sw_3_2.tg_sw_3_3.SWN ua[0] VGND sky130_fd_pr__nfet_01v8 ad=0.145 pd=1.58 as=0 ps=0 w=0.5 l=0.5
X3658 sar9b_0.net39 a_12211_21050# VGND VGND sky130_fd_pr__nfet_01v8 ad=0.169 pd=1.82 as=0.2087 ps=2.02 w=0.65 l=0.15
X3659 single_9b_cdac_1.cdac_sw_9b_0.S[3] single_9b_cdac_1.cdac_sw_9b_0.cdac_sw_3_4.tg_sw_3_3.SWP single_9b_cdac_1.cdac_sw_9b_0.S[3] VDPWR sky130_fd_pr__pfet_01v8 ad=0.435 pd=3.58 as=0 ps=0 w=1.5 l=0.5
X3660 VGND single_9b_cdac_0.cdac_sw_9b_0.cdac_sw_3_2.nooverlap_clk_0.x1.A single_9b_cdac_0.cdac_sw_9b_0.cdac_sw_3_2.nooverlap_clk_0.sky130_fd_sc_hs__inv_8_0.A VGND sky130_fd_pr__nfet_01v8_lvt ad=0.2331 pd=2.11 as=0.1184 ps=1.06 w=0.74 l=0.15
X3661 VGND VDPWR VGND VGND sky130_fd_pr__nfet_01v8 ad=0.143 pd=1.62 as=0 ps=0 w=0.55 l=0.59
X3662 VDPWR single_9b_cdac_1.cdac_sw_9b_0.cdac_sw_3_8.tg_sw_3_3.SWN single_9b_cdac_1.cdac_sw_9b_0.cdac_sw_3_8.tg_sw_3_3.SWP VDPWR sky130_fd_pr__pfet_01v8 ad=0.196 pd=1.47 as=0.168 ps=1.42 w=1.12 l=0.15
X3663 VDPWR single_9b_cdac_0.cdac_sw_9b_0.cdac_sw_3_4.tg_sw_3_3.SWN single_9b_cdac_0.cdac_sw_9b_0.cdac_sw_3_4.tg_sw_3_3.SWP VDPWR sky130_fd_pr__pfet_01v8 ad=0.3304 pd=2.83 as=0.168 ps=1.42 w=1.12 l=0.15
X3664 VGND VDPWR VGND VGND sky130_fd_pr__nfet_01v8 ad=0.143 pd=1.62 as=0 ps=0 w=0.55 l=0.59
X3665 a_13494_18722# sar9b_0.net15 VGND VGND sky130_fd_pr__nfet_01v8 ad=0.06405 pd=0.725 as=0.12495 ps=1.015 w=0.42 l=0.15
X3666 VGND single_9b_cdac_1.cdac_sw_9b_0.cdac_sw_3_4.nooverlap_clk_0.x8.A single_9b_cdac_1.cdac_sw_9b_0.cdac_sw_3_4.nooverlap_clk_0.x10.A VGND sky130_fd_pr__nfet_01v8_lvt ad=0.1221 pd=1.07 as=0.1184 ps=1.06 w=0.74 l=0.15
X3667 th_dif_sw_0.VCN single_9b_cdac_0.cdac_sw_9b_0.S[0] sky130_fd_pr__cap_mim_m3_1 l=2 w=2
X3668 th_dif_sw_0.VCN single_9b_cdac_0.cdac_sw_9b_0.S[0] sky130_fd_pr__cap_mim_m3_1 l=2 w=2
X3669 VGND single_9b_cdac_0.cdac_sw_9b_0.cdac_sw_3_8.nooverlap_clk_0.x10.A single_9b_cdac_0.cdac_sw_9b_0.cdac_sw_3_8.tg_sw_3_3.SWN VGND sky130_fd_pr__nfet_01v8_lvt ad=0.1295 pd=1.09 as=0.1036 ps=1.02 w=0.74 l=0.15
X3670 VDPWR a_6149_23770# sar9b_0.clknet_1_1__leaf_CLK VDPWR sky130_fd_pr__pfet_01v8_hvt ad=0.14 pd=1.28 as=0.14 ps=1.28 w=1 l=0.15
X3671 single_9b_cdac_1.cdac_sw_9b_0.cdac_sw_3_8.tg_sw_3_3.SWP single_9b_cdac_1.cdac_sw_9b_0.cdac_sw_3_8.tg_sw_3_3.SWN VDPWR VDPWR sky130_fd_pr__pfet_01v8 ad=0.168 pd=1.42 as=0.168 ps=1.42 w=1.12 l=0.15
X3672 single_9b_cdac_0.cdac_sw_9b_0.cdac_sw_3_4.tg_sw_3_3.SWP single_9b_cdac_0.cdac_sw_9b_0.cdac_sw_3_4.tg_sw_3_3.SWN VDPWR VDPWR sky130_fd_pr__pfet_01v8 ad=0.168 pd=1.42 as=0.196 ps=1.47 w=1.12 l=0.15
X3673 a_11935_25402# a_11760_25428# a_12114_25428# VGND sky130_fd_pr__nfet_01v8 ad=0.1092 pd=1.36 as=0.06405 ps=0.725 w=0.42 l=0.15
X3674 a_43540_16877# single_9b_cdac_1.SW[4] VDPWR VDPWR sky130_fd_pr__pfet_01v8 ad=0.435 pd=3.58 as=0.435 ps=3.58 w=1.5 l=0.5
X3675 VDPWR a_6149_23770# sar9b_0.clknet_1_1__leaf_CLK VDPWR sky130_fd_pr__pfet_01v8_hvt ad=0.14 pd=1.28 as=0.14 ps=1.28 w=1 l=0.15
X3676 a_12027_22138# a_11852_22164# a_12206_22164# VGND sky130_fd_pr__nfet_01v8 ad=0.1092 pd=1.36 as=0.06405 ps=0.725 w=0.42 l=0.15
X3677 a_8911_19444# sar9b_0.net15 VDPWR VDPWR sky130_fd_pr__pfet_01v8_hvt ad=0.1092 pd=1.36 as=0.07035 ps=0.755 w=0.42 l=0.15
X3678 VGND single_9b_cdac_1.cdac_sw_9b_0.cdac_sw_3_7.nooverlap_clk_0.x1.A single_9b_cdac_1.cdac_sw_9b_0.cdac_sw_3_7.nooverlap_clk_0.sky130_fd_sc_hs__inv_8_0.A VGND sky130_fd_pr__nfet_01v8_lvt ad=0.2109 pd=2.05 as=0.1036 ps=1.02 w=0.74 l=0.15
X3679 VDPWR single_9b_cdac_1.cdac_sw_9b_0.cdac_sw_3_6.nooverlap_clk_0.sky130_fd_sc_hs__inv_8_0.A single_9b_cdac_1.cdac_sw_9b_0.cdac_sw_3_6.nooverlap_clk_0.CLKB0 VDPWR sky130_fd_pr__pfet_01v8 ad=0.196 pd=1.47 as=0.168 ps=1.42 w=1.12 l=0.15
X3680 ua[0] single_9b_cdac_1.cdac_sw_9b_0.cdac_sw_3_4.tg_sw_3_3.SWP ua[0] VDPWR sky130_fd_pr__pfet_01v8 ad=0.435 pd=3.58 as=0 ps=0 w=1.5 l=0.5
X3681 th_dif_sw_0.VCN single_9b_cdac_0.cdac_sw_9b_0.S[1] sky130_fd_pr__cap_mim_m3_1 l=2 w=2
X3682 th_dif_sw_0.VCN single_9b_cdac_0.cdac_sw_9b_0.S[0] sky130_fd_pr__cap_mim_m3_1 l=2 w=2
X3683 VDPWR single_9b_cdac_0.cdac_sw_9b_0.cdac_sw_3_3.nooverlap_clk_0.x6.A single_9b_cdac_0.cdac_sw_9b_0.cdac_sw_3_3.nooverlap_clk_0.x8.A VDPWR sky130_fd_pr__pfet_01v8 ad=0.3864 pd=2.93 as=0.3304 ps=2.83 w=1.12 l=0.15
X3684 a_49926_29917# single_9b_cdac_0.cdac_sw_9b_0.cdac_sw_3_4.nooverlap_clk_0.x1.A single_9b_cdac_0.cdac_sw_9b_0.cdac_sw_3_4.nooverlap_clk_0.x4.A VGND sky130_fd_pr__nfet_01v8_lvt ad=0.0888 pd=0.98 as=0.2109 ps=2.05 w=0.74 l=0.15
X3685 th_dif_sw_0.VCP single_9b_cdac_1.cdac_sw_9b_0.S[1] sky130_fd_pr__cap_mim_m3_1 l=2 w=2
X3686 th_dif_sw_0.VCN single_9b_cdac_0.cdac_sw_9b_0.S[1] sky130_fd_pr__cap_mim_m3_1 l=2 w=2
X3687 VDPWR sar9b_0.net4 a_10955_18900# VDPWR sky130_fd_pr__pfet_01v8_hvt ad=0.0864 pd=0.91 as=0.1664 ps=1.8 w=0.64 l=0.15
X3688 VGND VDPWR VGND VGND sky130_fd_pr__nfet_01v8 ad=0.143 pd=1.62 as=0 ps=0 w=0.55 l=0.59
X3689 VDPWR single_9b_cdac_1.cdac_sw_9b_0.cdac_sw_3_8.tg_sw_3_3.SWN single_9b_cdac_1.cdac_sw_9b_0.cdac_sw_3_8.tg_sw_3_3.SWP VDPWR sky130_fd_pr__pfet_01v8 ad=0.168 pd=1.42 as=0.168 ps=1.42 w=1.12 l=0.15
X3690 single_9b_cdac_0.cdac_sw_9b_0.cdac_sw_3_1.nooverlap_clk_0.CLKB0 single_9b_cdac_0.cdac_sw_9b_0.cdac_sw_3_1.nooverlap_clk_0.sky130_fd_sc_hs__inv_8_0.A VGND VGND sky130_fd_pr__nfet_01v8_lvt ad=0.1036 pd=1.02 as=0.2146 ps=2.06 w=0.74 l=0.15
X3691 a_8545_24340# a_8379_24340# VGND VGND sky130_fd_pr__nfet_01v8 ad=0.1092 pd=1.36 as=0.0567 ps=0.69 w=0.42 l=0.15
X3692 VDPWR VGND VDPWR VDPWR sky130_fd_pr__pfet_01v8_hvt ad=0.2262 pd=2.26 as=0 ps=0 w=0.87 l=0.59
X3693 single_9b_cdac_1.cdac_sw_9b_0.S[1] single_9b_cdac_1.cdac_sw_9b_0.cdac_sw_3_1.tg_sw_3_3.SWN single_9b_cdac_1.cdac_sw_9b_0.S[1] VGND sky130_fd_pr__nfet_01v8 ad=0.145 pd=1.58 as=0 ps=0 w=0.5 l=0.5
X3694 th_dif_sw_0.VCP single_9b_cdac_1.cdac_sw_9b_0.S[1] sky130_fd_pr__cap_mim_m3_1 l=2 w=2
X3695 single_9b_cdac_1.cdac_sw_9b_0.cdac_sw_3_4.tg_sw_3_3.SWN single_9b_cdac_1.cdac_sw_9b_0.cdac_sw_3_4.nooverlap_clk_0.x10.A VGND VGND sky130_fd_pr__nfet_01v8_lvt ad=0.1036 pd=1.02 as=0.1036 ps=1.02 w=0.74 l=0.15
X3696 th_dif_sw_0.VCN single_9b_cdac_0.cdac_sw_9b_0.S[2] sky130_fd_pr__cap_mim_m3_1 l=2 w=2
X3697 single_9b_cdac_1.cdac_sw_9b_0.cdac_sw_3_8.nooverlap_clk_0.CLK0 single_9b_cdac_1.cdac_sw_9b_0.cdac_sw_3_8.nooverlap_clk_0.CLKB0 VGND VGND sky130_fd_pr__nfet_01v8_lvt ad=0.1036 pd=1.02 as=0.1554 ps=1.16 w=0.74 l=0.15
X3698 VGND single_9b_cdac_1.cdac_sw_9b_0.cdac_sw_3_7.nooverlap_clk_0.sky130_fd_sc_hs__inv_8_0.A single_9b_cdac_1.cdac_sw_9b_0.cdac_sw_3_7.nooverlap_clk_0.CLKB0 VGND sky130_fd_pr__nfet_01v8_lvt ad=0.1554 pd=1.16 as=0.1036 ps=1.02 w=0.74 l=0.15
X3699 single_9b_cdac_1.CF[5] a_13623_23252# VGND VGND sky130_fd_pr__nfet_01v8 ad=0.1352 pd=1.56 as=0.0754 ps=0.81 w=0.52 l=0.15
X3700 single_9b_cdac_1.cdac_sw_9b_0.cdac_sw_3_8.tg_sw_3_3.SWP single_9b_cdac_1.cdac_sw_9b_0.cdac_sw_3_8.tg_sw_3_3.SWN VDPWR VDPWR sky130_fd_pr__pfet_01v8 ad=0.168 pd=1.42 as=0.196 ps=1.47 w=1.12 l=0.15
X3701 single_9b_cdac_1.cdac_sw_9b_0.S[6] single_9b_cdac_1.cdac_sw_9b_0.cdac_sw_3_6.tg_sw_3_3.SWN single_9b_cdac_1.cdac_sw_9b_0.S[6] VGND sky130_fd_pr__nfet_01v8 ad=0.145 pd=1.58 as=0 ps=0 w=0.5 l=0.5
X3702 single_9b_cdac_1.cdac_sw_9b_0.cdac_sw_3_5.nooverlap_clk_0.x4.A single_9b_cdac_1.cdac_sw_9b_0.cdac_sw_3_5.nooverlap_clk_0.x1.A a_40321_15495# VGND sky130_fd_pr__nfet_01v8_lvt ad=0.2109 pd=2.05 as=0.0888 ps=0.98 w=0.74 l=0.15
X3703 th_dif_sw_0.VCN single_9b_cdac_0.cdac_sw_9b_0.S[0] sky130_fd_pr__cap_mim_m3_1 l=2 w=2
X3704 VDPWR VGND VDPWR VDPWR sky130_fd_pr__pfet_01v8_hvt ad=0.2262 pd=2.26 as=0 ps=0 w=0.87 l=0.59
X3705 VDPWR a_13621_20230# a_13511_20354# VDPWR sky130_fd_pr__pfet_01v8_hvt ad=0.07035 pd=0.755 as=0.1155 ps=0.97 w=0.42 l=0.15
X3706 VGND VDPWR VGND VGND sky130_fd_pr__nfet_01v8 ad=0.143 pd=1.62 as=0 ps=0 w=0.55 l=0.59
X3707 th_dif_sw_0.VCP single_9b_cdac_1.cdac_sw_9b_0.S[0] sky130_fd_pr__cap_mim_m3_1 l=2 w=2
X3708 single_9b_cdac_0.cdac_sw_9b_0.cdac_sw_3_0.nooverlap_clk_0.sky130_fd_sc_hs__inv_8_0.A single_9b_cdac_0.cdac_sw_9b_0.cdac_sw_3_0.nooverlap_clk_0.x1.A VGND VGND sky130_fd_pr__nfet_01v8_lvt ad=0.1036 pd=1.02 as=0.2109 ps=2.05 w=0.74 l=0.15
X3709 th_dif_sw_0.VCP single_9b_cdac_1.cdac_sw_9b_0.S[1] sky130_fd_pr__cap_mim_m3_1 l=2 w=2
X3710 VDPWR single_9b_cdac_0.cdac_sw_9b_0.cdac_sw_3_7.tg_sw_3_3.SWN single_9b_cdac_0.cdac_sw_9b_0.cdac_sw_3_7.tg_sw_3_3.SWP VDPWR sky130_fd_pr__pfet_01v8 ad=0.196 pd=1.47 as=0.168 ps=1.42 w=1.12 l=0.15
X3711 single_9b_cdac_0.cdac_sw_9b_0.S[1] single_9b_cdac_0.cdac_sw_9b_0.cdac_sw_3_1.tg_sw_3_3.SWP ua[0] VGND sky130_fd_pr__nfet_01v8 ad=0.145 pd=1.58 as=0.145 ps=1.58 w=0.5 l=0.5
X3712 single_9b_cdac_1.cdac_sw_9b_0.cdac_sw_3_8.tg_sw_3_3.SWN single_9b_cdac_1.cdac_sw_9b_0.cdac_sw_3_8.nooverlap_clk_0.x10.A VGND VGND sky130_fd_pr__nfet_01v8_lvt ad=0.1036 pd=1.02 as=0.2109 ps=2.05 w=0.74 l=0.15
X3713 single_9b_cdac_1.cdac_sw_9b_0.S[7] single_9b_cdac_1.cdac_sw_9b_0.cdac_sw_3_7.tg_sw_3_3.SWP ua[0] VGND sky130_fd_pr__nfet_01v8 ad=0.145 pd=1.58 as=0.145 ps=1.58 w=0.5 l=0.5
X3714 sar9b_0._03_ sar9b_0.clk_div_0.COUNT\[0\] a_6714_24340# VGND sky130_fd_pr__nfet_01v8 ad=0.091 pd=0.93 as=0.09588 ps=0.945 w=0.65 l=0.15
X3715 VGND a_13315_18660# a_13249_18734# VGND sky130_fd_pr__nfet_01v8 ad=0.12495 pd=1.015 as=0.0669 ps=0.75 w=0.42 l=0.15
X3716 VDPWR a_12211_26490# a_12198_26882# VDPWR sky130_fd_pr__pfet_01v8_hvt ad=0.0819 pd=0.81 as=0.0567 ps=0.69 w=0.42 l=0.15
X3717 VDPWR single_9b_cdac_1.cdac_sw_9b_0.cdac_sw_3_8.nooverlap_clk_0.sky130_fd_sc_hs__inv_8_0.A single_9b_cdac_1.cdac_sw_9b_0.cdac_sw_3_8.nooverlap_clk_0.CLKB0 VDPWR sky130_fd_pr__pfet_01v8 ad=0.3864 pd=2.93 as=0.168 ps=1.42 w=1.12 l=0.15
X3718 VDPWR single_9b_cdac_0.cdac_sw_9b_0.cdac_sw_3_5.nooverlap_clk_0.x8.A single_9b_cdac_0.cdac_sw_9b_0.cdac_sw_3_5.nooverlap_clk_0.x10.A VDPWR sky130_fd_pr__pfet_01v8 ad=0.3304 pd=2.83 as=0.168 ps=1.42 w=1.12 l=0.15
X3719 VDPWR a_12036_18900# a_12211_18874# VDPWR sky130_fd_pr__pfet_01v8_hvt ad=0.1134 pd=1.38 as=0.0567 ps=0.69 w=0.42 l=0.15
X3720 dw_12589_1395# a_10166_3438# sky130_fd_pr__cap_mim_m3_1 l=2 w=2
X3721 single_9b_cdac_0.cdac_sw_9b_0.S[6] single_9b_cdac_0.cdac_sw_9b_0.cdac_sw_3_6.tg_sw_3_3.SWP ua[0] VGND sky130_fd_pr__nfet_01v8 ad=0.145 pd=1.58 as=0.145 ps=1.58 w=0.5 l=0.5
X3722 single_9b_cdac_0.cdac_sw_9b_0.cdac_sw_3_7.tg_sw_3_3.SWP single_9b_cdac_0.cdac_sw_9b_0.cdac_sw_3_7.tg_sw_3_3.SWN VDPWR VDPWR sky130_fd_pr__pfet_01v8 ad=0.168 pd=1.42 as=0.168 ps=1.42 w=1.12 l=0.15
X3723 th_dif_sw_0.VCN single_9b_cdac_0.cdac_sw_9b_0.S[0] sky130_fd_pr__cap_mim_m3_1 l=2 w=2
X3724 single_9b_cdac_0.cdac_sw_9b_0.cdac_sw_3_3.tg_sw_3_3.SWP single_9b_cdac_0.cdac_sw_9b_0.cdac_sw_3_3.tg_sw_3_3.SWN VGND VGND sky130_fd_pr__nfet_01v8_lvt ad=0.1036 pd=1.02 as=0.1036 ps=1.02 w=0.74 l=0.15
X3725 a_6778_22682# a_6610_22708# VGND VGND sky130_fd_pr__nfet_01v8 ad=0.0989 pd=0.995 as=0.12095 ps=1.085 w=0.64 l=0.15
X3726 VDPWR sar9b_0._08_ a_5884_21326# VDPWR sky130_fd_pr__pfet_01v8_hvt ad=0.3275 pd=1.655 as=0.195 ps=1.39 w=1 l=0.15
X3727 single_9b_cdac_1.cdac_sw_9b_0.cdac_sw_3_3.nooverlap_clk_0.sky130_fd_sc_hs__inv_1_1.A single_9b_cdac_1.cdac_sw_9b_0.cdac_sw_3_3.nooverlap_clk_0.sky130_fd_sc_hs__nand2_1_0.Y VGND VGND sky130_fd_pr__nfet_01v8_lvt ad=0.2109 pd=2.05 as=0.2627 ps=2.19 w=0.74 l=0.15
X3728 VGND VDPWR VGND VGND sky130_fd_pr__nfet_01v8 ad=0.143 pd=1.62 as=0 ps=0 w=0.55 l=0.59
X3729 VGND VDPWR VGND VGND sky130_fd_pr__nfet_01v8 ad=0.143 pd=1.62 as=0 ps=0 w=0.55 l=0.59
X3730 single_9b_cdac_1.cdac_sw_9b_0.cdac_sw_3_8.nooverlap_clk_0.CLKB0 single_9b_cdac_1.cdac_sw_9b_0.cdac_sw_3_8.nooverlap_clk_0.sky130_fd_sc_hs__inv_8_0.A VDPWR VDPWR sky130_fd_pr__pfet_01v8 ad=0.168 pd=1.42 as=0.196 ps=1.47 w=1.12 l=0.15
X3731 single_9b_cdac_0.cdac_sw_9b_0.S[7] single_9b_cdac_0.cdac_sw_9b_0.cdac_sw_3_7.tg_sw_3_3.SWN ua[0] VDPWR sky130_fd_pr__pfet_01v8 ad=0.435 pd=3.58 as=0.435 ps=3.58 w=1.5 l=0.5
X3732 VDPWR single_9b_cdac_0.cdac_sw_9b_0.cdac_sw_3_7.tg_sw_3_3.SWN single_9b_cdac_0.cdac_sw_9b_0.cdac_sw_3_7.tg_sw_3_3.SWP VDPWR sky130_fd_pr__pfet_01v8 ad=0.168 pd=1.42 as=0.168 ps=1.42 w=1.12 l=0.15
X3733 a_5969_25428# a_5803_25428# VGND VGND sky130_fd_pr__nfet_01v8 ad=0.1092 pd=1.36 as=0.0567 ps=0.69 w=0.42 l=0.15
X3734 VDPWR VGND VDPWR VDPWR sky130_fd_pr__pfet_01v8_hvt ad=0.2262 pd=2.26 as=0 ps=0 w=0.87 l=0.59
X3735 VGND single_9b_cdac_0.cdac_sw_9b_0.cdac_sw_3_4.nooverlap_clk_0.CLKB0 single_9b_cdac_0.cdac_sw_9b_0.cdac_sw_3_4.nooverlap_clk_0.CLK0 VGND sky130_fd_pr__nfet_01v8_lvt ad=0.1295 pd=1.09 as=0.1036 ps=1.02 w=0.74 l=0.15
X3736 sar9b_0.net40 a_10187_22138# VGND VGND sky130_fd_pr__nfet_01v8 ad=0.169 pd=1.82 as=0.2087 ps=2.02 w=0.65 l=0.15
X3737 a_13053_21076# a_12887_21076# VDPWR VDPWR sky130_fd_pr__pfet_01v8_hvt ad=0.1664 pd=1.8 as=0.0864 ps=0.91 w=0.64 l=0.15
X3738 th_dif_sw_0.VCN single_9b_cdac_0.cdac_sw_9b_0.S[0] sky130_fd_pr__cap_mim_m3_1 l=2 w=2
X3739 VDPWR single_9b_cdac_0.cdac_sw_9b_0.cdac_sw_3_6.nooverlap_clk_0.x10.A single_9b_cdac_0.cdac_sw_9b_0.cdac_sw_3_6.tg_sw_3_3.SWN VDPWR sky130_fd_pr__pfet_01v8 ad=0.196 pd=1.47 as=0.168 ps=1.42 w=1.12 l=0.15
X3740 VDPWR single_9b_cdac_0.cdac_sw_9b_0.cdac_sw_3_2.nooverlap_clk_0.sky130_fd_sc_hs__nand2_1_0.Y single_9b_cdac_0.cdac_sw_9b_0.cdac_sw_3_2.nooverlap_clk_0.sky130_fd_sc_hs__inv_1_1.A VDPWR sky130_fd_pr__pfet_01v8 ad=0.3864 pd=2.93 as=0.3304 ps=2.83 w=1.12 l=0.15
X3741 VGND sar9b_0.net15 a_9065_19810# VGND sky130_fd_pr__nfet_01v8 ad=0.1346 pd=1.15 as=0.0441 ps=0.63 w=0.42 l=0.15
X3742 single_9b_cdac_1.cdac_sw_9b_0.S[6] single_9b_cdac_1.cdac_sw_9b_0.cdac_sw_3_6.nooverlap_clk_0.CLKB0 a_33936_16877# VDPWR sky130_fd_pr__pfet_01v8 ad=0.435 pd=3.58 as=0.435 ps=3.58 w=1.5 l=0.5
X3743 th_dif_sw_0.VCP single_9b_cdac_1.cdac_sw_9b_0.S[0] sky130_fd_pr__cap_mim_m3_1 l=2 w=2
X3744 dw_12589_1395# a_10166_3438# sky130_fd_pr__cap_mim_m3_1 l=2 w=2
X3745 single_9b_cdac_1.cdac_sw_9b_0.cdac_sw_3_7.nooverlap_clk_0.sky130_fd_sc_hs__inv_1_1.A single_9b_cdac_1.cdac_sw_9b_0.cdac_sw_3_7.nooverlap_clk_0.sky130_fd_sc_hs__nand2_1_0.Y VDPWR VDPWR sky130_fd_pr__pfet_01v8 ad=0.3304 pd=2.83 as=0.3864 ps=2.93 w=1.12 l=0.15
X3746 single_9b_cdac_0.cdac_sw_9b_0.cdac_sw_3_6.tg_sw_3_3.SWN single_9b_cdac_0.cdac_sw_9b_0.cdac_sw_3_6.nooverlap_clk_0.x10.A VDPWR VDPWR sky130_fd_pr__pfet_01v8 ad=0.168 pd=1.42 as=0.3864 ps=2.93 w=1.12 l=0.15
X3747 VDPWR sar9b_0.net12 a_12887_25428# VDPWR sky130_fd_pr__pfet_01v8_hvt ad=0.0864 pd=0.91 as=0.1664 ps=1.8 w=0.64 l=0.15
X3748 a_6226_23364# a_6058_23618# VDPWR VDPWR sky130_fd_pr__pfet_01v8_hvt ad=0.1095 pd=1.075 as=0.17887 ps=1.26 w=0.75 l=0.15
X3749 a_13511_21442# a_12887_21076# a_13403_21076# VDPWR sky130_fd_pr__pfet_01v8_hvt ad=0.1155 pd=0.97 as=0.07245 ps=0.765 w=0.42 l=0.15
X3750 th_dif_sw_0.VCP single_9b_cdac_1.cdac_sw_9b_0.S[1] sky130_fd_pr__cap_mim_m3_1 l=2 w=2
X3751 th_dif_sw_0.VCP single_9b_cdac_1.cdac_sw_9b_0.S[0] sky130_fd_pr__cap_mim_m3_1 l=2 w=2
X3752 th_dif_sw_0.VCN single_9b_cdac_0.cdac_sw_9b_0.S[1] sky130_fd_pr__cap_mim_m3_1 l=2 w=2
X3753 th_dif_sw_0.th_sw_1.CKB a_21177_7457# VGND VGND sky130_fd_pr__nfet_01v8_lvt ad=0.1036 pd=1.02 as=0.1554 ps=1.16 w=0.74 l=0.15
X3754 VGND single_9b_cdac_0.cdac_sw_9b_0.cdac_sw_3_1.nooverlap_clk_0.x10.A single_9b_cdac_0.cdac_sw_9b_0.cdac_sw_3_1.tg_sw_3_3.SWN VGND sky130_fd_pr__nfet_01v8_lvt ad=0.1554 pd=1.16 as=0.1036 ps=1.02 w=0.74 l=0.15
X3755 VDPWR single_9b_cdac_1.CF[7] single_9b_cdac_0.cdac_sw_9b_0.cdac_sw_3_7.nooverlap_clk_0.x3.Y VDPWR sky130_fd_pr__pfet_01v8 ad=0.3864 pd=2.93 as=0.3304 ps=2.83 w=1.12 l=0.15
X3756 sar9b_0.net33 a_14143_25402# VDPWR VDPWR sky130_fd_pr__pfet_01v8_hvt ad=0.26 pd=2.52 as=0.3012 ps=2.66 w=1 l=0.15
X3757 sar9b_0.net13 a_11567_25188# VDPWR VDPWR sky130_fd_pr__pfet_01v8_hvt ad=0.26 pd=2.52 as=0.3012 ps=2.66 w=1 l=0.15
X3758 th_dif_sw_0.VCP single_9b_cdac_1.cdac_sw_9b_0.S[1] sky130_fd_pr__cap_mim_m3_1 l=2 w=2
X3759 VDPWR single_9b_cdac_1.cdac_sw_9b_0.cdac_sw_3_5.nooverlap_clk_0.sky130_fd_sc_hs__inv_8_0.A single_9b_cdac_1.cdac_sw_9b_0.cdac_sw_3_5.nooverlap_clk_0.CLKB0 VDPWR sky130_fd_pr__pfet_01v8 ad=0.196 pd=1.47 as=0.168 ps=1.42 w=1.12 l=0.15
X3760 a_12666_20898# sar9b_0.net15 VGND VGND sky130_fd_pr__nfet_01v8 ad=0.06405 pd=0.725 as=0.12495 ps=1.015 w=0.42 l=0.15
X3761 sar9b_0.net43 a_12211_24100# VDPWR VDPWR sky130_fd_pr__pfet_01v8_hvt ad=0.26 pd=2.52 as=0.3012 ps=2.66 w=1 l=0.15
X3762 VDPWR a_9132_7271# th_dif_sw_0.th_sw_1.CK VDPWR sky130_fd_pr__pfet_01v8 ad=0.3304 pd=2.83 as=0.168 ps=1.42 w=1.12 l=0.15
X3763 single_9b_cdac_1.cdac_sw_9b_0.cdac_sw_3_1.nooverlap_clk_0.x10.A single_9b_cdac_1.cdac_sw_9b_0.cdac_sw_3_1.nooverlap_clk_0.x8.A VGND VGND sky130_fd_pr__nfet_01v8_lvt ad=0.1184 pd=1.06 as=0.2331 ps=2.11 w=0.74 l=0.15
X3764 VDPWR a_10211_20225# a_10142_20354# VDPWR sky130_fd_pr__pfet_01v8_hvt ad=0.2184 pd=2.2 as=0.12915 ps=1.185 w=0.84 l=0.15
X3765 single_9b_cdac_1.cdac_sw_9b_0.cdac_sw_3_6.tg_sw_3_3.SWN single_9b_cdac_1.cdac_sw_9b_0.cdac_sw_3_6.nooverlap_clk_0.x10.A VGND VGND sky130_fd_pr__nfet_01v8_lvt ad=0.1036 pd=1.02 as=0.1554 ps=1.16 w=0.74 l=0.15
X3766 VGND single_9b_cdac_1.cdac_sw_9b_0.cdac_sw_3_0.nooverlap_clk_0.x10.A single_9b_cdac_1.cdac_sw_9b_0.cdac_sw_3_0.tg_sw_3_3.SWN VGND sky130_fd_pr__nfet_01v8_lvt ad=0.2146 pd=2.06 as=0.1036 ps=1.02 w=0.74 l=0.15
X3767 VGND a_9132_7271# th_dif_sw_0.th_sw_1.CK VGND sky130_fd_pr__nfet_01v8_lvt ad=0.1554 pd=1.16 as=0.1036 ps=1.02 w=0.74 l=0.15
X3768 VGND single_9b_cdac_1.cdac_sw_9b_0.cdac_sw_3_1.nooverlap_clk_0.x10.A single_9b_cdac_1.cdac_sw_9b_0.cdac_sw_3_1.tg_sw_3_3.SWN VGND sky130_fd_pr__nfet_01v8_lvt ad=0.1295 pd=1.09 as=0.1036 ps=1.02 w=0.74 l=0.15
X3769 single_9b_cdac_0.cdac_sw_9b_0.cdac_sw_3_3.nooverlap_clk_0.sky130_fd_sc_hs__inv_8_0.A single_9b_cdac_0.cdac_sw_9b_0.cdac_sw_3_3.nooverlap_clk_0.x1.A VGND VGND sky130_fd_pr__nfet_01v8_lvt ad=0.1036 pd=1.02 as=0.2109 ps=2.05 w=0.74 l=0.15
X3770 single_9b_cdac_0.cdac_sw_9b_0.cdac_sw_3_6.nooverlap_clk_0.CLKB0 single_9b_cdac_0.cdac_sw_9b_0.cdac_sw_3_6.nooverlap_clk_0.sky130_fd_sc_hs__inv_8_0.A VDPWR VDPWR sky130_fd_pr__pfet_01v8 ad=0.168 pd=1.42 as=0.196 ps=1.47 w=1.12 l=0.15
X3771 single_9b_cdac_0.cdac_sw_9b_0.cdac_sw_3_2.nooverlap_clk_0.CLK0 single_9b_cdac_0.cdac_sw_9b_0.cdac_sw_3_2.nooverlap_clk_0.CLKB0 VDPWR VDPWR sky130_fd_pr__pfet_01v8 ad=0.168 pd=1.42 as=0.3864 ps=2.93 w=1.12 l=0.15
X3772 VGND tdc_0.RDY a_7735_17812# VGND sky130_fd_pr__nfet_01v8 ad=0.06825 pd=0.745 as=0.1113 ps=1.37 w=0.42 l=0.15
X3773 dw_17224_1400# a_21368_4076# sky130_fd_pr__cap_mim_m3_1 l=2 w=2
X3774 VGND single_9b_cdac_0.cdac_sw_9b_0.cdac_sw_3_8.nooverlap_clk_0.x10.A single_9b_cdac_0.cdac_sw_9b_0.cdac_sw_3_8.tg_sw_3_3.SWN VGND sky130_fd_pr__nfet_01v8_lvt ad=0.2109 pd=2.05 as=0.1036 ps=1.02 w=0.74 l=0.15
X3775 single_9b_cdac_0.cdac_sw_9b_0.cdac_sw_3_4.nooverlap_clk_0.sky130_fd_sc_hs__inv_8_0.A single_9b_cdac_0.cdac_sw_9b_0.cdac_sw_3_4.nooverlap_clk_0.x1.A VDPWR VDPWR sky130_fd_pr__pfet_01v8 ad=0.168 pd=1.42 as=0.168 ps=1.42 w=1.12 l=0.15
X3776 a_34814_26990# single_9b_cdac_0.cdac_sw_9b_0.cdac_sw_3_6.nooverlap_clk_0.CLK0 single_9b_cdac_0.cdac_sw_9b_0.S[6] VGND sky130_fd_pr__nfet_01v8 ad=0.145 pd=1.58 as=0.145 ps=1.58 w=0.5 l=0.5
X3777 VDPWR VGND VDPWR VDPWR sky130_fd_pr__pfet_01v8_hvt ad=0.2262 pd=2.26 as=0 ps=0 w=0.87 l=0.59
X3778 VDPWR VGND VDPWR VDPWR sky130_fd_pr__pfet_01v8_hvt ad=0.2262 pd=2.26 as=0 ps=0 w=0.87 l=0.59
X3779 single_9b_cdac_1.cdac_sw_9b_0.S[6] single_9b_cdac_1.cdac_sw_9b_0.cdac_sw_3_6.tg_sw_3_3.SWP ua[0] VGND sky130_fd_pr__nfet_01v8 ad=0.145 pd=1.58 as=0.145 ps=1.58 w=0.5 l=0.5
X3780 VDPWR single_9b_cdac_0.cdac_sw_9b_0.cdac_sw_3_4.nooverlap_clk_0.x1.A single_9b_cdac_0.cdac_sw_9b_0.cdac_sw_3_4.nooverlap_clk_0.sky130_fd_sc_hs__inv_8_0.A VDPWR sky130_fd_pr__pfet_01v8 ad=0.168 pd=1.42 as=0.168 ps=1.42 w=1.12 l=0.15
X3781 a_9097_22164# a_8931_22164# VDPWR VDPWR sky130_fd_pr__pfet_01v8_hvt ad=0.1664 pd=1.8 as=0.0864 ps=0.91 w=0.64 l=0.15
X3782 a_8708_19810# sar9b_0.net15 VDPWR VDPWR sky130_fd_pr__pfet_01v8_hvt ad=0.0651 pd=0.73 as=0.1092 ps=1.36 w=0.42 l=0.15
X3783 th_dif_sw_0.VCP single_9b_cdac_1.cdac_sw_9b_0.S[0] sky130_fd_pr__cap_mim_m3_1 l=2 w=2
X3784 th_dif_sw_0.VCN single_9b_cdac_0.cdac_sw_9b_0.S[0] sky130_fd_pr__cap_mim_m3_1 l=2 w=2
X3785 VGND single_9b_cdac_0.cdac_sw_9b_0.cdac_sw_3_5.nooverlap_clk_0.x10.A single_9b_cdac_0.cdac_sw_9b_0.cdac_sw_3_5.tg_sw_3_3.SWN VGND sky130_fd_pr__nfet_01v8_lvt ad=0.1295 pd=1.09 as=0.1036 ps=1.02 w=0.74 l=0.15
X3786 VGND sar9b_0._00_ a_6417_19822# VGND sky130_fd_pr__nfet_01v8 ad=0.1092 pd=1.36 as=0.0813 ps=0.83 w=0.42 l=0.15
X3787 VDPWR VGND VDPWR VDPWR sky130_fd_pr__pfet_01v8_hvt ad=0.2262 pd=2.26 as=0 ps=0 w=0.87 l=0.59
X3788 a_13403_19822# a_13053_19450# a_13308_19810# VDPWR sky130_fd_pr__pfet_01v8_hvt ad=0.07245 pd=0.765 as=0.0651 ps=0.73 w=0.42 l=0.15
X3789 single_9b_cdac_1.cdac_sw_9b_0.cdac_sw_3_0.nooverlap_clk_0.CLK0 single_9b_cdac_1.cdac_sw_9b_0.cdac_sw_3_0.nooverlap_clk_0.CLKB0 VGND VGND sky130_fd_pr__nfet_01v8_lvt ad=0.1036 pd=1.02 as=0.1036 ps=1.02 w=0.74 l=0.15
X3790 th_dif_sw_0.VCP th_dif_sw_0.th_sw_1.th_sw_main_0.VGS ua[2] VGND sky130_fd_pr__nfet_01v8 ad=5.8 pd=40.58 as=5.8 ps=40.58 w=20 l=0.15
X3791 single_9b_cdac_0.cdac_sw_9b_0.cdac_sw_3_4.nooverlap_clk_0.sky130_fd_sc_hs__inv_8_0.A single_9b_cdac_0.cdac_sw_9b_0.cdac_sw_3_4.nooverlap_clk_0.x1.A VDPWR VDPWR sky130_fd_pr__pfet_01v8 ad=0.168 pd=1.42 as=0.3304 ps=2.83 w=1.12 l=0.15
X3792 single_9b_cdac_0.cdac_sw_9b_0.S[1] single_9b_cdac_0.cdac_sw_9b_0.cdac_sw_3_1.nooverlap_clk_0.CLKB0 a_57946_26999# VDPWR sky130_fd_pr__pfet_01v8 ad=0.435 pd=3.58 as=0.435 ps=3.58 w=1.5 l=0.5
X3793 single_9b_cdac_0.cdac_sw_9b_0.cdac_sw_3_2.tg_sw_3_3.SWN single_9b_cdac_0.cdac_sw_9b_0.cdac_sw_3_2.nooverlap_clk_0.x10.A VGND VGND sky130_fd_pr__nfet_01v8_lvt ad=0.1036 pd=1.02 as=0.2146 ps=2.06 w=0.74 l=0.15
X3794 a_12934_25972# a_11857_25978# a_12772_26350# VDPWR sky130_fd_pr__pfet_01v8_hvt ad=0.0567 pd=0.69 as=0.0588 ps=0.7 w=0.42 l=0.15
X3795 VGND VDPWR VGND VGND sky130_fd_pr__nfet_01v8 ad=0.143 pd=1.62 as=0 ps=0 w=0.55 l=0.59
X3796 VGND VDPWR VGND VGND sky130_fd_pr__nfet_01v8 ad=0.143 pd=1.62 as=0 ps=0 w=0.55 l=0.59
X3797 VDPWR VGND VDPWR VDPWR sky130_fd_pr__pfet_01v8_hvt ad=0.2262 pd=2.26 as=0 ps=0 w=0.87 l=0.59
X3798 single_9b_cdac_1.cdac_sw_9b_0.cdac_sw_3_8.nooverlap_clk_0.x8.A single_9b_cdac_1.cdac_sw_9b_0.cdac_sw_3_8.nooverlap_clk_0.x6.A VDPWR VDPWR sky130_fd_pr__pfet_01v8 ad=0.3304 pd=2.83 as=0.3864 ps=2.93 w=1.12 l=0.15
X3799 VDPWR single_9b_cdac_1.cdac_sw_9b_0.cdac_sw_3_5.nooverlap_clk_0.x1.A single_9b_cdac_1.cdac_sw_9b_0.cdac_sw_3_5.nooverlap_clk_0.x4.A VDPWR sky130_fd_pr__pfet_01v8 ad=0.3192 pd=2.81 as=0.168 ps=1.42 w=1.12 l=0.15
X3800 VDPWR a_9175_27364# a_9162_27060# VDPWR sky130_fd_pr__pfet_01v8_hvt ad=0.0819 pd=0.81 as=0.0567 ps=0.69 w=0.42 l=0.15
X3801 single_9b_cdac_0.cdac_sw_9b_0.S[6] single_9b_cdac_0.cdac_sw_9b_0.cdac_sw_3_6.tg_sw_3_3.SWN ua[0] VDPWR sky130_fd_pr__pfet_01v8 ad=0.435 pd=3.58 as=0.435 ps=3.58 w=1.5 l=0.5
X3802 VGND a_6149_23770# sar9b_0.clknet_1_1__leaf_CLK VGND sky130_fd_pr__nfet_01v8 ad=0.0588 pd=0.7 as=0.0588 ps=0.7 w=0.42 l=0.15
X3803 a_5977_22708# sar9b_0._10_ sar9b_0._02_ VDPWR sky130_fd_pr__pfet_01v8_hvt ad=0.105 pd=1.21 as=0.26 ps=2.52 w=1 l=0.15
X3804 a_62748_16877# single_9b_cdac_1.SW[0] VDPWR VDPWR sky130_fd_pr__pfet_01v8 ad=0.435 pd=3.58 as=0.435 ps=3.58 w=1.5 l=0.5
X3805 single_9b_cdac_0.SW[7] a_13623_25972# VDPWR VDPWR sky130_fd_pr__pfet_01v8_hvt ad=0.2054 pd=2.1 as=0.11455 ps=1.08 w=0.79 l=0.15
X3806 a_9461_20910# a_8471_20538# a_9335_20532# VGND sky130_fd_pr__special_nfet_01v8 ad=0.066 pd=0.745 as=0.0684 ps=0.74 w=0.36 l=0.15
X3807 a_11965_20506# a_11747_20910# VGND VGND sky130_fd_pr__nfet_01v8 ad=0.0999 pd=0.985 as=0.1346 ps=1.15 w=0.64 l=0.15
X3808 th_dif_sw_0.VCN single_9b_cdac_0.cdac_sw_9b_0.S[0] sky130_fd_pr__cap_mim_m3_1 l=2 w=2
X3809 VGND VDPWR VGND VGND sky130_fd_pr__nfet_01v8 ad=0.143 pd=1.62 as=0 ps=0 w=0.55 l=0.59
X3810 a_6701_20506# sar9b_0.clknet_0_CLK VDPWR VDPWR sky130_fd_pr__pfet_01v8_hvt ad=0.14 pd=1.28 as=0.14 ps=1.28 w=1 l=0.15
X3811 VDPWR VGND VDPWR VDPWR sky130_fd_pr__pfet_01v8_hvt ad=0.2262 pd=2.26 as=0 ps=0 w=0.87 l=0.59
X3812 single_9b_cdac_1.cdac_sw_9b_0.cdac_sw_3_5.nooverlap_clk_0.x4.A single_9b_cdac_1.cdac_sw_9b_0.cdac_sw_3_5.nooverlap_clk_0.x3.Y VDPWR VDPWR sky130_fd_pr__pfet_01v8 ad=0.168 pd=1.42 as=0.3192 ps=2.81 w=1.12 l=0.15
X3813 th_dif_sw_0.VCP single_9b_cdac_1.cdac_sw_9b_0.S[0] sky130_fd_pr__cap_mim_m3_1 l=2 w=2
X3814 a_6483_23618# a_5785_23252# a_6226_23364# VGND sky130_fd_pr__special_nfet_01v8 ad=0.0684 pd=0.74 as=0.0989 ps=0.995 w=0.36 l=0.15
X3815 VDPWR VGND VDPWR VDPWR sky130_fd_pr__pfet_01v8_hvt ad=0.2262 pd=2.26 as=0 ps=0 w=0.87 l=0.59
X3816 sar9b_0.net5 a_9543_19748# VGND VGND sky130_fd_pr__nfet_01v8 ad=0.169 pd=1.82 as=0.2087 ps=2.02 w=0.65 l=0.15
X3817 VDPWR single_9b_cdac_0.cdac_sw_9b_0.cdac_sw_3_0.nooverlap_clk_0.sky130_fd_sc_hs__inv_8_0.A single_9b_cdac_0.cdac_sw_9b_0.cdac_sw_3_0.nooverlap_clk_0.CLKB0 VDPWR sky130_fd_pr__pfet_01v8 ad=0.196 pd=1.47 as=0.168 ps=1.42 w=1.12 l=0.15
X3818 VDPWR a_9635_24314# a_9622_24706# VDPWR sky130_fd_pr__pfet_01v8_hvt ad=0.0819 pd=0.81 as=0.0567 ps=0.69 w=0.42 l=0.15
X3819 VDPWR single_9b_cdac_0.cdac_sw_9b_0.cdac_sw_3_3.nooverlap_clk_0.x3.Y single_9b_cdac_0.cdac_sw_9b_0.cdac_sw_3_3.nooverlap_clk_0.x4.A VDPWR sky130_fd_pr__pfet_01v8 ad=0.3192 pd=2.81 as=0.168 ps=1.42 w=1.12 l=0.15
X3820 VGND VDPWR VGND VGND sky130_fd_pr__nfet_01v8 ad=0.143 pd=1.62 as=0 ps=0 w=0.55 l=0.59
X3821 ua[0] single_9b_cdac_1.cdac_sw_9b_0.cdac_sw_3_6.tg_sw_3_3.SWN ua[0] VGND sky130_fd_pr__nfet_01v8 ad=0.145 pd=1.58 as=0 ps=0 w=0.5 l=0.5
X3822 single_9b_cdac_1.cdac_sw_9b_0.cdac_sw_3_5.tg_sw_3_3.SWN single_9b_cdac_1.cdac_sw_9b_0.cdac_sw_3_5.nooverlap_clk_0.x10.A VGND VGND sky130_fd_pr__nfet_01v8_lvt ad=0.1036 pd=1.02 as=0.2109 ps=2.05 w=0.74 l=0.15
X3823 th_dif_sw_0.VCP single_9b_cdac_1.cdac_sw_9b_0.S[0] sky130_fd_pr__cap_mim_m3_1 l=2 w=2
X3824 th_dif_sw_0.VCN single_9b_cdac_0.cdac_sw_9b_0.S[6] sky130_fd_pr__cap_mim_m3_1 l=2 w=2
X3825 th_dif_sw_0.VCN single_9b_cdac_0.cdac_sw_9b_0.S[1] sky130_fd_pr__cap_mim_m3_1 l=2 w=2
X3826 VDPWR single_9b_cdac_0.cdac_sw_9b_0.cdac_sw_3_7.nooverlap_clk_0.x4.A single_9b_cdac_0.cdac_sw_9b_0.cdac_sw_3_7.nooverlap_clk_0.x6.A VDPWR sky130_fd_pr__pfet_01v8 ad=0.3864 pd=2.93 as=0.3304 ps=2.83 w=1.12 l=0.15
X3827 a_43540_16877# single_9b_cdac_1.SW[4] VDPWR VDPWR sky130_fd_pr__pfet_01v8 ad=0.435 pd=3.58 as=0.435 ps=3.58 w=1.5 l=0.5
X3828 VGND single_9b_cdac_0.cdac_sw_9b_0.cdac_sw_3_6.nooverlap_clk_0.x1.A single_9b_cdac_0.cdac_sw_9b_0.cdac_sw_3_6.nooverlap_clk_0.sky130_fd_sc_hs__inv_8_0.A VGND sky130_fd_pr__nfet_01v8_lvt ad=0.2331 pd=2.11 as=0.1184 ps=1.06 w=0.74 l=0.15
X3829 a_13308_19810# sar9b_0.net1 VGND VGND sky130_fd_pr__nfet_01v8 ad=0.066 pd=0.745 as=0.2205 ps=1.89 w=0.42 l=0.15
X3830 ua[0] single_9b_cdac_1.cdac_sw_9b_0.cdac_sw_3_4.tg_sw_3_3.SWP ua[0] VDPWR sky130_fd_pr__pfet_01v8 ad=0.435 pd=3.58 as=0 ps=0 w=1.5 l=0.5
X3831 th_dif_sw_0.VCN single_9b_cdac_0.cdac_sw_9b_0.S[0] sky130_fd_pr__cap_mim_m3_1 l=2 w=2
X3832 single_9b_cdac_0.cdac_sw_9b_0.cdac_sw_3_3.nooverlap_clk_0.x4.A single_9b_cdac_0.cdac_sw_9b_0.cdac_sw_3_3.nooverlap_clk_0.x1.A VDPWR VDPWR sky130_fd_pr__pfet_01v8 ad=0.168 pd=1.42 as=0.3192 ps=2.81 w=1.12 l=0.15
X3833 single_9b_cdac_0.cdac_sw_9b_0.cdac_sw_3_0.nooverlap_clk_0.CLKB0 single_9b_cdac_0.cdac_sw_9b_0.cdac_sw_3_0.nooverlap_clk_0.sky130_fd_sc_hs__inv_8_0.A VDPWR VDPWR sky130_fd_pr__pfet_01v8 ad=0.168 pd=1.42 as=0.3864 ps=2.93 w=1.12 l=0.15
X3834 th_dif_sw_0.VCP single_9b_cdac_1.cdac_sw_9b_0.S[1] sky130_fd_pr__cap_mim_m3_1 l=2 w=2
X3835 th_dif_sw_0.VCN single_9b_cdac_0.cdac_sw_9b_0.S[2] sky130_fd_pr__cap_mim_m3_1 l=2 w=2
X3836 single_9b_cdac_0.cdac_sw_9b_0.cdac_sw_3_0.tg_sw_3_3.SWP single_9b_cdac_0.cdac_sw_9b_0.cdac_sw_3_0.tg_sw_3_3.SWN VGND VGND sky130_fd_pr__nfet_01v8_lvt ad=0.1036 pd=1.02 as=0.1295 ps=1.09 w=0.74 l=0.15
X3837 a_7055_26350# a_6705_25978# a_6960_26338# VDPWR sky130_fd_pr__pfet_01v8_hvt ad=0.07245 pd=0.765 as=0.0651 ps=0.73 w=0.42 l=0.15
X3838 a_7059_21228# sar9b_0._07_ VDPWR VDPWR sky130_fd_pr__pfet_01v8_hvt ad=0.0567 pd=0.69 as=0.16655 ps=1.39 w=0.42 l=0.15
X3839 dw_12589_1395# a_10166_3438# sky130_fd_pr__cap_mim_m3_1 l=2 w=2
X3840 single_9b_cdac_1.cdac_sw_9b_0.S[1] single_9b_cdac_1.cdac_sw_9b_0.cdac_sw_3_1.tg_sw_3_3.SWP single_9b_cdac_1.cdac_sw_9b_0.S[1] VDPWR sky130_fd_pr__pfet_01v8 ad=0.435 pd=3.58 as=0 ps=0 w=1.5 l=0.5
X3841 ua[0] single_9b_cdac_0.cdac_sw_9b_0.cdac_sw_3_1.tg_sw_3_3.SWP ua[0] VDPWR sky130_fd_pr__pfet_01v8 ad=0.435 pd=3.58 as=0 ps=0 w=1.5 l=0.5
X3842 single_9b_cdac_1.cdac_sw_9b_0.S[4] single_9b_cdac_1.cdac_sw_9b_0.cdac_sw_3_3.tg_sw_3_3.SWN ua[0] VDPWR sky130_fd_pr__pfet_01v8 ad=0.435 pd=3.58 as=0.435 ps=3.58 w=1.5 l=0.5
X3843 dw_12589_1395# a_10166_3438# sky130_fd_pr__cap_mim_m3_1 l=2 w=2
X3844 th_dif_sw_0.VCP single_9b_cdac_1.cdac_sw_9b_0.S[2] sky130_fd_pr__cap_mim_m3_1 l=2 w=2
X3845 single_9b_cdac_0.cdac_sw_9b_0.cdac_sw_3_5.nooverlap_clk_0.CLKB0 single_9b_cdac_0.cdac_sw_9b_0.cdac_sw_3_5.nooverlap_clk_0.sky130_fd_sc_hs__inv_8_0.A VDPWR VDPWR sky130_fd_pr__pfet_01v8 ad=0.168 pd=1.42 as=0.196 ps=1.47 w=1.12 l=0.15
X3846 VGND sar9b_0.net11 a_12887_24890# VGND sky130_fd_pr__nfet_01v8 ad=0.0567 pd=0.69 as=0.1092 ps=1.36 w=0.42 l=0.15
X3847 th_dif_sw_0.VCP single_9b_cdac_1.cdac_sw_9b_0.S[0] sky130_fd_pr__cap_mim_m3_1 l=2 w=2
X3848 dw_12589_1395# a_10166_3438# sky130_fd_pr__cap_mim_m3_1 l=2 w=2
X3849 a_6678_26882# a_5601_26516# a_6516_26516# VDPWR sky130_fd_pr__pfet_01v8_hvt ad=0.0567 pd=0.69 as=0.0588 ps=0.7 w=0.42 l=0.15
X3850 single_9b_cdac_0.cdac_sw_9b_0.cdac_sw_3_7.nooverlap_clk_0.CLKB0 single_9b_cdac_0.cdac_sw_9b_0.cdac_sw_3_7.nooverlap_clk_0.sky130_fd_sc_hs__inv_8_0.A VGND VGND sky130_fd_pr__nfet_01v8_lvt ad=0.1036 pd=1.02 as=0.2146 ps=2.06 w=0.74 l=0.15
X3851 single_9b_cdac_0.cdac_sw_9b_0.S[0] single_9b_cdac_0.cdac_sw_9b_0.cdac_sw_3_2.tg_sw_3_3.SWN ua[0] VDPWR sky130_fd_pr__pfet_01v8 ad=0.435 pd=3.58 as=0.435 ps=3.58 w=1.5 l=0.5
X3852 single_9b_cdac_1.cdac_sw_9b_0.S[7] single_9b_cdac_1.cdac_sw_9b_0.cdac_sw_3_7.tg_sw_3_3.SWN single_9b_cdac_1.cdac_sw_9b_0.S[7] VGND sky130_fd_pr__nfet_01v8 ad=0.145 pd=1.58 as=0 ps=0 w=0.5 l=0.5
X3853 VDPWR a_8951_23770# a_8867_23796# VDPWR sky130_fd_pr__pfet_01v8_hvt ad=0.1113 pd=1.37 as=0.0882 ps=0.84 w=0.42 l=0.15
X3854 VDPWR single_9b_cdac_1.cdac_sw_9b_0.cdac_sw_3_3.nooverlap_clk_0.CLKB0 single_9b_cdac_1.cdac_sw_9b_0.cdac_sw_3_3.nooverlap_clk_0.CLK0 VDPWR sky130_fd_pr__pfet_01v8 ad=0.196 pd=1.47 as=0.168 ps=1.42 w=1.12 l=0.15
X3855 a_14038_23796# a_12961_23802# a_13876_24174# VDPWR sky130_fd_pr__pfet_01v8_hvt ad=0.0567 pd=0.69 as=0.0588 ps=0.7 w=0.42 l=0.15
X3856 single_9b_cdac_1.cdac_sw_9b_0.cdac_sw_3_3.nooverlap_clk_0.CLK0 single_9b_cdac_1.cdac_sw_9b_0.cdac_sw_3_3.nooverlap_clk_0.CLKB0 VGND VGND sky130_fd_pr__nfet_01v8_lvt ad=0.1036 pd=1.02 as=0.1036 ps=1.02 w=0.74 l=0.15
X3857 th_dif_sw_0.VCP single_9b_cdac_1.cdac_sw_9b_0.S[0] sky130_fd_pr__cap_mim_m3_1 l=2 w=2
X3858 th_dif_sw_0.VCP single_9b_cdac_1.cdac_sw_9b_0.S[0] sky130_fd_pr__cap_mim_m3_1 l=2 w=2
X3859 VGND VDPWR VGND VGND sky130_fd_pr__nfet_01v8 ad=0.143 pd=1.62 as=0 ps=0 w=0.55 l=0.59
X3860 tdc_0.RDY tdc_0.phase_detector_0.pd_out_0.B a_16542_13134# VGND sky130_fd_pr__nfet_01v8_lvt ad=0.1554 pd=1.16 as=0.0888 ps=0.98 w=0.74 l=0.15
X3861 single_9b_cdac_0.cdac_sw_9b_0.cdac_sw_3_8.nooverlap_clk_0.CLK0 single_9b_cdac_0.cdac_sw_9b_0.cdac_sw_3_8.nooverlap_clk_0.CLKB0 VGND VGND sky130_fd_pr__nfet_01v8_lvt ad=0.1036 pd=1.02 as=0.2146 ps=2.06 w=0.74 l=0.15
X3862 single_9b_cdac_0.cdac_sw_9b_0.cdac_sw_3_7.tg_sw_3_3.SWP single_9b_cdac_0.cdac_sw_9b_0.cdac_sw_3_7.tg_sw_3_3.SWN VDPWR VDPWR sky130_fd_pr__pfet_01v8 ad=0.168 pd=1.42 as=0.3864 ps=2.93 w=1.12 l=0.15
X3863 a_12947_26276# sar9b_0.net3 VDPWR VDPWR sky130_fd_pr__pfet_01v8_hvt ad=0.0567 pd=0.69 as=0.0819 ps=0.81 w=0.42 l=0.15
X3864 single_9b_cdac_1.cdac_sw_9b_0.cdac_sw_3_3.nooverlap_clk_0.CLK0 single_9b_cdac_1.cdac_sw_9b_0.cdac_sw_3_3.nooverlap_clk_0.CLKB0 VDPWR VDPWR sky130_fd_pr__pfet_01v8 ad=0.168 pd=1.42 as=0.168 ps=1.42 w=1.12 l=0.15
X3865 VGND VDPWR VGND VGND sky130_fd_pr__nfet_01v8 ad=0.143 pd=1.62 as=0 ps=0 w=0.55 l=0.59
X3866 VGND single_9b_cdac_1.SW[6] a_34814_17740# VGND sky130_fd_pr__nfet_01v8 ad=0.145 pd=1.58 as=0.145 ps=1.58 w=0.5 l=0.5
X3867 th_dif_sw_0.VCP single_9b_cdac_1.cdac_sw_9b_0.S[0] sky130_fd_pr__cap_mim_m3_1 l=2 w=2
X3868 VDPWR single_9b_cdac_0.cdac_sw_9b_0.cdac_sw_3_2.nooverlap_clk_0.sky130_fd_sc_hs__inv_1_1.A single_9b_cdac_0.cdac_sw_9b_0.cdac_sw_3_2.nooverlap_clk_0.x1.A VDPWR sky130_fd_pr__pfet_01v8 ad=0.3864 pd=2.93 as=0.3304 ps=2.83 w=1.12 l=0.15
X3869 sar9b_0.clknet_0_CLK a_7345_21594# VDPWR VDPWR sky130_fd_pr__pfet_01v8_hvt ad=0.14 pd=1.28 as=0.14 ps=1.28 w=1 l=0.15
X3870 th_dif_sw_0.VCN single_9b_cdac_0.cdac_sw_9b_0.S[1] sky130_fd_pr__cap_mim_m3_1 l=2 w=2
X3871 VDPWR single_9b_cdac_1.cdac_sw_9b_0.cdac_sw_3_3.nooverlap_clk_0.CLKB0 single_9b_cdac_1.cdac_sw_9b_0.cdac_sw_3_3.nooverlap_clk_0.CLK0 VDPWR sky130_fd_pr__pfet_01v8 ad=0.168 pd=1.42 as=0.168 ps=1.42 w=1.12 l=0.15
X3872 VGND single_9b_cdac_1.cdac_sw_9b_0.cdac_sw_3_1.nooverlap_clk_0.x10.A single_9b_cdac_1.cdac_sw_9b_0.cdac_sw_3_1.tg_sw_3_3.SWN VGND sky130_fd_pr__nfet_01v8_lvt ad=0.1036 pd=1.02 as=0.1036 ps=1.02 w=0.74 l=0.15
X3873 single_9b_cdac_1.CF[8] a_14451_23252# VGND VGND sky130_fd_pr__nfet_01v8 ad=0.1352 pd=1.56 as=0.0754 ps=0.81 w=0.52 l=0.15
X3874 VDPWR single_9b_cdac_1.cdac_sw_9b_0.cdac_sw_3_3.nooverlap_clk_0.x8.A single_9b_cdac_1.cdac_sw_9b_0.cdac_sw_3_3.nooverlap_clk_0.x10.A VDPWR sky130_fd_pr__pfet_01v8 ad=0.3304 pd=2.83 as=0.168 ps=1.42 w=1.12 l=0.15
X3875 VDPWR single_9b_cdac_0.cdac_sw_9b_0.cdac_sw_3_3.tg_sw_3_3.SWN single_9b_cdac_0.cdac_sw_9b_0.cdac_sw_3_3.tg_sw_3_3.SWP VDPWR sky130_fd_pr__pfet_01v8 ad=0.196 pd=1.47 as=0.168 ps=1.42 w=1.12 l=0.15
X3876 VGND VDPWR VGND VGND sky130_fd_pr__nfet_01v8 ad=0.143 pd=1.62 as=0 ps=0 w=0.55 l=0.59
X3877 VGND single_9b_cdac_0.cdac_sw_9b_0.cdac_sw_3_8.nooverlap_clk_0.x10.A single_9b_cdac_0.cdac_sw_9b_0.cdac_sw_3_8.tg_sw_3_3.SWN VGND sky130_fd_pr__nfet_01v8_lvt ad=0.1036 pd=1.02 as=0.1036 ps=1.02 w=0.74 l=0.15
X3878 single_9b_cdac_0.cdac_sw_9b_0.S[2] single_9b_cdac_0.cdac_sw_9b_0.cdac_sw_3_0.tg_sw_3_3.SWN single_9b_cdac_0.cdac_sw_9b_0.S[2] VGND sky130_fd_pr__nfet_01v8 ad=0.145 pd=1.58 as=2.32 ps=25.28 w=0.5 l=0.5
X3879 VDPWR sar9b_0.clk_div_0.COUNT\[0\] a_7925_23502# VDPWR sky130_fd_pr__pfet_01v8_hvt ad=0.26 pd=2.52 as=0.105 ps=1.21 w=1 l=0.15
X3880 VGND a_11567_23226# a_11501_23252# VGND sky130_fd_pr__nfet_01v8 ad=0.12495 pd=1.015 as=0.0669 ps=0.75 w=0.42 l=0.15
X3881 single_9b_cdac_1.cdac_sw_9b_0.cdac_sw_3_3.nooverlap_clk_0.CLK0 single_9b_cdac_1.cdac_sw_9b_0.cdac_sw_3_3.nooverlap_clk_0.CLKB0 VDPWR VDPWR sky130_fd_pr__pfet_01v8 ad=0.168 pd=1.42 as=0.196 ps=1.47 w=1.12 l=0.15
X3882 th_dif_sw_0.VCP single_9b_cdac_1.cdac_sw_9b_0.S[0] sky130_fd_pr__cap_mim_m3_1 l=2 w=2
X3883 th_dif_sw_0.VCN single_9b_cdac_0.cdac_sw_9b_0.S[4] sky130_fd_pr__cap_mim_m3_1 l=2 w=2
X3884 VDPWR th_dif_sw_0.th_sw_0.th_sw_main_0.VGS dw_17224_1400# dw_17224_1400# sky130_fd_pr__pfet_01v8 ad=1.16 pd=8.58 as=1.16 ps=8.58 w=4 l=0.15
X3885 single_9b_cdac_1.cdac_sw_9b_0.cdac_sw_3_2.nooverlap_clk_0.x3.Y single_9b_cdac_1.CF[0] VDPWR VDPWR sky130_fd_pr__pfet_01v8 ad=0.3304 pd=2.83 as=0.3864 ps=2.93 w=1.12 l=0.15
X3886 VGND VDPWR VGND VGND sky130_fd_pr__nfet_01v8 ad=0.143 pd=1.62 as=0 ps=0 w=0.55 l=0.59
X3887 VDPWR VGND VDPWR VDPWR sky130_fd_pr__pfet_01v8_hvt ad=0.2262 pd=2.26 as=0 ps=0 w=0.87 l=0.59
X3888 single_9b_cdac_1.cdac_sw_9b_0.cdac_sw_3_4.nooverlap_clk_0.x10.A single_9b_cdac_1.cdac_sw_9b_0.cdac_sw_3_4.nooverlap_clk_0.x8.A VGND VGND sky130_fd_pr__nfet_01v8_lvt ad=0.1036 pd=1.02 as=0.1221 ps=1.07 w=0.74 l=0.15
X3889 th_dif_sw_0.VCN single_9b_cdac_0.cdac_sw_9b_0.S[0] sky130_fd_pr__cap_mim_m3_1 l=2 w=2
X3890 VGND single_9b_cdac_0.cdac_sw_9b_0.cdac_sw_3_5.nooverlap_clk_0.x10.A single_9b_cdac_0.cdac_sw_9b_0.cdac_sw_3_5.tg_sw_3_3.SWN VGND sky130_fd_pr__nfet_01v8_lvt ad=0.2109 pd=2.05 as=0.1036 ps=1.02 w=0.74 l=0.15
X3891 a_29134_16877# single_9b_cdac_1.SW[7] VDPWR VDPWR sky130_fd_pr__pfet_01v8 ad=0.435 pd=3.58 as=0.435 ps=3.58 w=1.5 l=0.5
X3892 single_9b_cdac_1.cdac_sw_9b_0.cdac_sw_3_3.nooverlap_clk_0.x10.A single_9b_cdac_1.cdac_sw_9b_0.cdac_sw_3_3.nooverlap_clk_0.x8.A VDPWR VDPWR sky130_fd_pr__pfet_01v8 ad=0.168 pd=1.42 as=0.168 ps=1.42 w=1.12 l=0.15
X3893 a_7145_23226# sar9b_0.clk_div_0.COUNT\[2\] VGND VGND sky130_fd_pr__nfet_01v8 ad=0.08937 pd=0.925 as=0.25675 ps=1.44 w=0.65 l=0.15
X3894 a_7035_22708# a_6337_22714# a_6778_22682# VGND sky130_fd_pr__special_nfet_01v8 ad=0.0684 pd=0.74 as=0.0989 ps=0.995 w=0.36 l=0.15
X3895 VDPWR single_9b_cdac_1.cdac_sw_9b_0.cdac_sw_3_2.nooverlap_clk_0.x10.A single_9b_cdac_1.cdac_sw_9b_0.cdac_sw_3_2.tg_sw_3_3.SWN VDPWR sky130_fd_pr__pfet_01v8 ad=0.3864 pd=2.93 as=0.168 ps=1.42 w=1.12 l=0.15
X3896 VDPWR VGND VDPWR VDPWR sky130_fd_pr__pfet_01v8_hvt ad=0.2262 pd=2.26 as=0 ps=0 w=0.87 l=0.59
X3897 sar9b_0.clknet_1_0__leaf_CLK a_6701_20506# VGND VGND sky130_fd_pr__nfet_01v8 ad=0.0588 pd=0.7 as=0.0588 ps=0.7 w=0.42 l=0.15
X3898 th_dif_sw_0.VCP single_9b_cdac_1.cdac_sw_9b_0.S[0] sky130_fd_pr__cap_mim_m3_1 l=2 w=2
X3899 th_dif_sw_0.VCN single_9b_cdac_0.cdac_sw_9b_0.S[2] sky130_fd_pr__cap_mim_m3_1 l=2 w=2
X3900 single_9b_cdac_0.cdac_sw_9b_0.cdac_sw_3_4.tg_sw_3_3.SWP single_9b_cdac_0.cdac_sw_9b_0.cdac_sw_3_4.tg_sw_3_3.SWN VGND VGND sky130_fd_pr__nfet_01v8_lvt ad=0.1036 pd=1.02 as=0.1554 ps=1.16 w=0.74 l=0.15
X3901 VDPWR single_9b_cdac_1.cdac_sw_9b_0.cdac_sw_3_3.nooverlap_clk_0.x8.A single_9b_cdac_1.cdac_sw_9b_0.cdac_sw_3_3.nooverlap_clk_0.x10.A VDPWR sky130_fd_pr__pfet_01v8 ad=0.168 pd=1.42 as=0.168 ps=1.42 w=1.12 l=0.15
X3902 ua[0] single_9b_cdac_0.cdac_sw_9b_0.cdac_sw_3_1.tg_sw_3_3.SWP ua[0] VDPWR sky130_fd_pr__pfet_01v8 ad=0.435 pd=3.58 as=0 ps=0 w=1.5 l=0.5
X3903 a_9665_22406# a_9447_22164# VGND VGND sky130_fd_pr__nfet_01v8 ad=0.0999 pd=0.985 as=0.1346 ps=1.15 w=0.64 l=0.15
X3904 single_9b_cdac_1.cdac_sw_9b_0.cdac_sw_3_4.tg_sw_3_3.SWN single_9b_cdac_1.cdac_sw_9b_0.cdac_sw_3_4.nooverlap_clk_0.x10.A VGND VGND sky130_fd_pr__nfet_01v8_lvt ad=0.1036 pd=1.02 as=0.1295 ps=1.09 w=0.74 l=0.15
X3905 single_9b_cdac_1.cdac_sw_9b_0.cdac_sw_3_2.tg_sw_3_3.SWN single_9b_cdac_1.cdac_sw_9b_0.cdac_sw_3_2.nooverlap_clk_0.x10.A VDPWR VDPWR sky130_fd_pr__pfet_01v8 ad=0.168 pd=1.42 as=0.196 ps=1.47 w=1.12 l=0.15
X3906 VGND VDPWR VGND VGND sky130_fd_pr__nfet_01v8 ad=0.143 pd=1.62 as=0 ps=0 w=0.55 l=0.59
X3907 th_dif_sw_0.VCP single_9b_cdac_1.cdac_sw_9b_0.S[1] sky130_fd_pr__cap_mim_m3_1 l=2 w=2
X3908 single_9b_cdac_1.cdac_sw_9b_0.cdac_sw_3_3.nooverlap_clk_0.x10.A single_9b_cdac_1.cdac_sw_9b_0.cdac_sw_3_3.nooverlap_clk_0.x8.A VDPWR VDPWR sky130_fd_pr__pfet_01v8 ad=0.168 pd=1.42 as=0.3304 ps=2.83 w=1.12 l=0.15
X3909 single_9b_cdac_0.cdac_sw_9b_0.S[8] single_9b_cdac_0.cdac_sw_9b_0.cdac_sw_3_8.tg_sw_3_3.SWN ua[0] VDPWR sky130_fd_pr__pfet_01v8 ad=0.435 pd=3.58 as=0.435 ps=3.58 w=1.5 l=0.5
X3910 VGND VDPWR VGND VGND sky130_fd_pr__nfet_01v8 ad=0.143 pd=1.62 as=0 ps=0 w=0.55 l=0.59
X3911 VDPWR sar9b_0.net9 a_12887_22714# VDPWR sky130_fd_pr__pfet_01v8_hvt ad=0.0864 pd=0.91 as=0.1664 ps=1.8 w=0.64 l=0.15
X3912 a_9543_22164# a_9097_22164# a_9447_22164# VGND sky130_fd_pr__special_nfet_01v8 ad=0.1401 pd=1.1 as=0.0594 ps=0.69 w=0.36 l=0.15
X3913 VDPWR VGND VDPWR VDPWR sky130_fd_pr__pfet_01v8_hvt ad=0.2262 pd=2.26 as=0 ps=0 w=0.87 l=0.59
X3914 VGND single_9b_cdac_0.cdac_sw_9b_0.cdac_sw_3_5.nooverlap_clk_0.sky130_fd_sc_hs__inv_8_0.A single_9b_cdac_0.cdac_sw_9b_0.cdac_sw_3_5.nooverlap_clk_0.CLKB0 VGND sky130_fd_pr__nfet_01v8_lvt ad=0.1554 pd=1.16 as=0.1036 ps=1.02 w=0.74 l=0.15
X3915 VDPWR VGND VDPWR VDPWR sky130_fd_pr__pfet_01v8_hvt ad=0.2262 pd=2.26 as=0 ps=0 w=0.87 l=0.59
X3916 th_dif_sw_0.VCP single_9b_cdac_1.cdac_sw_9b_0.S[0] sky130_fd_pr__cap_mim_m3_1 l=2 w=2
X3917 single_9b_cdac_0.cdac_sw_9b_0.cdac_sw_3_0.tg_sw_3_3.SWN single_9b_cdac_0.cdac_sw_9b_0.cdac_sw_3_0.nooverlap_clk_0.x10.A VGND VGND sky130_fd_pr__nfet_01v8_lvt ad=0.1036 pd=1.02 as=0.1554 ps=1.16 w=0.74 l=0.15
X3918 VDPWR a_7345_21594# sar9b_0.clknet_0_CLK VDPWR sky130_fd_pr__pfet_01v8_hvt ad=0.14 pd=1.28 as=0.14 ps=1.28 w=1 l=0.15
X3919 a_5601_26516# a_5435_26516# VDPWR VDPWR sky130_fd_pr__pfet_01v8_hvt ad=0.1664 pd=1.8 as=0.0864 ps=0.91 w=0.64 l=0.15
X3920 single_9b_cdac_0.cdac_sw_9b_0.S[8] single_9b_cdac_0.cdac_sw_9b_0.cdac_sw_3_8.nooverlap_clk_0.CLKB0 a_24332_26999# VDPWR sky130_fd_pr__pfet_01v8 ad=0.435 pd=3.58 as=0.435 ps=3.58 w=1.5 l=0.5
X3921 a_6679_22316# a_6943_22316# VGND VGND sky130_fd_pr__nfet_01v8 ad=0.05985 pd=0.705 as=0.0567 ps=0.69 w=0.42 l=0.15
X3922 single_9b_cdac_1.cdac_sw_9b_0.cdac_sw_3_5.nooverlap_clk_0.sky130_fd_sc_hs__inv_8_0.A single_9b_cdac_1.cdac_sw_9b_0.cdac_sw_3_5.nooverlap_clk_0.x1.A VGND VGND sky130_fd_pr__nfet_01v8_lvt ad=0.1184 pd=1.06 as=0.2331 ps=2.11 w=0.74 l=0.15
X3923 a_63626_17740# single_9b_cdac_1.cdac_sw_9b_0.cdac_sw_3_2.nooverlap_clk_0.CLK0 single_9b_cdac_1.cdac_sw_9b_0.S[0] VGND sky130_fd_pr__nfet_01v8 ad=0.145 pd=1.58 as=0.145 ps=1.58 w=0.5 l=0.5
X3924 a_11303_25794# sar9b_0.net15 VDPWR VDPWR sky130_fd_pr__pfet_01v8_hvt ad=0.1092 pd=1.36 as=0.07035 ps=0.755 w=0.42 l=0.15
X3925 a_11689_21318# a_11471_21076# VDPWR VDPWR sky130_fd_pr__pfet_01v8_hvt ad=0.12915 pd=1.185 as=0.2184 ps=2.2 w=0.84 l=0.15
X3926 single_9b_cdac_1.cdac_sw_9b_0.S[8] single_9b_cdac_1.cdac_sw_9b_0.cdac_sw_3_8.tg_sw_3_3.SWN ua[0] VDPWR sky130_fd_pr__pfet_01v8 ad=0.435 pd=3.58 as=0.435 ps=3.58 w=1.5 l=0.5
X3927 VGND single_9b_cdac_1.cdac_sw_9b_0.cdac_sw_3_7.tg_sw_3_3.SWN single_9b_cdac_1.cdac_sw_9b_0.cdac_sw_3_7.tg_sw_3_3.SWP VGND sky130_fd_pr__nfet_01v8_lvt ad=0.2146 pd=2.06 as=0.1036 ps=1.02 w=0.74 l=0.15
X3928 VGND single_9b_cdac_1.cdac_sw_9b_0.cdac_sw_3_5.nooverlap_clk_0.sky130_fd_sc_hs__inv_8_0.A single_9b_cdac_1.cdac_sw_9b_0.cdac_sw_3_5.nooverlap_clk_0.CLKB0 VGND sky130_fd_pr__nfet_01v8_lvt ad=0.1295 pd=1.09 as=0.1036 ps=1.02 w=0.74 l=0.15
X3929 th_dif_sw_0.VCN single_9b_cdac_0.cdac_sw_9b_0.S[1] sky130_fd_pr__cap_mim_m3_1 l=2 w=2
X3930 single_9b_cdac_0.cdac_sw_9b_0.S[7] single_9b_cdac_0.cdac_sw_9b_0.cdac_sw_3_7.tg_sw_3_3.SWN ua[0] VDPWR sky130_fd_pr__pfet_01v8 ad=0.435 pd=3.58 as=0.435 ps=3.58 w=1.5 l=0.5
X3931 VDPWR a_13968_19822# a_14143_19748# VDPWR sky130_fd_pr__pfet_01v8_hvt ad=0.1134 pd=1.38 as=0.0567 ps=0.69 w=0.42 l=0.15
X3932 a_9774_19266# a_9648_19168# a_9370_19152# VGND sky130_fd_pr__special_nfet_01v8 ad=0.0999 pd=0.985 as=0.0711 ps=0.755 w=0.36 l=0.15
X3933 a_8783_23796# a_8085_23802# a_8526_23770# VGND sky130_fd_pr__special_nfet_01v8 ad=0.0684 pd=0.74 as=0.0989 ps=0.995 w=0.36 l=0.15
X3934 tdc_0.phase_detector_0.pd_out_0.B tdc_0.phase_detector_0.INN a_15400_11316# VDPWR sky130_fd_pr__pfet_01v8 ad=0.435 pd=3.29 as=0.435 ps=3.29 w=3 l=0.15
X3935 VGND VDPWR VGND VGND sky130_fd_pr__nfet_01v8 ad=0.143 pd=1.62 as=0 ps=0 w=0.55 l=0.59
X3936 single_9b_cdac_0.cdac_sw_9b_0.cdac_sw_3_6.tg_sw_3_3.SWN single_9b_cdac_0.cdac_sw_9b_0.cdac_sw_3_6.nooverlap_clk_0.x10.A VGND VGND sky130_fd_pr__nfet_01v8_lvt ad=0.1036 pd=1.02 as=0.1036 ps=1.02 w=0.74 l=0.15
X3937 VDPWR VGND VDPWR VDPWR sky130_fd_pr__pfet_01v8_hvt ad=0.2262 pd=2.26 as=0 ps=0 w=0.87 l=0.59
X3938 th_dif_sw_0.VCN single_9b_cdac_0.cdac_sw_9b_0.S[0] sky130_fd_pr__cap_mim_m3_1 l=2 w=2
X3939 a_13053_21076# a_12887_21076# VGND VGND sky130_fd_pr__nfet_01v8 ad=0.1092 pd=1.36 as=0.0567 ps=0.69 w=0.42 l=0.15
X3940 single_9b_cdac_0.cdac_sw_9b_0.S[7] single_9b_cdac_0.cdac_sw_9b_0.cdac_sw_3_7.nooverlap_clk_0.CLKB0 a_29134_26999# VDPWR sky130_fd_pr__pfet_01v8 ad=0.435 pd=3.58 as=0.435 ps=3.58 w=1.5 l=0.5
X3941 VDPWR a_11392_25262# a_11567_25188# VDPWR sky130_fd_pr__pfet_01v8_hvt ad=0.1134 pd=1.38 as=0.0567 ps=0.69 w=0.42 l=0.15
X3942 VGND VDPWR VGND VGND sky130_fd_pr__nfet_01v8 ad=0.143 pd=1.62 as=0 ps=0 w=0.55 l=0.59
X3943 VDPWR VGND VDPWR VDPWR sky130_fd_pr__pfet_01v8_hvt ad=0.2262 pd=2.26 as=0 ps=0 w=0.87 l=0.59
X3944 VDPWR VGND VDPWR VDPWR sky130_fd_pr__pfet_01v8_hvt ad=0.2262 pd=2.26 as=0 ps=0 w=0.87 l=0.59
X3945 VGND single_9b_cdac_0.cdac_sw_9b_0.cdac_sw_3_7.nooverlap_clk_0.x4.A single_9b_cdac_0.cdac_sw_9b_0.cdac_sw_3_7.nooverlap_clk_0.x6.A VGND sky130_fd_pr__nfet_01v8_lvt ad=0.2627 pd=2.19 as=0.2109 ps=2.05 w=0.74 l=0.15
X3946 VDPWR single_9b_cdac_0.cdac_sw_9b_0.cdac_sw_3_7.nooverlap_clk_0.x6.A single_9b_cdac_0.cdac_sw_9b_0.cdac_sw_3_7.nooverlap_clk_0.x8.A VDPWR sky130_fd_pr__pfet_01v8 ad=0.3864 pd=2.93 as=0.3304 ps=2.83 w=1.12 l=0.15
X3947 sar9b_0.net15 a_6930_20241# VGND VGND sky130_fd_pr__nfet_01v8 ad=0.08775 pd=0.92 as=0.10563 ps=0.975 w=0.65 l=0.15
X3948 a_33936_16877# single_9b_cdac_1.SW[6] VDPWR VDPWR sky130_fd_pr__pfet_01v8 ad=0.435 pd=3.58 as=0.435 ps=3.58 w=1.5 l=0.5
X3949 th_dif_sw_0.VCN single_9b_cdac_0.cdac_sw_9b_0.S[0] sky130_fd_pr__cap_mim_m3_1 l=2 w=2
X3950 th_dif_sw_0.VCN single_9b_cdac_0.cdac_sw_9b_0.S[1] sky130_fd_pr__cap_mim_m3_1 l=2 w=2
X3951 VDPWR single_9b_cdac_0.cdac_sw_9b_0.cdac_sw_3_8.tg_sw_3_3.SWN single_9b_cdac_0.cdac_sw_9b_0.cdac_sw_3_8.tg_sw_3_3.SWP VDPWR sky130_fd_pr__pfet_01v8 ad=0.3304 pd=2.83 as=0.168 ps=1.42 w=1.12 l=0.15
X3952 th_dif_sw_0.VCP single_9b_cdac_1.cdac_sw_9b_0.S[5] sky130_fd_pr__cap_mim_m3_1 l=2 w=2
X3953 VGND sar9b_0.net12 a_12887_25428# VGND sky130_fd_pr__nfet_01v8 ad=0.0567 pd=0.69 as=0.1092 ps=1.36 w=0.42 l=0.15
X3954 VDPWR single_9b_cdac_1.cdac_sw_9b_0.cdac_sw_3_1.nooverlap_clk_0.CLKB0 single_9b_cdac_1.cdac_sw_9b_0.cdac_sw_3_1.nooverlap_clk_0.CLK0 VDPWR sky130_fd_pr__pfet_01v8 ad=0.196 pd=1.47 as=0.168 ps=1.42 w=1.12 l=0.15
X3955 VDPWR VGND VDPWR VDPWR sky130_fd_pr__pfet_01v8_hvt ad=0.2262 pd=2.26 as=0 ps=0 w=0.87 l=0.59
X3956 VGND VDPWR VGND VGND sky130_fd_pr__nfet_01v8 ad=0.143 pd=1.62 as=0 ps=0 w=0.55 l=0.59
X3957 single_9b_cdac_0.cdac_sw_9b_0.cdac_sw_3_8.tg_sw_3_3.SWP single_9b_cdac_0.cdac_sw_9b_0.cdac_sw_3_8.tg_sw_3_3.SWN VDPWR VDPWR sky130_fd_pr__pfet_01v8 ad=0.168 pd=1.42 as=0.196 ps=1.47 w=1.12 l=0.15
X3958 VGND single_9b_cdac_0.cdac_sw_9b_0.cdac_sw_3_1.tg_sw_3_3.SWN single_9b_cdac_0.cdac_sw_9b_0.cdac_sw_3_1.tg_sw_3_3.SWP VGND sky130_fd_pr__nfet_01v8_lvt ad=0.1295 pd=1.09 as=0.1036 ps=1.02 w=0.74 l=0.15
X3959 VGND VDPWR VGND VGND sky130_fd_pr__nfet_01v8 ad=0.143 pd=1.62 as=0 ps=0 w=0.55 l=0.59
X3960 single_9b_cdac_1.cdac_sw_9b_0.cdac_sw_3_7.nooverlap_clk_0.x8.A single_9b_cdac_1.cdac_sw_9b_0.cdac_sw_3_7.nooverlap_clk_0.x6.A VGND VGND sky130_fd_pr__nfet_01v8_lvt ad=0.2109 pd=2.05 as=0.2627 ps=2.19 w=0.74 l=0.15
X3961 th_dif_sw_0.VCP single_9b_cdac_1.cdac_sw_9b_0.S[3] sky130_fd_pr__cap_mim_m3_1 l=2 w=2
X3962 th_dif_sw_0.VCN single_9b_cdac_0.cdac_sw_9b_0.S[2] sky130_fd_pr__cap_mim_m3_1 l=2 w=2
X3963 th_dif_sw_0.VCN single_9b_cdac_0.cdac_sw_9b_0.S[0] sky130_fd_pr__cap_mim_m3_1 l=2 w=2
X3964 VDPWR a_7620_26350# a_7795_26276# VDPWR sky130_fd_pr__pfet_01v8_hvt ad=0.1134 pd=1.38 as=0.0567 ps=0.69 w=0.42 l=0.15
X3965 single_9b_cdac_0.SW[4] a_14451_25972# VDPWR VDPWR sky130_fd_pr__pfet_01v8_hvt ad=0.2054 pd=2.1 as=0.11455 ps=1.08 w=0.79 l=0.15
X3966 single_9b_cdac_1.cdac_sw_9b_0.cdac_sw_3_4.nooverlap_clk_0.CLKB0 single_9b_cdac_1.cdac_sw_9b_0.cdac_sw_3_4.nooverlap_clk_0.sky130_fd_sc_hs__inv_8_0.A VGND VGND sky130_fd_pr__nfet_01v8_lvt ad=0.1036 pd=1.02 as=0.1554 ps=1.16 w=0.74 l=0.15
X3967 single_9b_cdac_1.cdac_sw_9b_0.cdac_sw_3_1.nooverlap_clk_0.CLK0 single_9b_cdac_1.cdac_sw_9b_0.cdac_sw_3_1.nooverlap_clk_0.CLKB0 VDPWR VDPWR sky130_fd_pr__pfet_01v8 ad=0.168 pd=1.42 as=0.168 ps=1.42 w=1.12 l=0.15
X3968 VGND VDPWR VGND VGND sky130_fd_pr__nfet_01v8 ad=0.143 pd=1.62 as=0 ps=0 w=0.55 l=0.59
X3969 single_9b_cdac_1.cdac_sw_9b_0.S[1] single_9b_cdac_1.cdac_sw_9b_0.cdac_sw_3_1.tg_sw_3_3.SWP single_9b_cdac_1.cdac_sw_9b_0.S[1] VDPWR sky130_fd_pr__pfet_01v8 ad=0.435 pd=3.58 as=0 ps=0 w=1.5 l=0.5
X3970 VDPWR VGND VDPWR VDPWR sky130_fd_pr__pfet_01v8_hvt ad=0.2262 pd=2.26 as=0 ps=0 w=0.87 l=0.59
X3971 VDPWR a_5393_17977# th_dif_sw_0.CKB VDPWR sky130_fd_pr__pfet_01v8_hvt ad=0.11455 pd=1.08 as=0.2054 ps=2.1 w=0.79 l=0.15
X3972 single_9b_cdac_1.cdac_sw_9b_0.cdac_sw_3_3.nooverlap_clk_0.x1.A single_9b_cdac_1.cdac_sw_9b_0.cdac_sw_3_3.nooverlap_clk_0.sky130_fd_sc_hs__inv_1_1.A VDPWR VDPWR sky130_fd_pr__pfet_01v8 ad=0.3304 pd=2.83 as=0.3864 ps=2.93 w=1.12 l=0.15
X3973 th_dif_sw_0.VCP single_9b_cdac_1.cdac_sw_9b_0.S[0] sky130_fd_pr__cap_mim_m3_1 l=2 w=2
X3974 single_9b_cdac_1.cdac_sw_9b_0.cdac_sw_3_2.nooverlap_clk_0.x3.Y single_9b_cdac_1.CF[0] VGND VGND sky130_fd_pr__nfet_01v8_lvt ad=0.2109 pd=2.05 as=0.2627 ps=2.19 w=0.74 l=0.15
X3975 VDPWR single_9b_cdac_1.cdac_sw_9b_0.cdac_sw_3_1.nooverlap_clk_0.CLKB0 single_9b_cdac_1.cdac_sw_9b_0.cdac_sw_3_1.nooverlap_clk_0.CLK0 VDPWR sky130_fd_pr__pfet_01v8 ad=0.168 pd=1.42 as=0.168 ps=1.42 w=1.12 l=0.15
X3976 VDPWR single_9b_cdac_0.cdac_sw_9b_0.cdac_sw_3_8.nooverlap_clk_0.x1.A single_9b_cdac_0.cdac_sw_9b_0.cdac_sw_3_8.nooverlap_clk_0.sky130_fd_sc_hs__inv_8_0.A VDPWR sky130_fd_pr__pfet_01v8 ad=0.3304 pd=2.83 as=0.168 ps=1.42 w=1.12 l=0.15
X3977 VGND single_9b_cdac_0.cdac_sw_9b_0.cdac_sw_3_5.nooverlap_clk_0.x10.A single_9b_cdac_0.cdac_sw_9b_0.cdac_sw_3_5.tg_sw_3_3.SWN VGND sky130_fd_pr__nfet_01v8_lvt ad=0.1036 pd=1.02 as=0.1036 ps=1.02 w=0.74 l=0.15
X3978 VGND VDPWR VGND VGND sky130_fd_pr__nfet_01v8 ad=0.143 pd=1.62 as=0 ps=0 w=0.55 l=0.59
X3979 single_9b_cdac_1.cdac_sw_9b_0.S[7] single_9b_cdac_1.cdac_sw_9b_0.cdac_sw_3_7.tg_sw_3_3.SWP single_9b_cdac_1.cdac_sw_9b_0.S[7] VDPWR sky130_fd_pr__pfet_01v8 ad=0.435 pd=3.58 as=0 ps=0 w=1.5 l=0.5
X3980 single_9b_cdac_0.cdac_sw_9b_0.S[5] single_9b_cdac_0.cdac_sw_9b_0.cdac_sw_3_5.tg_sw_3_3.SWP single_9b_cdac_0.cdac_sw_9b_0.S[5] VDPWR sky130_fd_pr__pfet_01v8 ad=0.435 pd=3.58 as=6.96 ps=57.28 w=1.5 l=0.5
X3981 single_9b_cdac_1.cdac_sw_9b_0.cdac_sw_3_1.nooverlap_clk_0.CLK0 single_9b_cdac_1.cdac_sw_9b_0.cdac_sw_3_1.nooverlap_clk_0.CLKB0 VDPWR VDPWR sky130_fd_pr__pfet_01v8 ad=0.168 pd=1.42 as=0.196 ps=1.47 w=1.12 l=0.15
X3982 single_9b_cdac_1.cdac_sw_9b_0.cdac_sw_3_8.tg_sw_3_3.SWP single_9b_cdac_1.cdac_sw_9b_0.cdac_sw_3_8.tg_sw_3_3.SWN VGND VGND sky130_fd_pr__nfet_01v8_lvt ad=0.1036 pd=1.02 as=0.2109 ps=2.05 w=0.74 l=0.15
X3983 VDPWR single_9b_cdac_1.CF[0] single_9b_cdac_0.cdac_sw_9b_0.cdac_sw_3_2.nooverlap_clk_0.sky130_fd_sc_hs__nand2_1_0.Y VDPWR sky130_fd_pr__pfet_01v8 ad=0.3192 pd=2.81 as=0.168 ps=1.42 w=1.12 l=0.15
X3984 a_9097_22164# a_8931_22164# VGND VGND sky130_fd_pr__nfet_01v8 ad=0.1092 pd=1.36 as=0.0567 ps=0.69 w=0.42 l=0.15
X3985 th_dif_sw_0.VCN single_9b_cdac_0.cdac_sw_9b_0.S[0] sky130_fd_pr__cap_mim_m3_1 l=2 w=2
X3986 VGND single_9b_cdac_0.SW[1] a_58824_26990# VGND sky130_fd_pr__nfet_01v8 ad=0.145 pd=1.58 as=0.145 ps=1.58 w=0.5 l=0.5
X3987 single_9b_cdac_0.cdac_sw_9b_0.S[6] single_9b_cdac_0.cdac_sw_9b_0.cdac_sw_3_6.tg_sw_3_3.SWN ua[0] VDPWR sky130_fd_pr__pfet_01v8 ad=0.435 pd=3.58 as=0.435 ps=3.58 w=1.5 l=0.5
X3988 a_13968_18900# a_12887_18900# a_13621_19142# VDPWR sky130_fd_pr__pfet_01v8_hvt ad=0.0588 pd=0.7 as=0.12915 ps=1.185 w=0.42 l=0.15
X3989 th_dif_sw_0.VCN single_9b_cdac_0.cdac_sw_9b_0.S[0] sky130_fd_pr__cap_mim_m3_1 l=2 w=2
X3990 VGND single_9b_cdac_0.SW[6] a_34814_26990# VGND sky130_fd_pr__nfet_01v8 ad=0.145 pd=1.58 as=0.145 ps=1.58 w=0.5 l=0.5
X3991 single_9b_cdac_0.cdac_sw_9b_0.cdac_sw_3_2.nooverlap_clk_0.sky130_fd_sc_hs__nand2_1_0.Y single_9b_cdac_0.cdac_sw_9b_0.cdac_sw_3_2.nooverlap_clk_0.x8.A VDPWR VDPWR sky130_fd_pr__pfet_01v8 ad=0.168 pd=1.42 as=0.3192 ps=2.81 w=1.12 l=0.15
X3992 single_9b_cdac_0.cdac_sw_9b_0.S[0] single_9b_cdac_0.cdac_sw_9b_0.cdac_sw_3_2.tg_sw_3_3.SWP ua[0] VGND sky130_fd_pr__nfet_01v8 ad=0.145 pd=1.58 as=0.145 ps=1.58 w=0.5 l=0.5
X3993 a_57946_26999# single_9b_cdac_0.SW[1] VDPWR VDPWR sky130_fd_pr__pfet_01v8 ad=0.435 pd=3.58 as=0.435 ps=3.58 w=1.5 l=0.5
X3994 VDPWR single_9b_cdac_1.cdac_sw_9b_0.cdac_sw_3_3.nooverlap_clk_0.x10.A single_9b_cdac_1.cdac_sw_9b_0.cdac_sw_3_3.tg_sw_3_3.SWN VDPWR sky130_fd_pr__pfet_01v8 ad=0.196 pd=1.47 as=0.168 ps=1.42 w=1.12 l=0.15
X3995 th_dif_sw_0.VCP single_9b_cdac_1.cdac_sw_9b_0.S[1] sky130_fd_pr__cap_mim_m3_1 l=2 w=2
X3996 VGND single_9b_cdac_0.cdac_sw_9b_0.cdac_sw_3_7.tg_sw_3_3.SWN single_9b_cdac_0.cdac_sw_9b_0.cdac_sw_3_7.tg_sw_3_3.SWP VGND sky130_fd_pr__nfet_01v8_lvt ad=0.2109 pd=2.05 as=0.1036 ps=1.02 w=0.74 l=0.15
X3997 sar9b_0.net25 a_12947_26276# VDPWR VDPWR sky130_fd_pr__pfet_01v8_hvt ad=0.26 pd=2.52 as=0.3012 ps=2.66 w=1 l=0.15
X3998 VGND VDPWR VGND VGND sky130_fd_pr__nfet_01v8 ad=0.143 pd=1.62 as=0 ps=0 w=0.55 l=0.59
X3999 th_dif_sw_0.VCN single_9b_cdac_0.cdac_sw_9b_0.S[1] sky130_fd_pr__cap_mim_m3_1 l=2 w=2
X4000 VGND single_9b_cdac_0.cdac_sw_9b_0.cdac_sw_3_3.nooverlap_clk_0.x10.A single_9b_cdac_0.cdac_sw_9b_0.cdac_sw_3_3.tg_sw_3_3.SWN VGND sky130_fd_pr__nfet_01v8_lvt ad=0.1554 pd=1.16 as=0.1036 ps=1.02 w=0.74 l=0.15
X4001 th_dif_sw_0.VCN single_9b_cdac_0.cdac_sw_9b_0.S[0] sky130_fd_pr__cap_mim_m3_1 l=2 w=2
X4002 th_dif_sw_0.VCN single_9b_cdac_0.cdac_sw_9b_0.S[0] sky130_fd_pr__cap_mim_m3_1 l=2 w=2
X4003 a_7059_25402# sar9b_0.net3 VDPWR VDPWR sky130_fd_pr__pfet_01v8_hvt ad=0.0567 pd=0.69 as=0.0819 ps=0.81 w=0.42 l=0.15
X4004 VDPWR VGND VDPWR VDPWR sky130_fd_pr__pfet_01v8_hvt ad=0.2262 pd=2.26 as=0 ps=0 w=0.87 l=0.59
X4005 VDPWR a_6587_21852# sar9b_0._08_ VDPWR sky130_fd_pr__pfet_01v8_hvt ad=0.14825 pd=1.34 as=0.275 ps=2.55 w=1 l=0.15
X4006 a_9604_19266# a_9167_18874# VDPWR VDPWR sky130_fd_pr__pfet_01v8_hvt ad=0.0567 pd=0.69 as=0.0819 ps=0.81 w=0.42 l=0.15
X4007 a_13308_18900# sar9b_0.net2 VGND VGND sky130_fd_pr__nfet_01v8 ad=0.066 pd=0.745 as=0.2205 ps=1.89 w=0.42 l=0.15
X4008 a_12198_26882# a_11121_26516# a_12036_26516# VDPWR sky130_fd_pr__pfet_01v8_hvt ad=0.0567 pd=0.69 as=0.0588 ps=0.7 w=0.42 l=0.15
X4009 th_dif_sw_0.VCP single_9b_cdac_1.cdac_sw_9b_0.S[0] sky130_fd_pr__cap_mim_m3_1 l=2 w=2
X4010 a_16970_11404# tdc_0.phase_detector_0.INP VGND VGND sky130_fd_pr__nfet_01v8 ad=0.145 pd=1.29 as=0.29 ps=2.58 w=1 l=0.15
X4011 a_11733_26516# a_11689_26758# a_11567_26516# VGND sky130_fd_pr__nfet_01v8 ad=0.0441 pd=0.63 as=0.1401 ps=1.1 w=0.42 l=0.15
X4012 th_dif_sw_0.CK a_14451_17812# VDPWR VDPWR sky130_fd_pr__pfet_01v8_hvt ad=0.2054 pd=2.1 as=0.11455 ps=1.08 w=0.79 l=0.15
X4013 VGND single_9b_cdac_1.cdac_sw_9b_0.cdac_sw_3_5.nooverlap_clk_0.sky130_fd_sc_hs__inv_8_0.A single_9b_cdac_1.cdac_sw_9b_0.cdac_sw_3_5.nooverlap_clk_0.CLKB0 VGND sky130_fd_pr__nfet_01v8_lvt ad=0.1036 pd=1.02 as=0.1036 ps=1.02 w=0.74 l=0.15
X4014 single_9b_cdac_1.cdac_sw_9b_0.cdac_sw_3_3.nooverlap_clk_0.x10.A single_9b_cdac_1.cdac_sw_9b_0.cdac_sw_3_3.nooverlap_clk_0.x8.A VGND VGND sky130_fd_pr__nfet_01v8_lvt ad=0.1184 pd=1.06 as=0.2331 ps=2.11 w=0.74 l=0.15
X4015 VGND single_9b_cdac_1.cdac_sw_9b_0.cdac_sw_3_4.nooverlap_clk_0.x10.A single_9b_cdac_1.cdac_sw_9b_0.cdac_sw_3_4.tg_sw_3_3.SWN VGND sky130_fd_pr__nfet_01v8_lvt ad=0.2146 pd=2.06 as=0.1036 ps=1.02 w=0.74 l=0.15
X4016 th_dif_sw_0.VCN single_9b_cdac_0.cdac_sw_9b_0.S[2] sky130_fd_pr__cap_mim_m3_1 l=2 w=2
X4017 VDPWR a_6907_19444# sar9b_0.clkload0.X VDPWR sky130_fd_pr__pfet_01v8_hvt ad=0.3 pd=2.6 as=0.14 ps=1.28 w=1 l=0.15
X4018 VDPWR VGND VDPWR VDPWR sky130_fd_pr__pfet_01v8_hvt ad=0.2262 pd=2.26 as=0 ps=0 w=0.87 l=0.59
X4019 VGND single_9b_cdac_1.cdac_sw_9b_0.cdac_sw_3_3.nooverlap_clk_0.x10.A single_9b_cdac_1.cdac_sw_9b_0.cdac_sw_3_3.tg_sw_3_3.SWN VGND sky130_fd_pr__nfet_01v8_lvt ad=0.1295 pd=1.09 as=0.1036 ps=1.02 w=0.74 l=0.15
X4020 single_9b_cdac_1.cdac_sw_9b_0.cdac_sw_3_6.nooverlap_clk_0.x3.Y single_9b_cdac_1.CF[6] VDPWR VDPWR sky130_fd_pr__pfet_01v8 ad=0.3304 pd=2.83 as=0.3864 ps=2.93 w=1.12 l=0.15
X4021 VDPWR single_9b_cdac_0.cdac_sw_9b_0.cdac_sw_3_6.nooverlap_clk_0.sky130_fd_sc_hs__inv_8_0.A single_9b_cdac_0.cdac_sw_9b_0.cdac_sw_3_6.nooverlap_clk_0.CLKB0 VDPWR sky130_fd_pr__pfet_01v8 ad=0.196 pd=1.47 as=0.168 ps=1.42 w=1.12 l=0.15
X4022 VGND sar9b_0.net31 a_14175_25972# VGND sky130_fd_pr__nfet_01v8 ad=0.0754 pd=0.81 as=0.1352 ps=1.56 w=0.52 l=0.15
X4023 VGND VDPWR VGND VGND sky130_fd_pr__nfet_01v8 ad=0.143 pd=1.62 as=0 ps=0 w=0.55 l=0.59
X4024 th_dif_sw_0.VCP single_9b_cdac_1.cdac_sw_9b_0.S[1] sky130_fd_pr__cap_mim_m3_1 l=2 w=2
X4025 ua[0] single_9b_cdac_1.cdac_sw_9b_0.cdac_sw_3_1.tg_sw_3_3.SWP ua[0] VDPWR sky130_fd_pr__pfet_01v8 ad=0.435 pd=3.58 as=0 ps=0 w=1.5 l=0.5
X4026 single_9b_cdac_0.cdac_sw_9b_0.cdac_sw_3_6.tg_sw_3_3.SWN single_9b_cdac_0.cdac_sw_9b_0.cdac_sw_3_6.nooverlap_clk_0.x10.A VGND VGND sky130_fd_pr__nfet_01v8_lvt ad=0.1036 pd=1.02 as=0.1295 ps=1.09 w=0.74 l=0.15
X4027 VGND VDPWR VGND VGND sky130_fd_pr__nfet_01v8 ad=0.143 pd=1.62 as=0 ps=0 w=0.55 l=0.59
X4028 a_13511_20354# sar9b_0.net15 VDPWR VDPWR sky130_fd_pr__pfet_01v8_hvt ad=0.1092 pd=1.36 as=0.07035 ps=0.755 w=0.42 l=0.15
X4029 VDPWR single_9b_cdac_1.cdac_sw_9b_0.cdac_sw_3_6.nooverlap_clk_0.x10.A single_9b_cdac_1.cdac_sw_9b_0.cdac_sw_3_6.tg_sw_3_3.SWN VDPWR sky130_fd_pr__pfet_01v8 ad=0.3864 pd=2.93 as=0.168 ps=1.42 w=1.12 l=0.15
X4030 th_dif_sw_0.VCP single_9b_cdac_1.cdac_sw_9b_0.S[0] sky130_fd_pr__cap_mim_m3_1 l=2 w=2
X4031 th_dif_sw_0.VCP single_9b_cdac_1.cdac_sw_9b_0.S[3] sky130_fd_pr__cap_mim_m3_1 l=2 w=2
X4032 a_13499_26516# a_13053_26516# a_13403_26516# VGND sky130_fd_pr__special_nfet_01v8 ad=0.1401 pd=1.1 as=0.0594 ps=0.69 w=0.36 l=0.15
X4033 single_9b_cdac_0.cdac_sw_9b_0.cdac_sw_3_6.nooverlap_clk_0.CLKB0 single_9b_cdac_0.cdac_sw_9b_0.cdac_sw_3_6.nooverlap_clk_0.sky130_fd_sc_hs__inv_8_0.A VDPWR VDPWR sky130_fd_pr__pfet_01v8 ad=0.168 pd=1.42 as=0.168 ps=1.42 w=1.12 l=0.15
X4034 th_dif_sw_0.VCN single_9b_cdac_0.cdac_sw_9b_0.S[0] sky130_fd_pr__cap_mim_m3_1 l=2 w=2
X4035 single_9b_cdac_1.cdac_sw_9b_0.S[8] single_9b_cdac_1.cdac_sw_9b_0.cdac_sw_3_8.tg_sw_3_3.SWP ua[0] VGND sky130_fd_pr__nfet_01v8 ad=0.145 pd=1.58 as=0.145 ps=1.58 w=0.5 l=0.5
X4036 a_53154_26999# single_9b_cdac_0.SW[2] VDPWR VDPWR sky130_fd_pr__pfet_01v8 ad=0.435 pd=3.58 as=0.435 ps=3.58 w=1.5 l=0.5
X4037 th_dif_sw_0.VCP single_9b_cdac_1.cdac_sw_9b_0.S[1] sky130_fd_pr__cap_mim_m3_1 l=2 w=2
X4038 single_9b_cdac_0.cdac_sw_9b_0.cdac_sw_3_2.nooverlap_clk_0.sky130_fd_sc_hs__nand2_1_0.Y single_9b_cdac_1.CF[0] a_65367_29911# VGND sky130_fd_pr__nfet_01v8_lvt ad=0.2109 pd=2.05 as=0.0888 ps=0.98 w=0.74 l=0.15
X4039 single_9b_cdac_1.cdac_sw_9b_0.cdac_sw_3_6.tg_sw_3_3.SWN single_9b_cdac_1.cdac_sw_9b_0.cdac_sw_3_6.nooverlap_clk_0.x10.A VDPWR VDPWR sky130_fd_pr__pfet_01v8 ad=0.168 pd=1.42 as=0.196 ps=1.47 w=1.12 l=0.15
X4040 VDPWR single_9b_cdac_1.cdac_sw_9b_0.cdac_sw_3_2.nooverlap_clk_0.x1.A single_9b_cdac_1.cdac_sw_9b_0.cdac_sw_3_2.nooverlap_clk_0.sky130_fd_sc_hs__inv_8_0.A VDPWR sky130_fd_pr__pfet_01v8 ad=0.3304 pd=2.83 as=0.168 ps=1.42 w=1.12 l=0.15
X4041 a_9849_26758# a_9631_26516# VGND VGND sky130_fd_pr__nfet_01v8 ad=0.0999 pd=0.985 as=0.1346 ps=1.15 w=0.64 l=0.15
X4042 VDPWR single_9b_cdac_0.cdac_sw_9b_0.cdac_sw_3_6.nooverlap_clk_0.sky130_fd_sc_hs__inv_8_0.A single_9b_cdac_0.cdac_sw_9b_0.cdac_sw_3_6.nooverlap_clk_0.CLKB0 VDPWR sky130_fd_pr__pfet_01v8 ad=0.168 pd=1.42 as=0.168 ps=1.42 w=1.12 l=0.15
X4043 single_9b_cdac_0.cdac_sw_9b_0.cdac_sw_3_2.nooverlap_clk_0.CLK0 single_9b_cdac_0.cdac_sw_9b_0.cdac_sw_3_2.nooverlap_clk_0.CLKB0 VGND VGND sky130_fd_pr__nfet_01v8_lvt ad=0.1036 pd=1.02 as=0.1036 ps=1.02 w=0.74 l=0.15
X4044 VDPWR single_9b_cdac_0.cdac_sw_9b_0.cdac_sw_3_2.nooverlap_clk_0.CLKB0 single_9b_cdac_0.cdac_sw_9b_0.cdac_sw_3_2.nooverlap_clk_0.CLK0 VDPWR sky130_fd_pr__pfet_01v8 ad=0.196 pd=1.47 as=0.168 ps=1.42 w=1.12 l=0.15
X4045 VGND a_5343_25972# sar9b_0.net3 VGND sky130_fd_pr__nfet_01v8 ad=0.1218 pd=1.42 as=0.0588 ps=0.7 w=0.42 l=0.15
X4046 single_9b_cdac_1.cdac_sw_9b_0.cdac_sw_3_8.nooverlap_clk_0.x6.A single_9b_cdac_1.cdac_sw_9b_0.cdac_sw_3_8.nooverlap_clk_0.x4.A VGND VGND sky130_fd_pr__nfet_01v8_lvt ad=0.2109 pd=2.05 as=0.2627 ps=2.19 w=0.74 l=0.15
X4047 VGND single_9b_cdac_1.cdac_sw_9b_0.cdac_sw_3_6.tg_sw_3_3.SWN single_9b_cdac_1.cdac_sw_9b_0.cdac_sw_3_6.tg_sw_3_3.SWP VGND sky130_fd_pr__nfet_01v8_lvt ad=0.1036 pd=1.02 as=0.1036 ps=1.02 w=0.74 l=0.15
X4048 th_dif_sw_0.VCN single_9b_cdac_0.cdac_sw_9b_0.S[0] sky130_fd_pr__cap_mim_m3_1 l=2 w=2
X4049 VDPWR VGND VDPWR VDPWR sky130_fd_pr__pfet_01v8_hvt ad=0.2262 pd=2.26 as=0 ps=0 w=0.87 l=0.59
X4050 single_9b_cdac_1.cdac_sw_9b_0.S[5] single_9b_cdac_1.cdac_sw_9b_0.cdac_sw_3_5.tg_sw_3_3.SWP single_9b_cdac_1.cdac_sw_9b_0.S[5] VDPWR sky130_fd_pr__pfet_01v8 ad=0.435 pd=3.58 as=0 ps=0 w=1.5 l=0.5
X4051 single_9b_cdac_0.cdac_sw_9b_0.S[4] single_9b_cdac_0.cdac_sw_9b_0.cdac_sw_3_3.tg_sw_3_3.SWP single_9b_cdac_0.cdac_sw_9b_0.S[4] VDPWR sky130_fd_pr__pfet_01v8 ad=0.435 pd=3.58 as=0 ps=0 w=1.5 l=0.5
X4052 a_7813_22316# sar9b_0._06_ VGND VGND sky130_fd_pr__nfet_01v8 ad=0.0567 pd=0.69 as=0.10025 ps=0.985 w=0.42 l=0.15
X4053 VDPWR single_9b_cdac_1.cdac_sw_9b_0.cdac_sw_3_8.nooverlap_clk_0.x8.A single_9b_cdac_1.cdac_sw_9b_0.cdac_sw_3_8.nooverlap_clk_0.sky130_fd_sc_hs__nand2_1_0.Y VDPWR sky130_fd_pr__pfet_01v8 ad=0.3192 pd=2.81 as=0.168 ps=1.42 w=1.12 l=0.15
X4054 a_12207_26350# a_11691_25978# a_12112_26338# VGND sky130_fd_pr__special_nfet_01v8 ad=0.0594 pd=0.69 as=0.066 ps=0.745 w=0.36 l=0.15
X4055 th_dif_sw_0.VCN single_9b_cdac_0.cdac_sw_9b_0.S[0] sky130_fd_pr__cap_mim_m3_1 l=2 w=2
X4056 single_9b_cdac_1.cdac_sw_9b_0.cdac_sw_3_2.nooverlap_clk_0.sky130_fd_sc_hs__inv_8_0.A single_9b_cdac_1.cdac_sw_9b_0.cdac_sw_3_2.nooverlap_clk_0.x1.A VDPWR VDPWR sky130_fd_pr__pfet_01v8 ad=0.168 pd=1.42 as=0.168 ps=1.42 w=1.12 l=0.15
X4057 VGND single_9b_cdac_0.SW[0] a_63626_26990# VGND sky130_fd_pr__nfet_01v8 ad=0.145 pd=1.58 as=0.145 ps=1.58 w=0.5 l=0.5
X4058 single_9b_cdac_1.cdac_sw_9b_0.S[8] single_9b_cdac_1.cdac_sw_9b_0.cdac_sw_3_8.tg_sw_3_3.SWN ua[0] VDPWR sky130_fd_pr__pfet_01v8 ad=0.435 pd=3.58 as=0.435 ps=3.58 w=1.5 l=0.5
X4059 single_9b_cdac_1.cdac_sw_9b_0.cdac_sw_3_5.nooverlap_clk_0.x6.A single_9b_cdac_1.cdac_sw_9b_0.cdac_sw_3_5.nooverlap_clk_0.x4.A VDPWR VDPWR sky130_fd_pr__pfet_01v8 ad=0.3304 pd=2.83 as=0.3864 ps=2.93 w=1.12 l=0.15
X4060 th_dif_sw_0.VCN single_9b_cdac_0.cdac_sw_9b_0.S[1] sky130_fd_pr__cap_mim_m3_1 l=2 w=2
X4061 a_63626_26990# single_9b_cdac_0.cdac_sw_9b_0.cdac_sw_3_2.nooverlap_clk_0.CLK0 single_9b_cdac_0.cdac_sw_9b_0.S[0] VGND sky130_fd_pr__nfet_01v8 ad=0.145 pd=1.58 as=0.145 ps=1.58 w=0.5 l=0.5
X4062 VGND sar9b_0.net15 a_11457_25428# VGND sky130_fd_pr__nfet_01v8 ad=0.1346 pd=1.15 as=0.0441 ps=0.63 w=0.42 l=0.15
X4063 single_9b_cdac_1.cdac_sw_9b_0.cdac_sw_3_8.nooverlap_clk_0.sky130_fd_sc_hs__nand2_1_0.Y single_9b_cdac_1.CF[8] VDPWR VDPWR sky130_fd_pr__pfet_01v8 ad=0.168 pd=1.42 as=0.3192 ps=2.81 w=1.12 l=0.15
X4064 single_9b_cdac_1.cdac_sw_9b_0.S[0] single_9b_cdac_1.cdac_sw_9b_0.cdac_sw_3_2.tg_sw_3_3.SWP ua[0] VGND sky130_fd_pr__nfet_01v8 ad=0.145 pd=1.58 as=0.145 ps=1.58 w=0.5 l=0.5
X4065 VDPWR single_9b_cdac_1.cdac_sw_9b_0.cdac_sw_3_2.nooverlap_clk_0.x1.A single_9b_cdac_1.cdac_sw_9b_0.cdac_sw_3_2.nooverlap_clk_0.sky130_fd_sc_hs__inv_8_0.A VDPWR sky130_fd_pr__pfet_01v8 ad=0.168 pd=1.42 as=0.168 ps=1.42 w=1.12 l=0.15
X4066 VDPWR single_9b_cdac_1.cdac_sw_9b_0.cdac_sw_3_4.nooverlap_clk_0.CLKB0 single_9b_cdac_1.cdac_sw_9b_0.cdac_sw_3_4.nooverlap_clk_0.CLK0 VDPWR sky130_fd_pr__pfet_01v8 ad=0.3864 pd=2.93 as=0.168 ps=1.42 w=1.12 l=0.15
X4067 VDPWR single_9b_cdac_0.cdac_sw_9b_0.cdac_sw_3_7.nooverlap_clk_0.x3.Y single_9b_cdac_0.cdac_sw_9b_0.cdac_sw_3_7.nooverlap_clk_0.x4.A VDPWR sky130_fd_pr__pfet_01v8 ad=0.3192 pd=2.81 as=0.168 ps=1.42 w=1.12 l=0.15
X4068 a_34814_17740# single_9b_cdac_1.cdac_sw_9b_0.cdac_sw_3_6.nooverlap_clk_0.CLK0 single_9b_cdac_1.cdac_sw_9b_0.S[6] VGND sky130_fd_pr__nfet_01v8 ad=0.145 pd=1.58 as=0.145 ps=1.58 w=0.5 l=0.5
X4069 th_dif_sw_0.VCP single_9b_cdac_1.cdac_sw_9b_0.S[2] sky130_fd_pr__cap_mim_m3_1 l=2 w=2
X4070 single_9b_cdac_1.cdac_sw_9b_0.cdac_sw_3_4.nooverlap_clk_0.CLK0 single_9b_cdac_1.cdac_sw_9b_0.cdac_sw_3_4.nooverlap_clk_0.CLKB0 VDPWR VDPWR sky130_fd_pr__pfet_01v8 ad=0.168 pd=1.42 as=0.196 ps=1.47 w=1.12 l=0.15
X4071 th_dif_sw_0.VCN single_9b_cdac_0.cdac_sw_9b_0.S[0] sky130_fd_pr__cap_mim_m3_1 l=2 w=2
X4072 single_9b_cdac_1.cdac_sw_9b_0.cdac_sw_3_2.nooverlap_clk_0.sky130_fd_sc_hs__inv_8_0.A single_9b_cdac_1.cdac_sw_9b_0.cdac_sw_3_2.nooverlap_clk_0.x1.A VDPWR VDPWR sky130_fd_pr__pfet_01v8 ad=0.168 pd=1.42 as=0.3304 ps=2.83 w=1.12 l=0.15
X4073 single_9b_cdac_1.cdac_sw_9b_0.cdac_sw_3_1.nooverlap_clk_0.x1.A single_9b_cdac_1.cdac_sw_9b_0.cdac_sw_3_1.nooverlap_clk_0.sky130_fd_sc_hs__inv_1_1.A VDPWR VDPWR sky130_fd_pr__pfet_01v8 ad=0.3304 pd=2.83 as=0.3864 ps=2.93 w=1.12 l=0.15
X4074 a_13302_18356# a_12225_18362# a_13140_18734# VDPWR sky130_fd_pr__pfet_01v8_hvt ad=0.0567 pd=0.69 as=0.0588 ps=0.7 w=0.42 l=0.15
X4075 single_9b_cdac_0.cdac_sw_9b_0.cdac_sw_3_4.tg_sw_3_3.SWP single_9b_cdac_0.cdac_sw_9b_0.cdac_sw_3_4.tg_sw_3_3.SWN VGND VGND sky130_fd_pr__nfet_01v8_lvt ad=0.1036 pd=1.02 as=0.1295 ps=1.09 w=0.74 l=0.15
X4076 VDPWR sar9b_0.FINAL a_6539_25978# VDPWR sky130_fd_pr__pfet_01v8_hvt ad=0.0864 pd=0.91 as=0.1664 ps=1.8 w=0.64 l=0.15
X4077 th_dif_sw_0.VCN single_9b_cdac_0.cdac_sw_9b_0.S[2] sky130_fd_pr__cap_mim_m3_1 l=2 w=2
X4078 single_9b_cdac_0.cdac_sw_9b_0.cdac_sw_3_7.nooverlap_clk_0.x4.A single_9b_cdac_0.cdac_sw_9b_0.cdac_sw_3_7.nooverlap_clk_0.x1.A VDPWR VDPWR sky130_fd_pr__pfet_01v8 ad=0.168 pd=1.42 as=0.3192 ps=2.81 w=1.12 l=0.15
X4079 th_dif_sw_0.VCP single_9b_cdac_1.cdac_sw_9b_0.S[0] sky130_fd_pr__cap_mim_m3_1 l=2 w=2
X4080 th_dif_sw_0.VCN single_9b_cdac_0.cdac_sw_9b_0.S[1] sky130_fd_pr__cap_mim_m3_1 l=2 w=2
X4081 single_9b_cdac_0.cdac_sw_9b_0.S[7] single_9b_cdac_0.cdac_sw_9b_0.cdac_sw_3_7.tg_sw_3_3.SWP ua[0] VGND sky130_fd_pr__nfet_01v8 ad=0.145 pd=1.58 as=0.145 ps=1.58 w=0.5 l=0.5
X4082 th_dif_sw_0.VCP single_9b_cdac_1.cdac_sw_9b_0.S[1] sky130_fd_pr__cap_mim_m3_1 l=2 w=2
X4083 single_9b_cdac_0.cdac_sw_9b_0.cdac_sw_3_3.tg_sw_3_3.SWN single_9b_cdac_0.cdac_sw_9b_0.cdac_sw_3_3.nooverlap_clk_0.x10.A VDPWR VDPWR sky130_fd_pr__pfet_01v8 ad=0.168 pd=1.42 as=0.196 ps=1.47 w=1.12 l=0.15
X4084 sar9b_0.clknet_1_0__leaf_CLK a_6701_20506# VDPWR VDPWR sky130_fd_pr__pfet_01v8_hvt ad=0.14 pd=1.28 as=0.14 ps=1.28 w=1 l=0.15
X4085 a_11121_26516# a_10955_26516# VDPWR VDPWR sky130_fd_pr__pfet_01v8_hvt ad=0.1664 pd=1.8 as=0.0864 ps=0.91 w=0.64 l=0.15
X4086 single_9b_cdac_0.cdac_sw_9b_0.cdac_sw_3_8.nooverlap_clk_0.x10.A single_9b_cdac_0.cdac_sw_9b_0.cdac_sw_3_8.nooverlap_clk_0.x8.A VGND VGND sky130_fd_pr__nfet_01v8_lvt ad=0.1036 pd=1.02 as=0.2109 ps=2.05 w=0.74 l=0.15
X4087 sar9b_0.clk_div_0.COUNT\[0\] a_6651_23520# VGND VGND sky130_fd_pr__nfet_01v8 ad=0.169 pd=1.82 as=0.08775 ps=0.92 w=0.65 l=0.15
X4088 th_dif_sw_0.VCP single_9b_cdac_1.cdac_sw_9b_0.S[0] sky130_fd_pr__cap_mim_m3_1 l=2 w=2
X4089 VDPWR single_9b_cdac_0.cdac_sw_9b_0.cdac_sw_3_5.nooverlap_clk_0.sky130_fd_sc_hs__inv_8_0.A single_9b_cdac_0.cdac_sw_9b_0.cdac_sw_3_5.nooverlap_clk_0.CLKB0 VDPWR sky130_fd_pr__pfet_01v8 ad=0.196 pd=1.47 as=0.168 ps=1.42 w=1.12 l=0.15
X4090 a_9536_21076# sar9b_0.net8 VGND VGND sky130_fd_pr__nfet_01v8 ad=0.066 pd=0.745 as=0.2205 ps=1.89 w=0.42 l=0.15
X4091 a_6701_20506# sar9b_0.clknet_0_CLK VDPWR VDPWR sky130_fd_pr__pfet_01v8_hvt ad=0.14 pd=1.28 as=0.14 ps=1.28 w=1 l=0.15
X4092 VGND VDPWR VGND VGND sky130_fd_pr__nfet_01v8 ad=0.143 pd=1.62 as=0 ps=0 w=0.55 l=0.59
X4093 single_9b_cdac_1.cdac_sw_9b_0.cdac_sw_3_5.tg_sw_3_3.SWP single_9b_cdac_1.cdac_sw_9b_0.cdac_sw_3_5.tg_sw_3_3.SWN VGND VGND sky130_fd_pr__nfet_01v8_lvt ad=0.1036 pd=1.02 as=0.2109 ps=2.05 w=0.74 l=0.15
X4094 th_dif_sw_0.VCN single_9b_cdac_0.cdac_sw_9b_0.S[0] sky130_fd_pr__cap_mim_m3_1 l=2 w=2
X4095 VDPWR a_12027_22138# a_12014_22530# VDPWR sky130_fd_pr__pfet_01v8_hvt ad=0.0819 pd=0.81 as=0.0567 ps=0.69 w=0.42 l=0.15
X4096 th_dif_sw_0.VCP single_9b_cdac_1.cdac_sw_9b_0.S[2] sky130_fd_pr__cap_mim_m3_1 l=2 w=2
X4097 ua[0] single_9b_cdac_1.cdac_sw_9b_0.cdac_sw_3_2.tg_sw_3_3.SWN ua[0] VGND sky130_fd_pr__nfet_01v8 ad=0.145 pd=1.58 as=0 ps=0 w=0.5 l=0.5
X4098 th_dif_sw_0.VCN single_9b_cdac_0.cdac_sw_9b_0.S[1] sky130_fd_pr__cap_mim_m3_1 l=2 w=2
X4099 single_9b_cdac_0.cdac_sw_9b_0.cdac_sw_3_4.tg_sw_3_3.SWP single_9b_cdac_0.cdac_sw_9b_0.cdac_sw_3_4.tg_sw_3_3.SWN VDPWR VDPWR sky130_fd_pr__pfet_01v8 ad=0.168 pd=1.42 as=0.196 ps=1.47 w=1.12 l=0.15
X4100 VGND sar9b_0.net11 a_8471_23252# VGND sky130_fd_pr__nfet_01v8 ad=0.0567 pd=0.69 as=0.1092 ps=1.36 w=0.42 l=0.15
X4101 VGND sar9b_0.clknet_1_1__leaf_CLK a_6171_22714# VGND sky130_fd_pr__nfet_01v8 ad=0.0567 pd=0.69 as=0.1092 ps=1.36 w=0.42 l=0.15
X4102 a_13499_19988# a_13053_19988# a_13403_19988# VGND sky130_fd_pr__special_nfet_01v8 ad=0.1401 pd=1.1 as=0.0594 ps=0.69 w=0.36 l=0.15
X4103 VDPWR single_9b_cdac_1.cdac_sw_9b_0.cdac_sw_3_7.nooverlap_clk_0.CLKB0 single_9b_cdac_1.cdac_sw_9b_0.cdac_sw_3_7.nooverlap_clk_0.CLK0 VDPWR sky130_fd_pr__pfet_01v8 ad=0.196 pd=1.47 as=0.168 ps=1.42 w=1.12 l=0.15
X4104 VGND single_9b_cdac_0.cdac_sw_9b_0.cdac_sw_3_8.nooverlap_clk_0.sky130_fd_sc_hs__inv_1_1.A single_9b_cdac_0.cdac_sw_9b_0.cdac_sw_3_8.nooverlap_clk_0.x1.A VGND sky130_fd_pr__nfet_01v8_lvt ad=0.2627 pd=2.19 as=0.2109 ps=2.05 w=0.74 l=0.15
X4105 VGND single_9b_cdac_0.cdac_sw_9b_0.cdac_sw_3_7.tg_sw_3_3.SWN single_9b_cdac_0.cdac_sw_9b_0.cdac_sw_3_7.tg_sw_3_3.SWP VGND sky130_fd_pr__nfet_01v8_lvt ad=0.1036 pd=1.02 as=0.1036 ps=1.02 w=0.74 l=0.15
X4106 single_9b_cdac_0.cdac_sw_9b_0.cdac_sw_3_5.nooverlap_clk_0.CLKB0 single_9b_cdac_0.cdac_sw_9b_0.cdac_sw_3_5.nooverlap_clk_0.sky130_fd_sc_hs__inv_8_0.A VDPWR VDPWR sky130_fd_pr__pfet_01v8 ad=0.168 pd=1.42 as=0.168 ps=1.42 w=1.12 l=0.15
X4107 VGND single_9b_cdac_0.cdac_sw_9b_0.cdac_sw_3_1.nooverlap_clk_0.sky130_fd_sc_hs__inv_8_0.A single_9b_cdac_0.cdac_sw_9b_0.cdac_sw_3_1.nooverlap_clk_0.CLKB0 VGND sky130_fd_pr__nfet_01v8_lvt ad=0.1295 pd=1.09 as=0.1036 ps=1.02 w=0.74 l=0.15
X4108 VGND a_6149_23770# sar9b_0.clknet_1_1__leaf_CLK VGND sky130_fd_pr__nfet_01v8 ad=0.0588 pd=0.7 as=0.0588 ps=0.7 w=0.42 l=0.15
X4109 VGND VDPWR VGND VGND sky130_fd_pr__nfet_01v8 ad=0.143 pd=1.62 as=0 ps=0 w=0.55 l=0.59
X4110 VDPWR VGND VDPWR VDPWR sky130_fd_pr__pfet_01v8_hvt ad=0.2262 pd=2.26 as=0 ps=0 w=0.87 l=0.59
X4111 VGND single_9b_cdac_0.cdac_sw_9b_0.cdac_sw_3_5.nooverlap_clk_0.CLKB0 single_9b_cdac_0.cdac_sw_9b_0.cdac_sw_3_5.nooverlap_clk_0.CLK0 VGND sky130_fd_pr__nfet_01v8_lvt ad=0.1295 pd=1.09 as=0.1036 ps=1.02 w=0.74 l=0.15
X4112 VGND VDPWR VGND VGND sky130_fd_pr__nfet_01v8 ad=0.143 pd=1.62 as=0 ps=0 w=0.55 l=0.59
X4113 VGND VDPWR VGND VGND sky130_fd_pr__nfet_01v8 ad=0.143 pd=1.62 as=0 ps=0 w=0.55 l=0.59
X4114 th_dif_sw_0.VCN single_9b_cdac_0.cdac_sw_9b_0.S[2] sky130_fd_pr__cap_mim_m3_1 l=2 w=2
X4115 VDPWR single_9b_cdac_0.cdac_sw_9b_0.cdac_sw_3_5.nooverlap_clk_0.sky130_fd_sc_hs__inv_8_0.A single_9b_cdac_0.cdac_sw_9b_0.cdac_sw_3_5.nooverlap_clk_0.CLKB0 VDPWR sky130_fd_pr__pfet_01v8 ad=0.168 pd=1.42 as=0.168 ps=1.42 w=1.12 l=0.15
X4116 single_9b_cdac_1.cdac_sw_9b_0.cdac_sw_3_7.nooverlap_clk_0.CLK0 single_9b_cdac_1.cdac_sw_9b_0.cdac_sw_3_7.nooverlap_clk_0.CLKB0 VDPWR VDPWR sky130_fd_pr__pfet_01v8 ad=0.168 pd=1.42 as=0.168 ps=1.42 w=1.12 l=0.15
X4117 VGND single_9b_cdac_1.cdac_sw_9b_0.cdac_sw_3_0.nooverlap_clk_0.CLKB0 single_9b_cdac_1.cdac_sw_9b_0.cdac_sw_3_0.nooverlap_clk_0.CLK0 VGND sky130_fd_pr__nfet_01v8_lvt ad=0.2146 pd=2.06 as=0.1036 ps=1.02 w=0.74 l=0.15
X4118 VDPWR single_9b_cdac_1.cdac_sw_9b_0.cdac_sw_3_0.nooverlap_clk_0.sky130_fd_sc_hs__inv_8_0.A single_9b_cdac_1.cdac_sw_9b_0.cdac_sw_3_0.nooverlap_clk_0.CLKB0 VDPWR sky130_fd_pr__pfet_01v8 ad=0.3864 pd=2.93 as=0.168 ps=1.42 w=1.12 l=0.15
X4119 th_dif_sw_0.VCN single_9b_cdac_0.cdac_sw_9b_0.S[0] sky130_fd_pr__cap_mim_m3_1 l=2 w=2
X4120 single_9b_cdac_1.cdac_sw_9b_0.S[7] single_9b_cdac_1.cdac_sw_9b_0.cdac_sw_3_7.tg_sw_3_3.SWP single_9b_cdac_1.cdac_sw_9b_0.S[7] VDPWR sky130_fd_pr__pfet_01v8 ad=0.435 pd=3.58 as=0 ps=0 w=1.5 l=0.5
X4121 single_9b_cdac_1.cdac_sw_9b_0.S[4] single_9b_cdac_1.cdac_sw_9b_0.cdac_sw_3_3.tg_sw_3_3.SWP single_9b_cdac_1.cdac_sw_9b_0.S[4] VDPWR sky130_fd_pr__pfet_01v8 ad=0.435 pd=3.58 as=0 ps=0 w=1.5 l=0.5
X4122 a_13311_24174# a_12961_23802# a_13216_24162# VDPWR sky130_fd_pr__pfet_01v8_hvt ad=0.07245 pd=0.765 as=0.0651 ps=0.73 w=0.42 l=0.15
X4123 VGND VDPWR VGND VGND sky130_fd_pr__nfet_01v8 ad=0.143 pd=1.62 as=0 ps=0 w=0.55 l=0.59
X4124 a_8531_27438# a_8085_27066# a_8435_27438# VGND sky130_fd_pr__special_nfet_01v8 ad=0.1401 pd=1.1 as=0.0594 ps=0.69 w=0.36 l=0.15
X4125 VDPWR single_9b_cdac_0.cdac_sw_9b_0.cdac_sw_3_3.nooverlap_clk_0.CLKB0 single_9b_cdac_0.cdac_sw_9b_0.cdac_sw_3_3.nooverlap_clk_0.CLK0 VDPWR sky130_fd_pr__pfet_01v8 ad=0.3304 pd=2.83 as=0.168 ps=1.42 w=1.12 l=0.15
X4126 a_9370_19152# a_9687_19042# a_9645_18900# VGND sky130_fd_pr__special_nfet_01v8 ad=0.0711 pd=0.755 as=0.0669 ps=0.75 w=0.36 l=0.15
X4127 VDPWR single_9b_cdac_1.cdac_sw_9b_0.cdac_sw_3_7.nooverlap_clk_0.CLKB0 single_9b_cdac_1.cdac_sw_9b_0.cdac_sw_3_7.nooverlap_clk_0.CLK0 VDPWR sky130_fd_pr__pfet_01v8 ad=0.168 pd=1.42 as=0.168 ps=1.42 w=1.12 l=0.15
X4128 single_9b_cdac_1.cdac_sw_9b_0.cdac_sw_3_0.nooverlap_clk_0.CLKB0 single_9b_cdac_1.cdac_sw_9b_0.cdac_sw_3_0.nooverlap_clk_0.sky130_fd_sc_hs__inv_8_0.A VDPWR VDPWR sky130_fd_pr__pfet_01v8 ad=0.168 pd=1.42 as=0.196 ps=1.47 w=1.12 l=0.15
X4129 a_5601_26516# a_5435_26516# VGND VGND sky130_fd_pr__nfet_01v8 ad=0.1092 pd=1.36 as=0.0567 ps=0.69 w=0.42 l=0.15
X4130 a_10732_25250# sar9b_0.net12 VGND VGND sky130_fd_pr__nfet_01v8 ad=0.066 pd=0.745 as=0.2205 ps=1.89 w=0.42 l=0.15
X4131 VGND single_9b_cdac_1.cdac_sw_9b_0.cdac_sw_3_3.nooverlap_clk_0.x10.A single_9b_cdac_1.cdac_sw_9b_0.cdac_sw_3_3.tg_sw_3_3.SWN VGND sky130_fd_pr__nfet_01v8_lvt ad=0.1036 pd=1.02 as=0.1036 ps=1.02 w=0.74 l=0.15
X4132 th_dif_sw_0.VCN single_9b_cdac_0.cdac_sw_9b_0.S[0] sky130_fd_pr__cap_mim_m3_1 l=2 w=2
X4133 VDPWR single_9b_cdac_1.cdac_sw_9b_0.cdac_sw_3_7.nooverlap_clk_0.x8.A single_9b_cdac_1.cdac_sw_9b_0.cdac_sw_3_7.nooverlap_clk_0.x10.A VDPWR sky130_fd_pr__pfet_01v8 ad=0.3304 pd=2.83 as=0.168 ps=1.42 w=1.12 l=0.15
X4134 single_9b_cdac_1.cdac_sw_9b_0.S[1] single_9b_cdac_1.cdac_sw_9b_0.cdac_sw_3_1.tg_sw_3_3.SWN single_9b_cdac_1.cdac_sw_9b_0.S[1] VGND sky130_fd_pr__nfet_01v8 ad=0.145 pd=1.58 as=0 ps=0 w=0.5 l=0.5
X4135 th_dif_sw_0.VCP single_9b_cdac_1.cdac_sw_9b_0.S[0] sky130_fd_pr__cap_mim_m3_1 l=2 w=2
X4136 single_9b_cdac_1.cdac_sw_9b_0.cdac_sw_3_2.nooverlap_clk_0.x4.A single_9b_cdac_1.cdac_sw_9b_0.cdac_sw_3_2.nooverlap_clk_0.x1.A a_64331_15495# VGND sky130_fd_pr__nfet_01v8_lvt ad=0.2109 pd=2.05 as=0.0888 ps=0.98 w=0.74 l=0.15
X4137 VDPWR single_9b_cdac_0.cdac_sw_9b_0.cdac_sw_3_7.tg_sw_3_3.SWN single_9b_cdac_0.cdac_sw_9b_0.cdac_sw_3_7.tg_sw_3_3.SWP VDPWR sky130_fd_pr__pfet_01v8 ad=0.196 pd=1.47 as=0.168 ps=1.42 w=1.12 l=0.15
X4138 single_9b_cdac_0.cdac_sw_9b_0.S[3] single_9b_cdac_0.cdac_sw_9b_0.cdac_sw_3_4.tg_sw_3_3.SWN single_9b_cdac_0.cdac_sw_9b_0.S[3] VGND sky130_fd_pr__nfet_01v8 ad=0.145 pd=1.58 as=2.32 ps=25.28 w=0.5 l=0.5
X4139 VGND VDPWR VGND VGND sky130_fd_pr__nfet_01v8 ad=0.143 pd=1.62 as=0 ps=0 w=0.55 l=0.59
X4140 VGND a_5393_17977# th_dif_sw_0.CKB VGND sky130_fd_pr__nfet_01v8 ad=0.0754 pd=0.81 as=0.1352 ps=1.56 w=0.52 l=0.15
X4141 th_dif_sw_0.VCP single_9b_cdac_1.cdac_sw_9b_0.S[1] sky130_fd_pr__cap_mim_m3_1 l=2 w=2
X4142 th_dif_sw_0.VCP single_9b_cdac_1.cdac_sw_9b_0.S[0] sky130_fd_pr__cap_mim_m3_1 l=2 w=2
X4143 single_9b_cdac_0.cdac_sw_9b_0.cdac_sw_3_3.nooverlap_clk_0.CLK0 single_9b_cdac_0.cdac_sw_9b_0.cdac_sw_3_3.nooverlap_clk_0.CLKB0 VDPWR VDPWR sky130_fd_pr__pfet_01v8 ad=0.168 pd=1.42 as=0.196 ps=1.47 w=1.12 l=0.15
X4144 single_9b_cdac_0.cdac_sw_9b_0.cdac_sw_3_4.nooverlap_clk_0.CLKB0 single_9b_cdac_0.cdac_sw_9b_0.cdac_sw_3_4.nooverlap_clk_0.sky130_fd_sc_hs__inv_8_0.A VGND VGND sky130_fd_pr__nfet_01v8_lvt ad=0.1036 pd=1.02 as=0.1036 ps=1.02 w=0.74 l=0.15
X4145 a_11045_24858# a_10827_25262# VDPWR VDPWR sky130_fd_pr__pfet_01v8_hvt ad=0.12915 pd=1.185 as=0.2184 ps=2.2 w=0.84 l=0.15
X4146 VDPWR VGND VDPWR VDPWR sky130_fd_pr__pfet_01v8_hvt ad=0.2262 pd=2.26 as=0 ps=0 w=0.87 l=0.59
X4147 VDPWR VGND VDPWR VDPWR sky130_fd_pr__pfet_01v8_hvt ad=0.2262 pd=2.26 as=0 ps=0 w=0.87 l=0.59
X4148 single_9b_cdac_1.cdac_sw_9b_0.cdac_sw_3_7.nooverlap_clk_0.CLK0 single_9b_cdac_1.cdac_sw_9b_0.cdac_sw_3_7.nooverlap_clk_0.CLKB0 VDPWR VDPWR sky130_fd_pr__pfet_01v8 ad=0.168 pd=1.42 as=0.196 ps=1.47 w=1.12 l=0.15
X4149 th_dif_sw_0.VCN single_9b_cdac_0.cdac_sw_9b_0.S[2] sky130_fd_pr__cap_mim_m3_1 l=2 w=2
X4150 th_dif_sw_0.VCN single_9b_cdac_0.cdac_sw_9b_0.S[0] sky130_fd_pr__cap_mim_m3_1 l=2 w=2
X4151 single_9b_cdac_1.cdac_sw_9b_0.cdac_sw_3_1.nooverlap_clk_0.CLKB0 single_9b_cdac_1.cdac_sw_9b_0.cdac_sw_3_1.nooverlap_clk_0.sky130_fd_sc_hs__inv_8_0.A VGND VGND sky130_fd_pr__nfet_01v8_lvt ad=0.1036 pd=1.02 as=0.2109 ps=2.05 w=0.74 l=0.15
X4152 VGND single_9b_cdac_0.cdac_sw_9b_0.cdac_sw_3_0.nooverlap_clk_0.sky130_fd_sc_hs__nand2_1_0.Y single_9b_cdac_0.cdac_sw_9b_0.cdac_sw_3_0.nooverlap_clk_0.sky130_fd_sc_hs__inv_1_1.A VGND sky130_fd_pr__nfet_01v8_lvt ad=0.2627 pd=2.19 as=0.2109 ps=2.05 w=0.74 l=0.15
X4153 a_6993_25428# a_5803_25428# a_6884_25428# VGND sky130_fd_pr__special_nfet_01v8 ad=0.0669 pd=0.75 as=0.0711 ps=0.755 w=0.36 l=0.15
X4154 single_9b_cdac_1.cdac_sw_9b_0.cdac_sw_3_7.nooverlap_clk_0.x10.A single_9b_cdac_1.cdac_sw_9b_0.cdac_sw_3_7.nooverlap_clk_0.x8.A VDPWR VDPWR sky130_fd_pr__pfet_01v8 ad=0.168 pd=1.42 as=0.168 ps=1.42 w=1.12 l=0.15
X4155 VDPWR single_9b_cdac_0.cdac_sw_9b_0.cdac_sw_3_2.nooverlap_clk_0.x8.A single_9b_cdac_0.cdac_sw_9b_0.cdac_sw_3_2.nooverlap_clk_0.x10.A VDPWR sky130_fd_pr__pfet_01v8 ad=0.3304 pd=2.83 as=0.168 ps=1.42 w=1.12 l=0.15
X4156 VDPWR a_14143_19962# a_14130_20354# VDPWR sky130_fd_pr__pfet_01v8_hvt ad=0.0819 pd=0.81 as=0.0567 ps=0.69 w=0.42 l=0.15
X4157 th_dif_sw_0.VCP single_9b_cdac_1.cdac_sw_9b_0.S[0] sky130_fd_pr__cap_mim_m3_1 l=2 w=2
X4158 single_9b_cdac_0.cdac_sw_9b_0.S[1] single_9b_cdac_0.cdac_sw_9b_0.cdac_sw_3_1.tg_sw_3_3.SWP ua[0] VGND sky130_fd_pr__nfet_01v8 ad=0.145 pd=1.58 as=0.145 ps=1.58 w=0.5 l=0.5
X4159 single_9b_cdac_1.cdac_sw_9b_0.S[7] single_9b_cdac_1.cdac_sw_9b_0.cdac_sw_3_7.tg_sw_3_3.SWP ua[0] VGND sky130_fd_pr__nfet_01v8 ad=0.145 pd=1.58 as=0.145 ps=1.58 w=0.5 l=0.5
X4160 VDPWR a_11935_25402# sar9b_0.FINAL VDPWR sky130_fd_pr__pfet_01v8_hvt ad=0.26 pd=2.52 as=0.135 ps=1.27 w=1 l=0.15
X4161 VDPWR single_9b_cdac_1.cdac_sw_9b_0.cdac_sw_3_7.nooverlap_clk_0.x8.A single_9b_cdac_1.cdac_sw_9b_0.cdac_sw_3_7.nooverlap_clk_0.x10.A VDPWR sky130_fd_pr__pfet_01v8 ad=0.168 pd=1.42 as=0.168 ps=1.42 w=1.12 l=0.15
X4162 VGND th_dif_sw_0.CK a_9132_7271# VGND sky130_fd_pr__nfet_01v8_lvt ad=0.11655 pd=1.055 as=0.1295 ps=1.09 w=0.74 l=0.15
X4163 a_16881_10256# tdc_0.delay_gate_ori_1.sky130_fd_sc_hs__and2_1_0.A a_16527_10454# VGND sky130_fd_pr__nfet_01v8_lvt ad=0.1376 pd=1.14 as=0.1824 ps=1.85 w=0.64 l=0.15
X4164 VGND sar9b_0.clknet_1_1__leaf_CLK a_7919_23802# VGND sky130_fd_pr__nfet_01v8 ad=0.0567 pd=0.69 as=0.1092 ps=1.36 w=0.42 l=0.15
X4165 sar9b_0.clknet_0_CLK a_7345_21594# VDPWR VDPWR sky130_fd_pr__pfet_01v8_hvt ad=0.14 pd=1.28 as=0.14 ps=1.28 w=1 l=0.15
X4166 single_9b_cdac_1.cdac_sw_9b_0.cdac_sw_3_0.nooverlap_clk_0.x1.A single_9b_cdac_1.cdac_sw_9b_0.cdac_sw_3_0.nooverlap_clk_0.sky130_fd_sc_hs__inv_1_1.A VGND VGND sky130_fd_pr__nfet_01v8_lvt ad=0.2109 pd=2.05 as=0.2627 ps=2.19 w=0.74 l=0.15
X4167 VGND single_9b_cdac_0.cdac_sw_9b_0.cdac_sw_3_6.nooverlap_clk_0.x8.A single_9b_cdac_0.cdac_sw_9b_0.cdac_sw_3_6.nooverlap_clk_0.x10.A VGND sky130_fd_pr__nfet_01v8_lvt ad=0.1221 pd=1.07 as=0.1036 ps=1.02 w=0.74 l=0.15
X4168 VGND sar9b_0.net4 a_11231_20538# VGND sky130_fd_pr__nfet_01v8 ad=0.0567 pd=0.69 as=0.1092 ps=1.36 w=0.42 l=0.15
X4169 single_9b_cdac_1.cdac_sw_9b_0.cdac_sw_3_5.nooverlap_clk_0.x6.A single_9b_cdac_1.cdac_sw_9b_0.cdac_sw_3_5.nooverlap_clk_0.x4.A VGND VGND sky130_fd_pr__nfet_01v8_lvt ad=0.2109 pd=2.05 as=0.2627 ps=2.19 w=0.74 l=0.15
X4170 a_21684_3438# th_dif_sw_0.th_sw_1.CK VGND VGND sky130_fd_pr__nfet_01v8 ad=2.175 pd=15.58 as=2.175 ps=15.58 w=7.5 l=0.15
X4171 single_9b_cdac_0.cdac_sw_9b_0.S[6] single_9b_cdac_0.cdac_sw_9b_0.cdac_sw_3_6.tg_sw_3_3.SWP ua[0] VGND sky130_fd_pr__nfet_01v8 ad=0.145 pd=1.58 as=0.145 ps=1.58 w=0.5 l=0.5
X4172 sar9b_0.clknet_0_CLK a_7345_21594# VDPWR VDPWR sky130_fd_pr__pfet_01v8_hvt ad=0.14 pd=1.28 as=0.14 ps=1.28 w=1 l=0.15
X4173 VGND sar9b_0.net5 a_12887_19450# VGND sky130_fd_pr__nfet_01v8 ad=0.0567 pd=0.69 as=0.1092 ps=1.36 w=0.42 l=0.15
X4174 th_dif_sw_0.VCP single_9b_cdac_1.cdac_sw_9b_0.S[0] sky130_fd_pr__cap_mim_m3_1 l=2 w=2
X4175 th_dif_sw_0.VCP single_9b_cdac_1.cdac_sw_9b_0.S[2] sky130_fd_pr__cap_mim_m3_1 l=2 w=2
X4176 a_9631_26516# a_9281_26516# a_9536_26516# VDPWR sky130_fd_pr__pfet_01v8_hvt ad=0.07245 pd=0.765 as=0.0651 ps=0.73 w=0.42 l=0.15
X4177 single_9b_cdac_0.cdac_sw_9b_0.S[2] single_9b_cdac_0.cdac_sw_9b_0.cdac_sw_3_0.tg_sw_3_3.SWP single_9b_cdac_0.cdac_sw_9b_0.S[2] VDPWR sky130_fd_pr__pfet_01v8 ad=0.435 pd=3.58 as=0 ps=0 w=1.5 l=0.5
X4178 VDPWR single_9b_cdac_0.cdac_sw_9b_0.cdac_sw_3_1.nooverlap_clk_0.x10.A single_9b_cdac_0.cdac_sw_9b_0.cdac_sw_3_1.tg_sw_3_3.SWN VDPWR sky130_fd_pr__pfet_01v8 ad=0.196 pd=1.47 as=0.168 ps=1.42 w=1.12 l=0.15
X4179 VGND VDPWR VGND VGND sky130_fd_pr__nfet_01v8 ad=0.143 pd=1.62 as=0 ps=0 w=0.55 l=0.59
X4180 a_13140_18734# a_12225_18362# a_12793_18330# VGND sky130_fd_pr__special_nfet_01v8 ad=0.0711 pd=0.755 as=0.0999 ps=0.985 w=0.36 l=0.15
X4181 ua[0] single_9b_cdac_1.cdac_sw_9b_0.cdac_sw_3_8.tg_sw_3_3.SWP ua[0] VDPWR sky130_fd_pr__pfet_01v8 ad=0.435 pd=3.58 as=0 ps=0 w=1.5 l=0.5
X4182 single_9b_cdac_1.cdac_sw_9b_0.cdac_sw_3_7.nooverlap_clk_0.x10.A single_9b_cdac_1.cdac_sw_9b_0.cdac_sw_3_7.nooverlap_clk_0.x8.A VDPWR VDPWR sky130_fd_pr__pfet_01v8 ad=0.168 pd=1.42 as=0.3304 ps=2.83 w=1.12 l=0.15
X4183 th_dif_sw_0.VCN single_9b_cdac_0.cdac_sw_9b_0.S[1] sky130_fd_pr__cap_mim_m3_1 l=2 w=2
X4184 single_9b_cdac_1.cdac_sw_9b_0.S[1] single_9b_cdac_1.cdac_sw_9b_0.cdac_sw_3_1.nooverlap_clk_0.CLKB0 a_57946_16877# VDPWR sky130_fd_pr__pfet_01v8 ad=0.435 pd=3.58 as=0.435 ps=3.58 w=1.5 l=0.5
X4185 VGND clk a_16881_10256# VGND sky130_fd_pr__nfet_01v8_lvt ad=0.15535 pd=1.17 as=0.1376 ps=1.14 w=0.64 l=0.15
X4186 a_11471_21076# a_11121_21076# a_11376_21076# VDPWR sky130_fd_pr__pfet_01v8_hvt ad=0.07245 pd=0.765 as=0.0651 ps=0.73 w=0.42 l=0.15
X4187 VGND VDPWR VGND VGND sky130_fd_pr__nfet_01v8 ad=0.143 pd=1.62 as=0 ps=0 w=0.55 l=0.59
X4188 single_9b_cdac_0.cdac_sw_9b_0.cdac_sw_3_4.tg_sw_3_3.SWN single_9b_cdac_0.cdac_sw_9b_0.cdac_sw_3_4.nooverlap_clk_0.x10.A VGND VGND sky130_fd_pr__nfet_01v8_lvt ad=0.1036 pd=1.02 as=0.1554 ps=1.16 w=0.74 l=0.15
X4189 single_9b_cdac_0.cdac_sw_9b_0.cdac_sw_3_1.tg_sw_3_3.SWN single_9b_cdac_0.cdac_sw_9b_0.cdac_sw_3_1.nooverlap_clk_0.x10.A VDPWR VDPWR sky130_fd_pr__pfet_01v8 ad=0.168 pd=1.42 as=0.3864 ps=2.93 w=1.12 l=0.15
X4190 single_9b_cdac_1.cdac_sw_9b_0.S[2] single_9b_cdac_1.cdac_sw_9b_0.cdac_sw_3_0.tg_sw_3_3.SWN single_9b_cdac_1.cdac_sw_9b_0.S[2] VGND sky130_fd_pr__nfet_01v8 ad=0.145 pd=1.58 as=2.32 ps=25.28 w=0.5 l=0.5
X4191 VGND VDPWR VGND VGND sky130_fd_pr__nfet_01v8 ad=0.143 pd=1.62 as=0 ps=0 w=0.55 l=0.59
X4192 single_9b_cdac_1.cdac_sw_9b_0.cdac_sw_3_8.tg_sw_3_3.SWP single_9b_cdac_1.cdac_sw_9b_0.cdac_sw_3_8.tg_sw_3_3.SWN VGND VGND sky130_fd_pr__nfet_01v8_lvt ad=0.1036 pd=1.02 as=0.1036 ps=1.02 w=0.74 l=0.15
X4193 a_13403_22164# a_13053_22164# a_13308_22164# VDPWR sky130_fd_pr__pfet_01v8_hvt ad=0.07245 pd=0.765 as=0.0651 ps=0.73 w=0.42 l=0.15
X4194 sar9b_0.clknet_1_0__leaf_CLK a_6701_20506# VGND VGND sky130_fd_pr__nfet_01v8 ad=0.0588 pd=0.7 as=0.1113 ps=1.37 w=0.42 l=0.15
X4195 VGND single_9b_cdac_1.cdac_sw_9b_0.cdac_sw_3_3.nooverlap_clk_0.CLKB0 single_9b_cdac_1.cdac_sw_9b_0.cdac_sw_3_3.nooverlap_clk_0.CLK0 VGND sky130_fd_pr__nfet_01v8_lvt ad=0.2146 pd=2.06 as=0.1036 ps=1.02 w=0.74 l=0.15
X4196 a_53154_26999# single_9b_cdac_0.SW[2] VDPWR VDPWR sky130_fd_pr__pfet_01v8 ad=0.435 pd=3.58 as=0.435 ps=3.58 w=1.5 l=0.5
X4197 sar9b_0.clknet_1_0__leaf_CLK a_6701_20506# VGND VGND sky130_fd_pr__nfet_01v8 ad=0.0588 pd=0.7 as=0.0588 ps=0.7 w=0.42 l=0.15
X4198 VDPWR single_9b_cdac_1.cdac_sw_9b_0.cdac_sw_3_2.nooverlap_clk_0.sky130_fd_sc_hs__inv_8_0.A single_9b_cdac_1.cdac_sw_9b_0.cdac_sw_3_2.nooverlap_clk_0.CLKB0 VDPWR sky130_fd_pr__pfet_01v8 ad=0.196 pd=1.47 as=0.168 ps=1.42 w=1.12 l=0.15
X4199 VDPWR VGND VDPWR VDPWR sky130_fd_pr__pfet_01v8_hvt ad=0.2262 pd=2.26 as=0 ps=0 w=0.87 l=0.59
X4200 a_13511_25794# a_12887_25428# a_13403_25428# VDPWR sky130_fd_pr__pfet_01v8_hvt ad=0.1155 pd=0.97 as=0.07245 ps=0.765 w=0.42 l=0.15
X4201 th_dif_sw_0.CK a_14451_17812# VGND VGND sky130_fd_pr__nfet_01v8 ad=0.1352 pd=1.56 as=0.0754 ps=0.81 w=0.52 l=0.15
X4202 th_dif_sw_0.VCN single_9b_cdac_0.cdac_sw_9b_0.S[0] sky130_fd_pr__cap_mim_m3_1 l=2 w=2
X4203 th_dif_sw_0.VCP single_9b_cdac_1.cdac_sw_9b_0.S[0] sky130_fd_pr__cap_mim_m3_1 l=2 w=2
X4204 VDPWR VGND VDPWR VDPWR sky130_fd_pr__pfet_01v8_hvt ad=0.2262 pd=2.26 as=0 ps=0 w=0.87 l=0.59
X4205 th_dif_sw_0.VCP single_9b_cdac_1.cdac_sw_9b_0.S[1] sky130_fd_pr__cap_mim_m3_1 l=2 w=2
X4206 single_9b_cdac_1.cdac_sw_9b_0.cdac_sw_3_1.tg_sw_3_3.SWN single_9b_cdac_1.cdac_sw_9b_0.cdac_sw_3_1.nooverlap_clk_0.x10.A VGND VGND sky130_fd_pr__nfet_01v8_lvt ad=0.1036 pd=1.02 as=0.1554 ps=1.16 w=0.74 l=0.15
X4207 a_9107_22682# a_8951_22950# a_9252_22708# VDPWR sky130_fd_pr__pfet_01v8_hvt ad=0.07245 pd=0.765 as=0.1155 ps=0.97 w=0.42 l=0.15
X4208 a_54737_15495# single_9b_cdac_1.cdac_sw_9b_0.cdac_sw_3_0.nooverlap_clk_0.x3.Y VGND VGND sky130_fd_pr__nfet_01v8_lvt ad=0.0888 pd=0.98 as=0.2109 ps=2.05 w=0.74 l=0.15
X4209 VDPWR VGND VDPWR VDPWR sky130_fd_pr__pfet_01v8_hvt ad=0.2262 pd=2.26 as=0 ps=0 w=0.87 l=0.59
X4210 th_dif_sw_0.VCN single_9b_cdac_0.cdac_sw_9b_0.S[2] sky130_fd_pr__cap_mim_m3_1 l=2 w=2
X4211 single_9b_cdac_0.cdac_sw_9b_0.cdac_sw_3_6.nooverlap_clk_0.sky130_fd_sc_hs__nand2_1_0.Y single_9b_cdac_1.CF[6] a_36555_29911# VGND sky130_fd_pr__nfet_01v8_lvt ad=0.2109 pd=2.05 as=0.0888 ps=0.98 w=0.74 l=0.15
X4212 single_9b_cdac_0.cdac_sw_9b_0.cdac_sw_3_6.nooverlap_clk_0.CLK0 single_9b_cdac_0.cdac_sw_9b_0.cdac_sw_3_6.nooverlap_clk_0.CLKB0 VGND VGND sky130_fd_pr__nfet_01v8_lvt ad=0.1036 pd=1.02 as=0.1036 ps=1.02 w=0.74 l=0.15
X4213 single_9b_cdac_0.cdac_sw_9b_0.cdac_sw_3_5.nooverlap_clk_0.x10.A single_9b_cdac_0.cdac_sw_9b_0.cdac_sw_3_5.nooverlap_clk_0.x8.A VGND VGND sky130_fd_pr__nfet_01v8_lvt ad=0.1036 pd=1.02 as=0.2109 ps=2.05 w=0.74 l=0.15
X4214 VGND single_9b_cdac_0.cdac_sw_9b_0.cdac_sw_3_0.nooverlap_clk_0.CLKB0 single_9b_cdac_0.cdac_sw_9b_0.cdac_sw_3_0.nooverlap_clk_0.CLK0 VGND sky130_fd_pr__nfet_01v8_lvt ad=0.2109 pd=2.05 as=0.1036 ps=1.02 w=0.74 l=0.15
X4215 VGND single_9b_cdac_0.cdac_sw_9b_0.cdac_sw_3_3.nooverlap_clk_0.sky130_fd_sc_hs__nand2_1_0.Y single_9b_cdac_0.cdac_sw_9b_0.cdac_sw_3_3.nooverlap_clk_0.sky130_fd_sc_hs__inv_1_1.A VGND sky130_fd_pr__nfet_01v8_lvt ad=0.2627 pd=2.19 as=0.2109 ps=2.05 w=0.74 l=0.15
X4216 VGND single_9b_cdac_0.cdac_sw_9b_0.cdac_sw_3_1.nooverlap_clk_0.sky130_fd_sc_hs__inv_8_0.A single_9b_cdac_0.cdac_sw_9b_0.cdac_sw_3_1.nooverlap_clk_0.CLKB0 VGND sky130_fd_pr__nfet_01v8_lvt ad=0.2109 pd=2.05 as=0.1036 ps=1.02 w=0.74 l=0.15
X4217 a_58824_26990# single_9b_cdac_0.cdac_sw_9b_0.cdac_sw_3_1.nooverlap_clk_0.CLK0 single_9b_cdac_0.cdac_sw_9b_0.S[1] VGND sky130_fd_pr__nfet_01v8 ad=0.145 pd=1.58 as=0.145 ps=1.58 w=0.5 l=0.5
X4218 VDPWR VGND VDPWR VDPWR sky130_fd_pr__pfet_01v8_hvt ad=0.2262 pd=2.26 as=0 ps=0 w=0.87 l=0.59
X4219 th_dif_sw_0.VCP single_9b_cdac_1.cdac_sw_9b_0.S[3] sky130_fd_pr__cap_mim_m3_1 l=2 w=2
X4220 VGND a_21177_7457# th_dif_sw_0.th_sw_1.CKB VGND sky130_fd_pr__nfet_01v8_lvt ad=0.1554 pd=1.16 as=0.1036 ps=1.02 w=0.74 l=0.15
X4221 VDPWR single_9b_cdac_1.cdac_sw_9b_0.cdac_sw_3_4.nooverlap_clk_0.x10.A single_9b_cdac_1.cdac_sw_9b_0.cdac_sw_3_4.tg_sw_3_3.SWN VDPWR sky130_fd_pr__pfet_01v8 ad=0.196 pd=1.47 as=0.168 ps=1.42 w=1.12 l=0.15
X4222 single_9b_cdac_1.cdac_sw_9b_0.S[1] single_9b_cdac_1.cdac_sw_9b_0.cdac_sw_3_1.tg_sw_3_3.SWP ua[0] VGND sky130_fd_pr__nfet_01v8 ad=0.145 pd=1.58 as=0.145 ps=1.58 w=0.5 l=0.5
X4223 th_dif_sw_0.VCP single_9b_cdac_1.cdac_sw_9b_0.S[0] sky130_fd_pr__cap_mim_m3_1 l=2 w=2
X4224 th_dif_sw_0.VCN single_9b_cdac_0.cdac_sw_9b_0.S[0] sky130_fd_pr__cap_mim_m3_1 l=2 w=2
X4225 a_34814_26990# single_9b_cdac_0.cdac_sw_9b_0.cdac_sw_3_6.nooverlap_clk_0.CLK0 single_9b_cdac_0.cdac_sw_9b_0.S[6] VGND sky130_fd_pr__nfet_01v8 ad=0.145 pd=1.58 as=0.145 ps=1.58 w=0.5 l=0.5
X4226 VGND single_9b_cdac_0.cdac_sw_9b_0.cdac_sw_3_2.nooverlap_clk_0.x10.A single_9b_cdac_0.cdac_sw_9b_0.cdac_sw_3_2.tg_sw_3_3.SWN VGND sky130_fd_pr__nfet_01v8_lvt ad=0.1295 pd=1.09 as=0.1036 ps=1.02 w=0.74 l=0.15
X4227 single_9b_cdac_1.cdac_sw_9b_0.S[6] single_9b_cdac_1.cdac_sw_9b_0.cdac_sw_3_6.tg_sw_3_3.SWP ua[0] VGND sky130_fd_pr__nfet_01v8 ad=0.145 pd=1.58 as=0.145 ps=1.58 w=0.5 l=0.5
X4228 single_9b_cdac_1.cdac_sw_9b_0.cdac_sw_3_3.nooverlap_clk_0.x1.A single_9b_cdac_1.cdac_sw_9b_0.cdac_sw_3_3.nooverlap_clk_0.sky130_fd_sc_hs__inv_1_1.A VGND VGND sky130_fd_pr__nfet_01v8_lvt ad=0.2109 pd=2.05 as=0.2627 ps=2.19 w=0.74 l=0.15
X4229 VGND single_9b_cdac_0.cdac_sw_9b_0.cdac_sw_3_3.tg_sw_3_3.SWN single_9b_cdac_0.cdac_sw_9b_0.cdac_sw_3_3.tg_sw_3_3.SWP VGND sky130_fd_pr__nfet_01v8_lvt ad=0.1295 pd=1.09 as=0.1036 ps=1.02 w=0.74 l=0.15
X4230 VDPWR VGND VDPWR VDPWR sky130_fd_pr__pfet_01v8_hvt ad=0.2262 pd=2.26 as=0 ps=0 w=0.87 l=0.59
X4231 single_9b_cdac_1.cdac_sw_9b_0.cdac_sw_3_4.tg_sw_3_3.SWN single_9b_cdac_1.cdac_sw_9b_0.cdac_sw_3_4.nooverlap_clk_0.x10.A VDPWR VDPWR sky130_fd_pr__pfet_01v8 ad=0.168 pd=1.42 as=0.168 ps=1.42 w=1.12 l=0.15
X4232 th_dif_sw_0.VCP single_9b_cdac_1.cdac_sw_9b_0.S[0] sky130_fd_pr__cap_mim_m3_1 l=2 w=2
X4233 VGND single_9b_cdac_0.SW[6] a_34814_26990# VGND sky130_fd_pr__nfet_01v8 ad=0.145 pd=1.58 as=0.145 ps=1.58 w=0.5 l=0.5
X4234 VDPWR single_9b_cdac_1.cdac_sw_9b_0.cdac_sw_3_2.nooverlap_clk_0.x1.A single_9b_cdac_1.cdac_sw_9b_0.cdac_sw_3_2.nooverlap_clk_0.x4.A VDPWR sky130_fd_pr__pfet_01v8 ad=0.3192 pd=2.81 as=0.168 ps=1.42 w=1.12 l=0.15
X4235 uo_out[0] a_14175_27060# VGND VGND sky130_fd_pr__nfet_01v8 ad=0.1352 pd=1.56 as=0.0754 ps=0.81 w=0.52 l=0.15
X4236 VDPWR sar9b_0.FINAL a_5435_26516# VDPWR sky130_fd_pr__pfet_01v8_hvt ad=0.0864 pd=0.91 as=0.1664 ps=1.8 w=0.64 l=0.15
X4237 single_9b_cdac_0.cdac_sw_9b_0.S[1] single_9b_cdac_0.cdac_sw_9b_0.cdac_sw_3_1.tg_sw_3_3.SWN ua[0] VDPWR sky130_fd_pr__pfet_01v8 ad=0.435 pd=3.58 as=0.435 ps=3.58 w=1.5 l=0.5
X4238 VGND sar9b_0.clk_div_0.COUNT\[1\] a_6679_22316# VGND sky130_fd_pr__nfet_01v8 ad=0.0567 pd=0.69 as=0.0567 ps=0.69 w=0.42 l=0.15
X4239 VGND sar9b_0.net2 a_10406_19266# VGND sky130_fd_pr__nfet_01v8 ad=0.2205 pd=1.89 as=0.066 ps=0.745 w=0.42 l=0.15
X4240 th_dif_sw_0.VCN single_9b_cdac_0.cdac_sw_9b_0.S[2] sky130_fd_pr__cap_mim_m3_1 l=2 w=2
X4241 a_5487_27034# a_5690_27192# VDPWR VDPWR sky130_fd_pr__pfet_01v8_hvt ad=0.0567 pd=0.69 as=0.1134 ps=1.38 w=0.42 l=0.15
X4242 VDPWR single_9b_cdac_1.cdac_sw_9b_0.cdac_sw_3_4.nooverlap_clk_0.x10.A single_9b_cdac_1.cdac_sw_9b_0.cdac_sw_3_4.tg_sw_3_3.SWN VDPWR sky130_fd_pr__pfet_01v8 ad=0.168 pd=1.42 as=0.168 ps=1.42 w=1.12 l=0.15
X4243 a_9714_23618# a_8637_23252# a_9552_23252# VDPWR sky130_fd_pr__pfet_01v8_hvt ad=0.0567 pd=0.69 as=0.0588 ps=0.7 w=0.42 l=0.15
X4244 VGND a_8431_22682# sar9b_0.net11 VGND sky130_fd_pr__nfet_01v8 ad=0.2087 pd=2.02 as=0.169 ps=1.82 w=0.65 l=0.15
X4245 single_9b_cdac_1.cdac_sw_9b_0.cdac_sw_3_7.nooverlap_clk_0.x1.A single_9b_cdac_1.cdac_sw_9b_0.cdac_sw_3_7.nooverlap_clk_0.sky130_fd_sc_hs__inv_1_1.A VDPWR VDPWR sky130_fd_pr__pfet_01v8 ad=0.3304 pd=2.83 as=0.3864 ps=2.93 w=1.12 l=0.15
X4246 single_9b_cdac_1.cdac_sw_9b_0.cdac_sw_3_2.nooverlap_clk_0.x4.A single_9b_cdac_1.cdac_sw_9b_0.cdac_sw_3_2.nooverlap_clk_0.x3.Y VDPWR VDPWR sky130_fd_pr__pfet_01v8 ad=0.168 pd=1.42 as=0.3192 ps=2.81 w=1.12 l=0.15
X4247 single_9b_cdac_0.cdac_sw_9b_0.cdac_sw_3_4.nooverlap_clk_0.CLKB0 single_9b_cdac_0.cdac_sw_9b_0.cdac_sw_3_4.nooverlap_clk_0.sky130_fd_sc_hs__inv_8_0.A VGND VGND sky130_fd_pr__nfet_01v8_lvt ad=0.1036 pd=1.02 as=0.1295 ps=1.09 w=0.74 l=0.15
X4248 VDPWR single_9b_cdac_0.cdac_sw_9b_0.cdac_sw_3_1.nooverlap_clk_0.CLKB0 single_9b_cdac_0.cdac_sw_9b_0.cdac_sw_3_1.nooverlap_clk_0.CLK0 VDPWR sky130_fd_pr__pfet_01v8 ad=0.3304 pd=2.83 as=0.168 ps=1.42 w=1.12 l=0.15
X4249 VGND VDPWR VGND VGND sky130_fd_pr__nfet_01v8 ad=0.143 pd=1.62 as=0 ps=0 w=0.55 l=0.59
X4250 VGND single_9b_cdac_1.cdac_sw_9b_0.cdac_sw_3_6.tg_sw_3_3.SWN single_9b_cdac_1.cdac_sw_9b_0.cdac_sw_3_6.tg_sw_3_3.SWP VGND sky130_fd_pr__nfet_01v8_lvt ad=0.1295 pd=1.09 as=0.1036 ps=1.02 w=0.74 l=0.15
X4251 single_9b_cdac_1.cdac_sw_9b_0.cdac_sw_3_4.tg_sw_3_3.SWN single_9b_cdac_1.cdac_sw_9b_0.cdac_sw_3_4.nooverlap_clk_0.x10.A VDPWR VDPWR sky130_fd_pr__pfet_01v8 ad=0.168 pd=1.42 as=0.196 ps=1.47 w=1.12 l=0.15
X4252 th_dif_sw_0.VCN single_9b_cdac_0.cdac_sw_9b_0.S[1] sky130_fd_pr__cap_mim_m3_1 l=2 w=2
X4253 VGND single_9b_cdac_1.cdac_sw_9b_0.cdac_sw_3_1.nooverlap_clk_0.x8.A a_60565_15501# VGND sky130_fd_pr__nfet_01v8_lvt ad=0.2109 pd=2.05 as=0.0888 ps=0.98 w=0.74 l=0.15
X4254 single_9b_cdac_0.cdac_sw_9b_0.cdac_sw_3_1.nooverlap_clk_0.CLK0 single_9b_cdac_0.cdac_sw_9b_0.cdac_sw_3_1.nooverlap_clk_0.CLKB0 VDPWR VDPWR sky130_fd_pr__pfet_01v8 ad=0.168 pd=1.42 as=0.196 ps=1.47 w=1.12 l=0.15
X4255 VDPWR VGND VDPWR VDPWR sky130_fd_pr__pfet_01v8_hvt ad=0.2262 pd=2.26 as=0 ps=0 w=0.87 l=0.59
X4256 ua[0] single_9b_cdac_1.cdac_sw_9b_0.cdac_sw_3_1.tg_sw_3_3.SWN ua[0] VGND sky130_fd_pr__nfet_01v8 ad=0.145 pd=1.58 as=0 ps=0 w=0.5 l=0.5
X4257 single_9b_cdac_1.cdac_sw_9b_0.cdac_sw_3_2.tg_sw_3_3.SWN single_9b_cdac_1.cdac_sw_9b_0.cdac_sw_3_2.nooverlap_clk_0.x10.A VGND VGND sky130_fd_pr__nfet_01v8_lvt ad=0.1036 pd=1.02 as=0.2109 ps=2.05 w=0.74 l=0.15
X4258 a_12036_21076# a_10955_21076# a_11689_21318# VDPWR sky130_fd_pr__pfet_01v8_hvt ad=0.0588 pd=0.7 as=0.12915 ps=1.185 w=0.42 l=0.15
X4259 ua[0] single_9b_cdac_0.cdac_sw_9b_0.cdac_sw_3_7.tg_sw_3_3.SWN ua[0] VGND sky130_fd_pr__nfet_01v8 ad=0.145 pd=1.58 as=0 ps=0 w=0.5 l=0.5
X4260 a_11567_25188# sar9b_0.net15 VDPWR VDPWR sky130_fd_pr__pfet_01v8_hvt ad=0.0567 pd=0.69 as=0.0819 ps=0.81 w=0.42 l=0.15
X4261 a_11121_23802# a_10955_23802# VDPWR VDPWR sky130_fd_pr__pfet_01v8_hvt ad=0.1664 pd=1.8 as=0.0864 ps=0.91 w=0.64 l=0.15
X4262 VGND single_9b_cdac_1.cdac_sw_9b_0.cdac_sw_3_4.nooverlap_clk_0.CLKB0 single_9b_cdac_1.cdac_sw_9b_0.cdac_sw_3_4.nooverlap_clk_0.CLK0 VGND sky130_fd_pr__nfet_01v8_lvt ad=0.1036 pd=1.02 as=0.1036 ps=1.02 w=0.74 l=0.15
X4263 th_dif_sw_0.VCN single_9b_cdac_0.cdac_sw_9b_0.S[0] sky130_fd_pr__cap_mim_m3_1 l=2 w=2
X4264 VDPWR VGND VDPWR VDPWR sky130_fd_pr__pfet_01v8_hvt ad=0.2262 pd=2.26 as=0 ps=0 w=0.87 l=0.59
X4265 a_50962_15501# single_9b_cdac_1.CF[3] single_9b_cdac_1.cdac_sw_9b_0.cdac_sw_3_4.nooverlap_clk_0.sky130_fd_sc_hs__nand2_1_0.Y VGND sky130_fd_pr__nfet_01v8_lvt ad=0.0888 pd=0.98 as=0.2109 ps=2.05 w=0.74 l=0.15
X4266 VDPWR sar9b_0.clknet_1_1__leaf_CLK a_5619_23252# VDPWR sky130_fd_pr__pfet_01v8_hvt ad=0.0864 pd=0.91 as=0.1664 ps=1.8 w=0.64 l=0.15
X4267 a_13621_21318# a_13403_21076# VDPWR VDPWR sky130_fd_pr__pfet_01v8_hvt ad=0.12915 pd=1.185 as=0.2184 ps=2.2 w=0.84 l=0.15
X4268 ua[0] single_9b_cdac_1.cdac_sw_9b_0.cdac_sw_3_6.tg_sw_3_3.SWN ua[0] VGND sky130_fd_pr__nfet_01v8 ad=0.145 pd=1.58 as=0 ps=0 w=0.5 l=0.5
X4269 VDPWR a_13876_24174# a_14051_24100# VDPWR sky130_fd_pr__pfet_01v8_hvt ad=0.1134 pd=1.38 as=0.0567 ps=0.69 w=0.42 l=0.15
X4270 th_dif_sw_0.VCP single_9b_cdac_1.cdac_sw_9b_0.S[2] sky130_fd_pr__cap_mim_m3_1 l=2 w=2
X4271 th_dif_sw_0.VCP single_9b_cdac_1.cdac_sw_9b_0.S[0] sky130_fd_pr__cap_mim_m3_1 l=2 w=2
X4272 a_16527_10454# tdc_0.delay_gate_ori_1.sky130_fd_sc_hs__and2_1_0.A VDPWR VDPWR sky130_fd_pr__pfet_01v8 ad=0.147 pd=1.19 as=0.252 ps=2.28 w=0.84 l=0.15
X4273 sar9b_0.net15 a_6930_20241# VDPWR VDPWR sky130_fd_pr__pfet_01v8_hvt ad=0.135 pd=1.27 as=0.1625 ps=1.325 w=1 l=0.15
X4274 VGND single_9b_cdac_0.cdac_sw_9b_0.cdac_sw_3_7.nooverlap_clk_0.sky130_fd_sc_hs__inv_8_0.A single_9b_cdac_0.cdac_sw_9b_0.cdac_sw_3_7.nooverlap_clk_0.CLKB0 VGND sky130_fd_pr__nfet_01v8_lvt ad=0.1295 pd=1.09 as=0.1036 ps=1.02 w=0.74 l=0.15
X4275 VGND single_9b_cdac_0.cdac_sw_9b_0.cdac_sw_3_3.nooverlap_clk_0.CLKB0 single_9b_cdac_0.cdac_sw_9b_0.cdac_sw_3_3.nooverlap_clk_0.CLK0 VGND sky130_fd_pr__nfet_01v8_lvt ad=0.2109 pd=2.05 as=0.1036 ps=1.02 w=0.74 l=0.15
X4276 VDPWR sar9b_0.net12 a_10311_23252# VDPWR sky130_fd_pr__pfet_01v8_hvt ad=0.0864 pd=0.91 as=0.1664 ps=1.8 w=0.64 l=0.15
X4277 sar9b_0.clknet_0_CLK a_7345_21594# VGND VGND sky130_fd_pr__nfet_01v8 ad=0.0588 pd=0.7 as=0.0588 ps=0.7 w=0.42 l=0.15
X4278 th_dif_sw_0.VCP single_9b_cdac_1.cdac_sw_9b_0.S[3] sky130_fd_pr__cap_mim_m3_1 l=2 w=2
X4279 th_dif_sw_0.VCN single_9b_cdac_0.cdac_sw_9b_0.S[0] sky130_fd_pr__cap_mim_m3_1 l=2 w=2
X4280 th_dif_sw_0.VCN single_9b_cdac_0.cdac_sw_9b_0.S[1] sky130_fd_pr__cap_mim_m3_1 l=2 w=2
X4281 a_43540_26999# single_9b_cdac_0.SW[4] VDPWR VDPWR sky130_fd_pr__pfet_01v8 ad=0.435 pd=3.58 as=0.435 ps=3.58 w=1.5 l=0.5
X4282 VGND single_9b_cdac_1.cdac_sw_9b_0.cdac_sw_3_8.nooverlap_clk_0.x1.A single_9b_cdac_1.cdac_sw_9b_0.cdac_sw_3_8.nooverlap_clk_0.sky130_fd_sc_hs__inv_8_0.A VGND sky130_fd_pr__nfet_01v8_lvt ad=0.2109 pd=2.05 as=0.1036 ps=1.02 w=0.74 l=0.15
X4283 VDPWR single_9b_cdac_1.cdac_sw_9b_0.cdac_sw_3_7.nooverlap_clk_0.x10.A single_9b_cdac_1.cdac_sw_9b_0.cdac_sw_3_7.tg_sw_3_3.SWN VDPWR sky130_fd_pr__pfet_01v8 ad=0.196 pd=1.47 as=0.168 ps=1.42 w=1.12 l=0.15
X4284 VDPWR a_8613_26681# uo_out[6] VDPWR sky130_fd_pr__pfet_01v8_hvt ad=0.11455 pd=1.08 as=0.2054 ps=2.1 w=0.79 l=0.15
X4285 single_9b_cdac_0.cdac_sw_9b_0.S[2] single_9b_cdac_0.cdac_sw_9b_0.cdac_sw_3_0.tg_sw_3_3.SWP ua[0] VGND sky130_fd_pr__nfet_01v8 ad=0.145 pd=1.58 as=0.145 ps=1.58 w=0.5 l=0.5
X4286 single_9b_cdac_0.cdac_sw_9b_0.cdac_sw_3_2.nooverlap_clk_0.CLKB0 single_9b_cdac_0.cdac_sw_9b_0.cdac_sw_3_2.nooverlap_clk_0.sky130_fd_sc_hs__inv_8_0.A VDPWR VDPWR sky130_fd_pr__pfet_01v8 ad=0.168 pd=1.42 as=0.196 ps=1.47 w=1.12 l=0.15
X4287 a_12947_26276# a_12772_26350# a_13126_26338# VGND sky130_fd_pr__nfet_01v8 ad=0.1092 pd=1.36 as=0.06405 ps=0.725 w=0.42 l=0.15
X4288 a_6427_25794# a_5803_25428# a_6319_25428# VDPWR sky130_fd_pr__pfet_01v8_hvt ad=0.1155 pd=0.97 as=0.07245 ps=0.765 w=0.42 l=0.15
X4289 VGND sar9b_0.net33 a_13623_25972# VGND sky130_fd_pr__nfet_01v8 ad=0.0754 pd=0.81 as=0.1352 ps=1.56 w=0.52 l=0.15
X4290 a_9555_22530# sar9b_0.net15 VDPWR VDPWR sky130_fd_pr__pfet_01v8_hvt ad=0.1092 pd=1.36 as=0.07035 ps=0.755 w=0.42 l=0.15
X4291 th_dif_sw_0.VCP single_9b_cdac_1.cdac_sw_9b_0.S[5] sky130_fd_pr__cap_mim_m3_1 l=2 w=2
X4292 th_dif_sw_0.VCP single_9b_cdac_1.cdac_sw_9b_0.S[2] sky130_fd_pr__cap_mim_m3_1 l=2 w=2
X4293 VDPWR a_9205_23494# a_9095_23618# VDPWR sky130_fd_pr__pfet_01v8_hvt ad=0.07035 pd=0.755 as=0.1155 ps=0.97 w=0.42 l=0.15
X4294 th_dif_sw_0.VCN single_9b_cdac_0.cdac_sw_9b_0.S[0] sky130_fd_pr__cap_mim_m3_1 l=2 w=2
X4295 VGND single_9b_cdac_1.cdac_sw_9b_0.cdac_sw_3_8.nooverlap_clk_0.sky130_fd_sc_hs__inv_8_0.A single_9b_cdac_1.cdac_sw_9b_0.cdac_sw_3_8.nooverlap_clk_0.CLKB0 VGND sky130_fd_pr__nfet_01v8_lvt ad=0.1554 pd=1.16 as=0.1036 ps=1.02 w=0.74 l=0.15
X4296 a_63626_26990# single_9b_cdac_0.cdac_sw_9b_0.cdac_sw_3_2.nooverlap_clk_0.CLK0 single_9b_cdac_0.cdac_sw_9b_0.S[0] VGND sky130_fd_pr__nfet_01v8 ad=0.145 pd=1.58 as=0.145 ps=1.58 w=0.5 l=0.5
X4297 single_9b_cdac_1.cdac_sw_9b_0.S[7] single_9b_cdac_1.cdac_sw_9b_0.cdac_sw_3_7.tg_sw_3_3.SWN single_9b_cdac_1.cdac_sw_9b_0.S[7] VGND sky130_fd_pr__nfet_01v8 ad=0.145 pd=1.58 as=0 ps=0 w=0.5 l=0.5
X4298 single_9b_cdac_1.cdac_sw_9b_0.cdac_sw_3_5.tg_sw_3_3.SWP single_9b_cdac_1.cdac_sw_9b_0.cdac_sw_3_5.tg_sw_3_3.SWN VGND VGND sky130_fd_pr__nfet_01v8_lvt ad=0.1036 pd=1.02 as=0.1036 ps=1.02 w=0.74 l=0.15
X4299 a_10371_26490# sar9b_0.net3 VDPWR VDPWR sky130_fd_pr__pfet_01v8_hvt ad=0.0567 pd=0.69 as=0.0819 ps=0.81 w=0.42 l=0.15
X4300 th_dif_sw_0.VCP single_9b_cdac_1.cdac_sw_9b_0.S[0] sky130_fd_pr__cap_mim_m3_1 l=2 w=2
X4301 th_dif_sw_0.th_sw_1.CK a_9132_7271# VDPWR VDPWR sky130_fd_pr__pfet_01v8 ad=0.168 pd=1.42 as=0.168 ps=1.42 w=1.12 l=0.15
X4302 a_11413_25670# a_11195_25428# VDPWR VDPWR sky130_fd_pr__pfet_01v8_hvt ad=0.12915 pd=1.185 as=0.2184 ps=2.2 w=0.84 l=0.15
X4303 th_dif_sw_0.VCN single_9b_cdac_0.cdac_sw_9b_0.S[4] sky130_fd_pr__cap_mim_m3_1 l=2 w=2
X4304 VGND single_9b_cdac_1.SW[1] a_58824_17740# VGND sky130_fd_pr__nfet_01v8 ad=0.145 pd=1.58 as=0.145 ps=1.58 w=0.5 l=0.5
X4305 VDPWR VGND VDPWR VDPWR sky130_fd_pr__pfet_01v8_hvt ad=0.2262 pd=2.26 as=0 ps=0 w=0.87 l=0.59
X4306 a_12211_24100# a_12036_24174# a_12390_24162# VGND sky130_fd_pr__nfet_01v8 ad=0.1092 pd=1.36 as=0.06405 ps=0.725 w=0.42 l=0.15
X4307 a_13403_23086# a_13053_22714# a_13308_23074# VDPWR sky130_fd_pr__pfet_01v8_hvt ad=0.07245 pd=0.765 as=0.0651 ps=0.73 w=0.42 l=0.15
X4308 single_9b_cdac_1.cdac_sw_9b_0.S[8] single_9b_cdac_1.cdac_sw_9b_0.cdac_sw_3_8.nooverlap_clk_0.CLKB0 a_24332_16877# VDPWR sky130_fd_pr__pfet_01v8 ad=0.435 pd=3.58 as=0.435 ps=3.58 w=1.5 l=0.5
X4309 single_9b_cdac_1.cdac_sw_9b_0.cdac_sw_3_7.nooverlap_clk_0.CLKB0 single_9b_cdac_1.cdac_sw_9b_0.cdac_sw_3_7.nooverlap_clk_0.sky130_fd_sc_hs__inv_8_0.A VGND VGND sky130_fd_pr__nfet_01v8_lvt ad=0.1036 pd=1.02 as=0.2109 ps=2.05 w=0.74 l=0.15
X4310 tdc_0.phase_detector_0.pd_out_0.B tdc_0.phase_detector_0.pd_out_0.A a_15052_11404# VGND sky130_fd_pr__nfet_01v8 ad=0.29 pd=2.58 as=0.145 ps=1.29 w=1 l=0.15
X4311 th_dif_sw_0.VCN single_9b_cdac_0.cdac_sw_9b_0.S[1] sky130_fd_pr__cap_mim_m3_1 l=2 w=2
X4312 VDPWR single_9b_cdac_0.cdac_sw_9b_0.cdac_sw_3_6.nooverlap_clk_0.x8.A single_9b_cdac_0.cdac_sw_9b_0.cdac_sw_3_6.nooverlap_clk_0.x10.A VDPWR sky130_fd_pr__pfet_01v8 ad=0.3304 pd=2.83 as=0.168 ps=1.42 w=1.12 l=0.15
X4313 a_48343_26999# single_9b_cdac_0.SW[3] VDPWR VDPWR sky130_fd_pr__pfet_01v8 ad=0.435 pd=3.58 as=0.435 ps=3.58 w=1.5 l=0.5
X4314 single_9b_cdac_0.cdac_sw_9b_0.S[2] single_9b_cdac_0.cdac_sw_9b_0.cdac_sw_3_0.tg_sw_3_3.SWP single_9b_cdac_0.cdac_sw_9b_0.S[2] VDPWR sky130_fd_pr__pfet_01v8 ad=0.435 pd=3.58 as=0 ps=0 w=1.5 l=0.5
X4315 VGND single_9b_cdac_1.SW[6] a_34814_17740# VGND sky130_fd_pr__nfet_01v8 ad=0.145 pd=1.58 as=0.145 ps=1.58 w=0.5 l=0.5
X4316 th_dif_sw_0.VCP single_9b_cdac_1.cdac_sw_9b_0.S[3] sky130_fd_pr__cap_mim_m3_1 l=2 w=2
X4317 th_dif_sw_0.VCN single_9b_cdac_0.cdac_sw_9b_0.S[1] sky130_fd_pr__cap_mim_m3_1 l=2 w=2
X4318 a_11121_26516# a_10955_26516# VGND VGND sky130_fd_pr__nfet_01v8 ad=0.1092 pd=1.36 as=0.0567 ps=0.69 w=0.42 l=0.15
X4319 VGND single_9b_cdac_0.cdac_sw_9b_0.cdac_sw_3_0.nooverlap_clk_0.CLKB0 single_9b_cdac_0.cdac_sw_9b_0.cdac_sw_3_0.nooverlap_clk_0.CLK0 VGND sky130_fd_pr__nfet_01v8_lvt ad=0.1036 pd=1.02 as=0.1036 ps=1.02 w=0.74 l=0.15
X4320 VGND a_6219_22316# sar9b_0._04_ VGND sky130_fd_pr__nfet_01v8 ad=0.13165 pd=1.14 as=0.169 ps=1.82 w=0.65 l=0.15
X4321 VDPWR a_12036_21076# a_12211_21050# VDPWR sky130_fd_pr__pfet_01v8_hvt ad=0.1134 pd=1.38 as=0.0567 ps=0.69 w=0.42 l=0.15
X4322 th_dif_sw_0.VCN single_9b_cdac_0.cdac_sw_9b_0.S[0] sky130_fd_pr__cap_mim_m3_1 l=2 w=2
X4323 VGND single_9b_cdac_0.cdac_sw_9b_0.cdac_sw_3_1.nooverlap_clk_0.sky130_fd_sc_hs__inv_8_0.A single_9b_cdac_0.cdac_sw_9b_0.cdac_sw_3_1.nooverlap_clk_0.CLKB0 VGND sky130_fd_pr__nfet_01v8_lvt ad=0.1036 pd=1.02 as=0.1036 ps=1.02 w=0.74 l=0.15
X4324 a_6884_25428# a_5803_25428# a_6537_25670# VDPWR sky130_fd_pr__pfet_01v8_hvt ad=0.0588 pd=0.7 as=0.12915 ps=1.185 w=0.42 l=0.15
X4325 a_9460_24340# a_8545_24340# a_9113_24582# VGND sky130_fd_pr__special_nfet_01v8 ad=0.0711 pd=0.755 as=0.0999 ps=0.985 w=0.36 l=0.15
X4326 a_9665_22406# a_9447_22164# VDPWR VDPWR sky130_fd_pr__pfet_01v8_hvt ad=0.12915 pd=1.185 as=0.2184 ps=2.2 w=0.84 l=0.15
X4327 th_dif_sw_0.VCP single_9b_cdac_1.cdac_sw_9b_0.S[0] sky130_fd_pr__cap_mim_m3_1 l=2 w=2
X4328 VGND single_9b_cdac_0.cdac_sw_9b_0.cdac_sw_3_2.nooverlap_clk_0.x10.A single_9b_cdac_0.cdac_sw_9b_0.cdac_sw_3_2.tg_sw_3_3.SWN VGND sky130_fd_pr__nfet_01v8_lvt ad=0.2109 pd=2.05 as=0.1036 ps=1.02 w=0.74 l=0.15
X4329 a_14143_25188# a_13968_25262# a_14322_25250# VGND sky130_fd_pr__nfet_01v8 ad=0.1092 pd=1.36 as=0.06405 ps=0.725 w=0.42 l=0.15
X4330 th_dif_sw_0.VCP single_9b_cdac_1.cdac_sw_9b_0.S[4] sky130_fd_pr__cap_mim_m3_1 l=2 w=2
X4331 VDPWR tdc_0.phase_detector_0.pd_out_0.B tdc_0.OUTP VDPWR sky130_fd_pr__pfet_01v8 ad=0.3192 pd=2.81 as=0.168 ps=1.42 w=1.12 l=0.15
X4332 VGND VDPWR VGND VGND sky130_fd_pr__nfet_01v8 ad=0.143 pd=1.62 as=0 ps=0 w=0.55 l=0.59
X4333 single_9b_cdac_0.cdac_sw_9b_0.S[2] single_9b_cdac_0.cdac_sw_9b_0.cdac_sw_3_0.tg_sw_3_3.SWN single_9b_cdac_0.cdac_sw_9b_0.S[2] VGND sky130_fd_pr__nfet_01v8 ad=0.145 pd=1.58 as=0 ps=0 w=0.5 l=0.5
X4334 th_dif_sw_0.VCN single_9b_cdac_0.cdac_sw_9b_0.S[2] sky130_fd_pr__cap_mim_m3_1 l=2 w=2
X4335 VGND VDPWR VGND VGND sky130_fd_pr__nfet_01v8 ad=0.143 pd=1.62 as=0 ps=0 w=0.55 l=0.59
X4336 VDPWR a_13968_22164# a_14143_22138# VDPWR sky130_fd_pr__pfet_01v8_hvt ad=0.1134 pd=1.38 as=0.0567 ps=0.69 w=0.42 l=0.15
X4337 th_dif_sw_0.VCP single_9b_cdac_1.cdac_sw_9b_0.S[2] sky130_fd_pr__cap_mim_m3_1 l=2 w=2
X4338 VDPWR a_5945_26191# uio_out[1] VDPWR sky130_fd_pr__pfet_01v8_hvt ad=0.11455 pd=1.08 as=0.2054 ps=2.1 w=0.79 l=0.15
X4339 single_9b_cdac_1.cdac_sw_9b_0.S[7] single_9b_cdac_1.cdac_sw_9b_0.cdac_sw_3_7.nooverlap_clk_0.CLKB0 a_29134_16877# VDPWR sky130_fd_pr__pfet_01v8 ad=0.435 pd=3.58 as=0.435 ps=3.58 w=1.5 l=0.5
X4340 single_9b_cdac_1.cdac_sw_9b_0.cdac_sw_3_8.nooverlap_clk_0.sky130_fd_sc_hs__inv_1_1.A single_9b_cdac_1.cdac_sw_9b_0.cdac_sw_3_8.nooverlap_clk_0.sky130_fd_sc_hs__nand2_1_0.Y VDPWR VDPWR sky130_fd_pr__pfet_01v8 ad=0.3304 pd=2.83 as=0.3864 ps=2.93 w=1.12 l=0.15
X4341 tdc_0.OUTP tdc_0.OUTN VDPWR VDPWR sky130_fd_pr__pfet_01v8 ad=0.168 pd=1.42 as=0.3192 ps=2.81 w=1.12 l=0.15
X4342 VDPWR a_6907_19444# sar9b_0.clkload0.X VDPWR sky130_fd_pr__pfet_01v8_hvt ad=0.14 pd=1.28 as=0.14 ps=1.28 w=1 l=0.15
X4343 a_5856_26516# sar9b_0.net36 VDPWR VDPWR sky130_fd_pr__pfet_01v8_hvt ad=0.0651 pd=0.73 as=0.1092 ps=1.36 w=0.42 l=0.15
X4344 VGND sar9b_0.clknet_0_CLK a_6149_23770# VGND sky130_fd_pr__nfet_01v8 ad=0.0588 pd=0.7 as=0.0588 ps=0.7 w=0.42 l=0.15
X4345 th_dif_sw_0.VCN single_9b_cdac_0.cdac_sw_9b_0.S[0] sky130_fd_pr__cap_mim_m3_1 l=2 w=2
X4346 VDPWR VGND VDPWR VDPWR sky130_fd_pr__pfet_01v8_hvt ad=0.2262 pd=2.26 as=0 ps=0 w=0.87 l=0.59
X4347 a_10935_24884# sar9b_0.net15 VDPWR VDPWR sky130_fd_pr__pfet_01v8_hvt ad=0.1092 pd=1.36 as=0.07035 ps=0.755 w=0.42 l=0.15
X4348 th_dif_sw_0.VCP single_9b_cdac_1.cdac_sw_9b_0.S[2] sky130_fd_pr__cap_mim_m3_1 l=2 w=2
X4349 th_dif_sw_0.th_sw_1.CK a_9132_7271# VGND VGND sky130_fd_pr__nfet_01v8_lvt ad=0.1036 pd=1.02 as=0.1554 ps=1.16 w=0.74 l=0.15
X4350 VGND single_9b_cdac_0.cdac_sw_9b_0.cdac_sw_3_2.nooverlap_clk_0.sky130_fd_sc_hs__inv_8_0.A single_9b_cdac_0.cdac_sw_9b_0.cdac_sw_3_2.nooverlap_clk_0.CLKB0 VGND sky130_fd_pr__nfet_01v8_lvt ad=0.1554 pd=1.16 as=0.1036 ps=1.02 w=0.74 l=0.15
X4351 dw_12589_1395# a_10166_3438# sky130_fd_pr__cap_mim_m3_1 l=2 w=2
X4352 th_dif_sw_0.VCP single_9b_cdac_1.cdac_sw_9b_0.S[5] sky130_fd_pr__cap_mim_m3_1 l=2 w=2
X4353 VGND a_11649_27279# uo_out[3] VGND sky130_fd_pr__nfet_01v8 ad=0.0754 pd=0.81 as=0.1352 ps=1.56 w=0.52 l=0.15
X4354 a_13621_20230# a_13403_19988# VDPWR VDPWR sky130_fd_pr__pfet_01v8_hvt ad=0.12915 pd=1.185 as=0.2184 ps=2.2 w=0.84 l=0.15
X4355 a_11579_23796# sar9b_0.net15 VDPWR VDPWR sky130_fd_pr__pfet_01v8_hvt ad=0.1092 pd=1.36 as=0.07035 ps=0.755 w=0.42 l=0.15
X4356 th_dif_sw_0.VCN single_9b_cdac_0.cdac_sw_9b_0.S[3] sky130_fd_pr__cap_mim_m3_1 l=2 w=2
X4357 a_6884_25428# a_5969_25428# a_6537_25670# VGND sky130_fd_pr__special_nfet_01v8 ad=0.0711 pd=0.755 as=0.0999 ps=0.985 w=0.36 l=0.15
X4358 VGND VDPWR VGND VGND sky130_fd_pr__nfet_01v8 ad=0.143 pd=1.62 as=0 ps=0 w=0.55 l=0.59
X4359 th_dif_sw_0.VCP single_9b_cdac_1.cdac_sw_9b_0.S[1] sky130_fd_pr__cap_mim_m3_1 l=2 w=2
X4360 a_11649_27279# sar9b_0.net23 VGND VGND sky130_fd_pr__nfet_01v8 ad=0.1352 pd=1.56 as=0.0754 ps=0.81 w=0.52 l=0.15
X4361 a_6219_22316# sar9b_0._09_ VDPWR VDPWR sky130_fd_pr__pfet_01v8_hvt ad=0.1092 pd=1.36 as=0.0567 ps=0.69 w=0.42 l=0.15
X4362 single_9b_cdac_0.cdac_sw_9b_0.cdac_sw_3_0.nooverlap_clk_0.x10.A single_9b_cdac_0.cdac_sw_9b_0.cdac_sw_3_0.nooverlap_clk_0.x8.A VDPWR VDPWR sky130_fd_pr__pfet_01v8 ad=0.168 pd=1.42 as=0.168 ps=1.42 w=1.12 l=0.15
X4363 a_13621_25670# a_13403_25428# VGND VGND sky130_fd_pr__nfet_01v8 ad=0.0999 pd=0.985 as=0.1346 ps=1.15 w=0.64 l=0.15
X4364 VDPWR VGND VDPWR VDPWR sky130_fd_pr__pfet_01v8_hvt ad=0.2262 pd=2.26 as=0 ps=0 w=0.87 l=0.59
X4365 single_9b_cdac_1.cdac_sw_9b_0.cdac_sw_3_2.nooverlap_clk_0.sky130_fd_sc_hs__inv_8_0.A single_9b_cdac_1.cdac_sw_9b_0.cdac_sw_3_2.nooverlap_clk_0.x1.A VGND VGND sky130_fd_pr__nfet_01v8_lvt ad=0.1184 pd=1.06 as=0.2331 ps=2.11 w=0.74 l=0.15
X4366 single_9b_cdac_0.cdac_sw_9b_0.cdac_sw_3_7.tg_sw_3_3.SWN single_9b_cdac_0.cdac_sw_9b_0.cdac_sw_3_7.nooverlap_clk_0.x10.A VDPWR VDPWR sky130_fd_pr__pfet_01v8 ad=0.168 pd=1.42 as=0.196 ps=1.47 w=1.12 l=0.15
X4367 VDPWR single_9b_cdac_0.cdac_sw_9b_0.cdac_sw_3_3.nooverlap_clk_0.x10.A single_9b_cdac_0.cdac_sw_9b_0.cdac_sw_3_3.tg_sw_3_3.SWN VDPWR sky130_fd_pr__pfet_01v8 ad=0.196 pd=1.47 as=0.168 ps=1.42 w=1.12 l=0.15
X4368 single_9b_cdac_1.cdac_sw_9b_0.cdac_sw_3_5.nooverlap_clk_0.CLKB0 single_9b_cdac_1.cdac_sw_9b_0.cdac_sw_3_5.nooverlap_clk_0.sky130_fd_sc_hs__inv_8_0.A VGND VGND sky130_fd_pr__nfet_01v8_lvt ad=0.1036 pd=1.02 as=0.1554 ps=1.16 w=0.74 l=0.15
X4369 VGND single_9b_cdac_1.cdac_sw_9b_0.cdac_sw_3_2.nooverlap_clk_0.sky130_fd_sc_hs__inv_8_0.A single_9b_cdac_1.cdac_sw_9b_0.cdac_sw_3_2.nooverlap_clk_0.CLKB0 VGND sky130_fd_pr__nfet_01v8_lvt ad=0.1295 pd=1.09 as=0.1036 ps=1.02 w=0.74 l=0.15
X4370 VGND sar9b_0.net7 a_12887_18900# VGND sky130_fd_pr__nfet_01v8 ad=0.0567 pd=0.69 as=0.1092 ps=1.36 w=0.42 l=0.15
X4371 VGND single_9b_cdac_0.cdac_sw_9b_0.cdac_sw_3_4.nooverlap_clk_0.x1.A single_9b_cdac_0.cdac_sw_9b_0.cdac_sw_3_4.nooverlap_clk_0.sky130_fd_sc_hs__inv_8_0.A VGND sky130_fd_pr__nfet_01v8_lvt ad=0.1221 pd=1.07 as=0.1036 ps=1.02 w=0.74 l=0.15
X4372 VDPWR VGND VDPWR VDPWR sky130_fd_pr__pfet_01v8_hvt ad=0.2262 pd=2.26 as=0 ps=0 w=0.87 l=0.59
X4373 th_dif_sw_0.VCP single_9b_cdac_1.cdac_sw_9b_0.S[0] sky130_fd_pr__cap_mim_m3_1 l=2 w=2
X4374 th_dif_sw_0.VCN single_9b_cdac_0.cdac_sw_9b_0.S[1] sky130_fd_pr__cap_mim_m3_1 l=2 w=2
X4375 sar9b_0.net24 a_12211_26490# VGND VGND sky130_fd_pr__nfet_01v8 ad=0.169 pd=1.82 as=0.2087 ps=2.02 w=0.65 l=0.15
X4376 VGND single_9b_cdac_0.cdac_sw_9b_0.cdac_sw_3_7.nooverlap_clk_0.sky130_fd_sc_hs__inv_8_0.A single_9b_cdac_0.cdac_sw_9b_0.cdac_sw_3_7.nooverlap_clk_0.CLKB0 VGND sky130_fd_pr__nfet_01v8_lvt ad=0.2109 pd=2.05 as=0.1036 ps=1.02 w=0.74 l=0.15
X4377 a_30012_26990# single_9b_cdac_0.cdac_sw_9b_0.cdac_sw_3_7.nooverlap_clk_0.CLK0 single_9b_cdac_0.cdac_sw_9b_0.S[7] VGND sky130_fd_pr__nfet_01v8 ad=0.145 pd=1.58 as=0.145 ps=1.58 w=0.5 l=0.5
X4378 single_9b_cdac_0.cdac_sw_9b_0.cdac_sw_3_3.tg_sw_3_3.SWN single_9b_cdac_0.cdac_sw_9b_0.cdac_sw_3_3.nooverlap_clk_0.x10.A VDPWR VDPWR sky130_fd_pr__pfet_01v8 ad=0.168 pd=1.42 as=0.168 ps=1.42 w=1.12 l=0.15
X4379 VDPWR single_9b_cdac_0.cdac_sw_9b_0.cdac_sw_3_0.nooverlap_clk_0.x8.A single_9b_cdac_0.cdac_sw_9b_0.cdac_sw_3_0.nooverlap_clk_0.x10.A VDPWR sky130_fd_pr__pfet_01v8 ad=0.168 pd=1.42 as=0.168 ps=1.42 w=1.12 l=0.15
X4380 sar9b_0.net6 a_11567_19748# VDPWR VDPWR sky130_fd_pr__pfet_01v8_hvt ad=0.26 pd=2.52 as=0.3012 ps=2.66 w=1 l=0.15
X4381 tdc_0.phase_detector_0.pd_out_0.A tdc_0.phase_detector_0.INP a_16222_11316# VDPWR sky130_fd_pr__pfet_01v8 ad=0.435 pd=3.29 as=0.435 ps=3.29 w=3 l=0.15
X4382 VGND single_9b_cdac_1.SW[0] a_63626_17740# VGND sky130_fd_pr__nfet_01v8 ad=0.145 pd=1.58 as=0.145 ps=1.58 w=0.5 l=0.5
X4383 a_63626_17740# single_9b_cdac_1.cdac_sw_9b_0.cdac_sw_3_2.nooverlap_clk_0.CLK0 single_9b_cdac_1.cdac_sw_9b_0.S[0] VGND sky130_fd_pr__nfet_01v8 ad=0.145 pd=1.58 as=0.145 ps=1.58 w=0.5 l=0.5
X4384 single_9b_cdac_0.cdac_sw_9b_0.cdac_sw_3_6.nooverlap_clk_0.x10.A single_9b_cdac_0.cdac_sw_9b_0.cdac_sw_3_6.nooverlap_clk_0.x8.A VGND VGND sky130_fd_pr__nfet_01v8_lvt ad=0.1184 pd=1.06 as=0.1221 ps=1.07 w=0.74 l=0.15
X4385 th_dif_sw_0.VCN single_9b_cdac_0.cdac_sw_9b_0.S[1] sky130_fd_pr__cap_mim_m3_1 l=2 w=2
X4386 th_dif_sw_0.VCN single_9b_cdac_0.cdac_sw_9b_0.S[0] sky130_fd_pr__cap_mim_m3_1 l=2 w=2
X4387 VGND single_9b_cdac_0.cdac_sw_9b_0.cdac_sw_3_3.nooverlap_clk_0.CLKB0 single_9b_cdac_0.cdac_sw_9b_0.cdac_sw_3_3.nooverlap_clk_0.CLK0 VGND sky130_fd_pr__nfet_01v8_lvt ad=0.1036 pd=1.02 as=0.1036 ps=1.02 w=0.74 l=0.15
X4388 single_9b_cdac_0.cdac_sw_9b_0.cdac_sw_3_1.tg_sw_3_3.SWN single_9b_cdac_0.cdac_sw_9b_0.cdac_sw_3_1.nooverlap_clk_0.x10.A VGND VGND sky130_fd_pr__nfet_01v8_lvt ad=0.1036 pd=1.02 as=0.1036 ps=1.02 w=0.74 l=0.15
X4389 th_dif_sw_0.VCP single_9b_cdac_1.cdac_sw_9b_0.S[0] sky130_fd_pr__cap_mim_m3_1 l=2 w=2
X4390 VDPWR a_10012_22164# a_10187_22138# VDPWR sky130_fd_pr__pfet_01v8_hvt ad=0.1134 pd=1.38 as=0.0567 ps=0.69 w=0.42 l=0.15
X4391 th_dif_sw_0.VCN single_9b_cdac_0.cdac_sw_9b_0.S[0] sky130_fd_pr__cap_mim_m3_1 l=2 w=2
X4392 VGND single_9b_cdac_0.cdac_sw_9b_0.cdac_sw_3_7.tg_sw_3_3.SWN single_9b_cdac_0.cdac_sw_9b_0.cdac_sw_3_7.tg_sw_3_3.SWP VGND sky130_fd_pr__nfet_01v8_lvt ad=0.1554 pd=1.16 as=0.1036 ps=1.02 w=0.74 l=0.15
X4393 VDPWR single_9b_cdac_0.cdac_sw_9b_0.cdac_sw_3_3.nooverlap_clk_0.x10.A single_9b_cdac_0.cdac_sw_9b_0.cdac_sw_3_3.tg_sw_3_3.SWN VDPWR sky130_fd_pr__pfet_01v8 ad=0.168 pd=1.42 as=0.168 ps=1.42 w=1.12 l=0.15
X4394 single_9b_cdac_0.cdac_sw_9b_0.cdac_sw_3_0.nooverlap_clk_0.x10.A single_9b_cdac_0.cdac_sw_9b_0.cdac_sw_3_0.nooverlap_clk_0.x8.A VDPWR VDPWR sky130_fd_pr__pfet_01v8 ad=0.168 pd=1.42 as=0.3304 ps=2.83 w=1.12 l=0.15
X4395 VDPWR a_9849_21318# a_9739_21442# VDPWR sky130_fd_pr__pfet_01v8_hvt ad=0.07035 pd=0.755 as=0.1155 ps=0.97 w=0.42 l=0.15
X4396 a_5483_19676# a_5579_19676# VDPWR VDPWR sky130_fd_pr__pfet_01v8_hvt ad=0.27 pd=2.54 as=0.135 ps=1.27 w=1 l=0.15
X4397 VDPWR VGND VDPWR VDPWR sky130_fd_pr__pfet_01v8_hvt ad=0.2262 pd=2.26 as=0 ps=0 w=0.87 l=0.59
X4398 th_dif_sw_0.VCP single_9b_cdac_1.cdac_sw_9b_0.S[0] sky130_fd_pr__cap_mim_m3_1 l=2 w=2
X4399 a_9738_20240# a_10016_20256# a_9972_20354# VDPWR sky130_fd_pr__pfet_01v8_hvt ad=0.0588 pd=0.7 as=0.0567 ps=0.69 w=0.42 l=0.15
X4400 VDPWR single_9b_cdac_1.cdac_sw_9b_0.cdac_sw_3_6.nooverlap_clk_0.x1.A single_9b_cdac_1.cdac_sw_9b_0.cdac_sw_3_6.nooverlap_clk_0.x4.A VDPWR sky130_fd_pr__pfet_01v8 ad=0.3192 pd=2.81 as=0.168 ps=1.42 w=1.12 l=0.15
X4401 VGND a_9175_27364# a_9109_27438# VGND sky130_fd_pr__nfet_01v8 ad=0.12495 pd=1.015 as=0.0669 ps=0.75 w=0.42 l=0.15
X4402 VDPWR single_9b_cdac_0.cdac_sw_9b_0.cdac_sw_3_0.nooverlap_clk_0.x1.A single_9b_cdac_0.cdac_sw_9b_0.cdac_sw_3_0.nooverlap_clk_0.sky130_fd_sc_hs__inv_8_0.A VDPWR sky130_fd_pr__pfet_01v8 ad=0.3304 pd=2.83 as=0.168 ps=1.42 w=1.12 l=0.15
X4403 a_9078_20506# a_8910_20532# VDPWR VDPWR sky130_fd_pr__pfet_01v8_hvt ad=0.1095 pd=1.075 as=0.17887 ps=1.26 w=0.75 l=0.15
X4404 a_57946_16877# single_9b_cdac_1.SW[1] VDPWR VDPWR sky130_fd_pr__pfet_01v8 ad=0.435 pd=3.58 as=0.435 ps=3.58 w=1.5 l=0.5
X4405 a_55773_29911# single_9b_cdac_0.cdac_sw_9b_0.cdac_sw_3_0.nooverlap_clk_0.x8.A VGND VGND sky130_fd_pr__nfet_01v8_lvt ad=0.0888 pd=0.98 as=0.2109 ps=2.05 w=0.74 l=0.15
X4406 VGND VDPWR VGND VGND sky130_fd_pr__nfet_01v8 ad=0.143 pd=1.62 as=0 ps=0 w=0.55 l=0.59
X4407 th_dif_sw_0.VCN single_9b_cdac_0.cdac_sw_9b_0.S[3] sky130_fd_pr__cap_mim_m3_1 l=2 w=2
X4408 single_9b_cdac_0.cdac_sw_9b_0.cdac_sw_3_8.tg_sw_3_3.SWP single_9b_cdac_0.cdac_sw_9b_0.cdac_sw_3_8.tg_sw_3_3.SWN VDPWR VDPWR sky130_fd_pr__pfet_01v8 ad=0.168 pd=1.42 as=0.196 ps=1.47 w=1.12 l=0.15
X4409 a_13511_24884# a_12887_24890# a_13403_25262# VDPWR sky130_fd_pr__pfet_01v8_hvt ad=0.1155 pd=0.97 as=0.07245 ps=0.765 w=0.42 l=0.15
X4410 single_9b_cdac_1.cdac_sw_9b_0.cdac_sw_3_6.nooverlap_clk_0.x4.A single_9b_cdac_1.cdac_sw_9b_0.cdac_sw_3_6.nooverlap_clk_0.x3.Y VDPWR VDPWR sky130_fd_pr__pfet_01v8 ad=0.168 pd=1.42 as=0.3192 ps=2.81 w=1.12 l=0.15
X4411 VGND sar9b_0.net3 a_5725_27426# VGND sky130_fd_pr__nfet_01v8 ad=0.12495 pd=1.015 as=0.06405 ps=0.725 w=0.42 l=0.15
X4412 VDPWR single_9b_cdac_0.cdac_sw_9b_0.cdac_sw_3_7.nooverlap_clk_0.CLKB0 single_9b_cdac_0.cdac_sw_9b_0.cdac_sw_3_7.nooverlap_clk_0.CLK0 VDPWR sky130_fd_pr__pfet_01v8 ad=0.3304 pd=2.83 as=0.168 ps=1.42 w=1.12 l=0.15
X4413 sar9b_0.clknet_1_0__leaf_CLK a_6701_20506# VDPWR VDPWR sky130_fd_pr__pfet_01v8_hvt ad=0.14 pd=1.28 as=0.14 ps=1.28 w=1 l=0.15
X4414 VGND single_9b_cdac_1.cdac_sw_9b_0.cdac_sw_3_7.nooverlap_clk_0.x8.A single_9b_cdac_1.cdac_sw_9b_0.cdac_sw_3_7.nooverlap_clk_0.x10.A VGND sky130_fd_pr__nfet_01v8_lvt ad=0.1221 pd=1.07 as=0.1184 ps=1.06 w=0.74 l=0.15
X4415 th_dif_sw_0.VCP single_9b_cdac_1.cdac_sw_9b_0.S[2] sky130_fd_pr__cap_mim_m3_1 l=2 w=2
X4416 VGND single_9b_cdac_1.cdac_sw_9b_0.cdac_sw_3_7.nooverlap_clk_0.x8.A a_31753_15501# VGND sky130_fd_pr__nfet_01v8_lvt ad=0.2109 pd=2.05 as=0.0888 ps=0.98 w=0.74 l=0.15
X4417 single_9b_cdac_0.cdac_sw_9b_0.cdac_sw_3_7.nooverlap_clk_0.CLK0 single_9b_cdac_0.cdac_sw_9b_0.cdac_sw_3_7.nooverlap_clk_0.CLKB0 VDPWR VDPWR sky130_fd_pr__pfet_01v8 ad=0.168 pd=1.42 as=0.196 ps=1.47 w=1.12 l=0.15
X4418 th_dif_sw_0.VCN single_9b_cdac_0.cdac_sw_9b_0.S[0] sky130_fd_pr__cap_mim_m3_1 l=2 w=2
X4419 a_9849_26758# a_9631_26516# VDPWR VDPWR sky130_fd_pr__pfet_01v8_hvt ad=0.12915 pd=1.185 as=0.2184 ps=2.2 w=0.84 l=0.15
X4420 VDPWR VGND VDPWR VDPWR sky130_fd_pr__pfet_01v8_hvt ad=0.2262 pd=2.26 as=0 ps=0 w=0.87 l=0.59
X4421 VDPWR a_7345_21594# sar9b_0.clknet_0_CLK VDPWR sky130_fd_pr__pfet_01v8_hvt ad=0.14 pd=1.28 as=0.14 ps=1.28 w=1 l=0.15
X4422 th_dif_sw_0.VCP single_9b_cdac_1.cdac_sw_9b_0.S[2] sky130_fd_pr__cap_mim_m3_1 l=2 w=2
X4423 th_dif_sw_0.VCN single_9b_cdac_0.cdac_sw_9b_0.S[3] sky130_fd_pr__cap_mim_m3_1 l=2 w=2
X4424 a_30717_29917# single_9b_cdac_0.cdac_sw_9b_0.cdac_sw_3_7.nooverlap_clk_0.x1.A single_9b_cdac_0.cdac_sw_9b_0.cdac_sw_3_7.nooverlap_clk_0.x4.A VGND sky130_fd_pr__nfet_01v8_lvt ad=0.0888 pd=0.98 as=0.2109 ps=2.05 w=0.74 l=0.15
X4425 th_dif_sw_0.VCP single_9b_cdac_1.cdac_sw_9b_0.S[0] sky130_fd_pr__cap_mim_m3_1 l=2 w=2
X4426 VGND single_9b_cdac_0.cdac_sw_9b_0.cdac_sw_3_2.nooverlap_clk_0.x10.A single_9b_cdac_0.cdac_sw_9b_0.cdac_sw_3_2.tg_sw_3_3.SWN VGND sky130_fd_pr__nfet_01v8_lvt ad=0.1036 pd=1.02 as=0.1036 ps=1.02 w=0.74 l=0.15
X4427 single_9b_cdac_1.cdac_sw_9b_0.cdac_sw_3_7.tg_sw_3_3.SWN single_9b_cdac_1.cdac_sw_9b_0.cdac_sw_3_7.nooverlap_clk_0.x10.A VGND VGND sky130_fd_pr__nfet_01v8_lvt ad=0.1036 pd=1.02 as=0.1036 ps=1.02 w=0.74 l=0.15
X4428 th_dif_sw_0.VCP single_9b_cdac_1.cdac_sw_9b_0.S[0] sky130_fd_pr__cap_mim_m3_1 l=2 w=2
X4429 a_53154_16877# single_9b_cdac_1.SW[2] VDPWR VDPWR sky130_fd_pr__pfet_01v8 ad=0.435 pd=3.58 as=0.435 ps=3.58 w=1.5 l=0.5
X4430 th_dif_sw_0.VCP single_9b_cdac_1.cdac_sw_9b_0.S[0] sky130_fd_pr__cap_mim_m3_1 l=2 w=2
X4431 VDPWR a_12937_27279# uo_out[2] VDPWR sky130_fd_pr__pfet_01v8_hvt ad=0.11455 pd=1.08 as=0.2054 ps=2.1 w=0.79 l=0.15
X4432 single_9b_cdac_0.cdac_sw_9b_0.S[3] single_9b_cdac_0.cdac_sw_9b_0.cdac_sw_3_4.tg_sw_3_3.SWP single_9b_cdac_0.cdac_sw_9b_0.S[3] VDPWR sky130_fd_pr__pfet_01v8 ad=0.435 pd=3.58 as=0 ps=0 w=1.5 l=0.5
X4433 a_8892_23252# sar9b_0.net2 VGND VGND sky130_fd_pr__nfet_01v8 ad=0.066 pd=0.745 as=0.2205 ps=1.89 w=0.42 l=0.15
X4434 a_7735_21076# sar9b_0._14_ VDPWR VDPWR sky130_fd_pr__pfet_01v8_hvt ad=0.06615 pd=0.735 as=0.0567 ps=0.69 w=0.42 l=0.15
X4435 single_9b_cdac_1.cdac_sw_9b_0.S[5] single_9b_cdac_1.cdac_sw_9b_0.cdac_sw_3_5.tg_sw_3_3.SWN ua[0] VDPWR sky130_fd_pr__pfet_01v8 ad=0.435 pd=3.58 as=0.435 ps=3.58 w=1.5 l=0.5
X4436 th_dif_sw_0.VCP single_9b_cdac_1.cdac_sw_9b_0.S[0] sky130_fd_pr__cap_mim_m3_1 l=2 w=2
X4437 a_14143_25402# a_13968_25428# a_14322_25428# VGND sky130_fd_pr__nfet_01v8 ad=0.1092 pd=1.36 as=0.06405 ps=0.725 w=0.42 l=0.15
X4438 a_11567_24174# a_11121_23802# a_11471_24174# VGND sky130_fd_pr__special_nfet_01v8 ad=0.1401 pd=1.1 as=0.0594 ps=0.69 w=0.36 l=0.15
X4439 th_dif_sw_0.VCN single_9b_cdac_0.cdac_sw_9b_0.S[3] sky130_fd_pr__cap_mim_m3_1 l=2 w=2
X4440 single_9b_cdac_1.cdac_sw_9b_0.cdac_sw_3_1.nooverlap_clk_0.CLK0 single_9b_cdac_1.cdac_sw_9b_0.cdac_sw_3_1.nooverlap_clk_0.CLKB0 VGND VGND sky130_fd_pr__nfet_01v8_lvt ad=0.1036 pd=1.02 as=0.2109 ps=2.05 w=0.74 l=0.15
X4441 single_9b_cdac_0.cdac_sw_9b_0.S[1] single_9b_cdac_0.cdac_sw_9b_0.cdac_sw_3_1.tg_sw_3_3.SWN ua[0] VDPWR sky130_fd_pr__pfet_01v8 ad=0.435 pd=3.58 as=0.435 ps=3.58 w=1.5 l=0.5
X4442 a_9635_26276# sar9b_0.net3 VDPWR VDPWR sky130_fd_pr__pfet_01v8_hvt ad=0.0567 pd=0.69 as=0.0819 ps=0.81 w=0.42 l=0.15
X4443 VDPWR VGND VDPWR VDPWR sky130_fd_pr__pfet_01v8_hvt ad=0.2262 pd=2.26 as=0 ps=0 w=0.87 l=0.59
X4444 a_11567_18900# a_11121_18900# a_11471_18900# VGND sky130_fd_pr__special_nfet_01v8 ad=0.1401 pd=1.1 as=0.0594 ps=0.69 w=0.36 l=0.15
X4445 dw_12589_1395# a_10166_3438# sky130_fd_pr__cap_mim_m3_1 l=2 w=2
X4446 a_13053_26516# a_12887_26516# VDPWR VDPWR sky130_fd_pr__pfet_01v8_hvt ad=0.1664 pd=1.8 as=0.0864 ps=0.91 w=0.64 l=0.15
X4447 single_9b_cdac_0.cdac_sw_9b_0.cdac_sw_3_8.nooverlap_clk_0.CLKB0 single_9b_cdac_0.cdac_sw_9b_0.cdac_sw_3_8.nooverlap_clk_0.sky130_fd_sc_hs__inv_8_0.A VGND VGND sky130_fd_pr__nfet_01v8_lvt ad=0.1036 pd=1.02 as=0.2146 ps=2.06 w=0.74 l=0.15
X4448 VDPWR single_9b_cdac_1.cdac_sw_9b_0.cdac_sw_3_5.tg_sw_3_3.SWN single_9b_cdac_1.cdac_sw_9b_0.cdac_sw_3_5.tg_sw_3_3.SWP VDPWR sky130_fd_pr__pfet_01v8 ad=0.196 pd=1.47 as=0.168 ps=1.42 w=1.12 l=0.15
X4449 th_dif_sw_0.VCP single_9b_cdac_1.cdac_sw_9b_0.S[0] sky130_fd_pr__cap_mim_m3_1 l=2 w=2
X4450 th_dif_sw_0.VCN single_9b_cdac_0.cdac_sw_9b_0.S[0] sky130_fd_pr__cap_mim_m3_1 l=2 w=2
X4451 VDPWR VGND VDPWR VDPWR sky130_fd_pr__pfet_01v8_hvt ad=0.2262 pd=2.26 as=0 ps=0 w=0.87 l=0.59
X4452 VDPWR a_13968_23086# a_14143_23012# VDPWR sky130_fd_pr__pfet_01v8_hvt ad=0.1134 pd=1.38 as=0.0567 ps=0.69 w=0.42 l=0.15
X4453 single_9b_cdac_1.cdac_sw_9b_0.S[3] single_9b_cdac_1.cdac_sw_9b_0.cdac_sw_3_4.tg_sw_3_3.SWN single_9b_cdac_1.cdac_sw_9b_0.S[3] VGND sky130_fd_pr__nfet_01v8 ad=0.145 pd=1.58 as=0 ps=0 w=0.5 l=0.5
X4454 VGND sar9b_0.FINAL a_5435_26516# VGND sky130_fd_pr__nfet_01v8 ad=0.0567 pd=0.69 as=0.1092 ps=1.36 w=0.42 l=0.15
X4455 VGND single_9b_cdac_0.SW[1] a_58824_26990# VGND sky130_fd_pr__nfet_01v8 ad=0.145 pd=1.58 as=0.145 ps=1.58 w=0.5 l=0.5
X4456 VGND VDPWR VGND VGND sky130_fd_pr__nfet_01v8 ad=0.143 pd=1.62 as=0 ps=0 w=0.55 l=0.59
X4457 VGND single_9b_cdac_1.cdac_sw_9b_0.cdac_sw_3_6.tg_sw_3_3.SWN single_9b_cdac_1.cdac_sw_9b_0.cdac_sw_3_6.tg_sw_3_3.SWP VGND sky130_fd_pr__nfet_01v8_lvt ad=0.1554 pd=1.16 as=0.1036 ps=1.02 w=0.74 l=0.15
X4458 th_dif_sw_0.VCP single_9b_cdac_1.cdac_sw_9b_0.S[0] sky130_fd_pr__cap_mim_m3_1 l=2 w=2
X4459 th_dif_sw_0.VCP single_9b_cdac_1.cdac_sw_9b_0.S[2] sky130_fd_pr__cap_mim_m3_1 l=2 w=2
X4460 a_34814_26990# single_9b_cdac_0.cdac_sw_9b_0.cdac_sw_3_6.nooverlap_clk_0.CLK0 single_9b_cdac_0.cdac_sw_9b_0.S[6] VGND sky130_fd_pr__nfet_01v8 ad=0.145 pd=1.58 as=0.145 ps=1.58 w=0.5 l=0.5
X4461 a_13499_25262# a_13053_24890# a_13403_25262# VGND sky130_fd_pr__special_nfet_01v8 ad=0.1401 pd=1.1 as=0.0594 ps=0.69 w=0.36 l=0.15
X4462 a_48343_26999# single_9b_cdac_0.SW[3] VDPWR VDPWR sky130_fd_pr__pfet_01v8 ad=0.435 pd=3.58 as=0.435 ps=3.58 w=1.5 l=0.5
X4463 sar9b_0.net37 a_14143_18874# VDPWR VDPWR sky130_fd_pr__pfet_01v8_hvt ad=0.26 pd=2.52 as=0.3012 ps=2.66 w=1 l=0.15
X4464 single_9b_cdac_1.cdac_sw_9b_0.cdac_sw_3_5.tg_sw_3_3.SWP single_9b_cdac_1.cdac_sw_9b_0.cdac_sw_3_5.tg_sw_3_3.SWN VDPWR VDPWR sky130_fd_pr__pfet_01v8 ad=0.168 pd=1.42 as=0.168 ps=1.42 w=1.12 l=0.15
X4465 VGND single_9b_cdac_1.cdac_sw_9b_0.cdac_sw_3_4.nooverlap_clk_0.CLKB0 single_9b_cdac_1.cdac_sw_9b_0.cdac_sw_3_4.nooverlap_clk_0.CLK0 VGND sky130_fd_pr__nfet_01v8_lvt ad=0.1295 pd=1.09 as=0.1036 ps=1.02 w=0.74 l=0.15
X4466 VGND single_9b_cdac_0.SW[6] a_34814_26990# VGND sky130_fd_pr__nfet_01v8 ad=0.145 pd=1.58 as=0.145 ps=1.58 w=0.5 l=0.5
X4467 a_13216_24162# sar9b_0.net1 VGND VGND sky130_fd_pr__nfet_01v8 ad=0.066 pd=0.745 as=0.2205 ps=1.89 w=0.42 l=0.15
X4468 th_dif_sw_0.VCP single_9b_cdac_1.cdac_sw_9b_0.S[0] sky130_fd_pr__cap_mim_m3_1 l=2 w=2
X4469 a_46159_29911# single_9b_cdac_0.cdac_sw_9b_0.cdac_sw_3_3.nooverlap_clk_0.x8.A VGND VGND sky130_fd_pr__nfet_01v8_lvt ad=0.0888 pd=0.98 as=0.2109 ps=2.05 w=0.74 l=0.15
X4470 VDPWR a_9543_19748# a_9530_19444# VDPWR sky130_fd_pr__pfet_01v8_hvt ad=0.0819 pd=0.81 as=0.0567 ps=0.69 w=0.42 l=0.15
X4471 th_dif_sw_0.VCN single_9b_cdac_0.cdac_sw_9b_0.S[0] sky130_fd_pr__cap_mim_m3_1 l=2 w=2
X4472 a_21177_7457# th_dif_sw_0.CKB VDPWR VDPWR sky130_fd_pr__pfet_01v8 ad=0.168 pd=1.42 as=0.168 ps=1.42 w=1.12 l=0.15
X4473 a_11089_23252# a_11045_23494# a_10923_23252# VGND sky130_fd_pr__nfet_01v8 ad=0.0441 pd=0.63 as=0.1401 ps=1.1 w=0.42 l=0.15
X4474 VDPWR sar9b_0.net12 a_14175_23252# VDPWR sky130_fd_pr__pfet_01v8_hvt ad=0.11455 pd=1.08 as=0.2054 ps=2.1 w=0.79 l=0.15
X4475 a_10732_19810# sar9b_0.net5 VGND VGND sky130_fd_pr__nfet_01v8 ad=0.066 pd=0.745 as=0.2205 ps=1.89 w=0.42 l=0.15
X4476 VDPWR single_9b_cdac_1.cdac_sw_9b_0.cdac_sw_3_5.tg_sw_3_3.SWN single_9b_cdac_1.cdac_sw_9b_0.cdac_sw_3_5.tg_sw_3_3.SWP VDPWR sky130_fd_pr__pfet_01v8 ad=0.168 pd=1.42 as=0.168 ps=1.42 w=1.12 l=0.15
X4477 sar9b_0.clknet_0_CLK a_7345_21594# VDPWR VDPWR sky130_fd_pr__pfet_01v8_hvt ad=0.14 pd=1.28 as=0.265 ps=2.53 w=1 l=0.15
X4478 a_49926_15495# single_9b_cdac_1.cdac_sw_9b_0.cdac_sw_3_4.nooverlap_clk_0.x3.Y VGND VGND sky130_fd_pr__nfet_01v8_lvt ad=0.0888 pd=0.98 as=0.2109 ps=2.05 w=0.74 l=0.15
X4479 VGND single_9b_cdac_1.cdac_sw_9b_0.cdac_sw_3_2.nooverlap_clk_0.sky130_fd_sc_hs__inv_8_0.A single_9b_cdac_1.cdac_sw_9b_0.cdac_sw_3_2.nooverlap_clk_0.CLKB0 VGND sky130_fd_pr__nfet_01v8_lvt ad=0.1036 pd=1.02 as=0.1036 ps=1.02 w=0.74 l=0.15
X4480 a_12225_18362# a_12059_18362# VDPWR VDPWR sky130_fd_pr__pfet_01v8_hvt ad=0.1664 pd=1.8 as=0.0864 ps=0.91 w=0.64 l=0.15
X4481 single_9b_cdac_1.cdac_sw_9b_0.cdac_sw_3_3.tg_sw_3_3.SWN single_9b_cdac_1.cdac_sw_9b_0.cdac_sw_3_3.nooverlap_clk_0.x10.A VGND VGND sky130_fd_pr__nfet_01v8_lvt ad=0.1036 pd=1.02 as=0.1554 ps=1.16 w=0.74 l=0.15
X4482 VDPWR single_9b_cdac_1.cdac_sw_9b_0.cdac_sw_3_0.nooverlap_clk_0.x8.A single_9b_cdac_1.cdac_sw_9b_0.cdac_sw_3_0.nooverlap_clk_0.sky130_fd_sc_hs__nand2_1_0.Y VDPWR sky130_fd_pr__pfet_01v8 ad=0.3192 pd=2.81 as=0.168 ps=1.42 w=1.12 l=0.15
X4483 single_9b_cdac_0.cdac_sw_9b_0.S[0] single_9b_cdac_0.cdac_sw_9b_0.cdac_sw_3_2.nooverlap_clk_0.CLKB0 a_62748_26999# VDPWR sky130_fd_pr__pfet_01v8 ad=0.435 pd=3.58 as=0.435 ps=3.58 w=1.5 l=0.5
X4484 single_9b_cdac_1.cdac_sw_9b_0.cdac_sw_3_5.tg_sw_3_3.SWP single_9b_cdac_1.cdac_sw_9b_0.cdac_sw_3_5.tg_sw_3_3.SWN VDPWR VDPWR sky130_fd_pr__pfet_01v8 ad=0.168 pd=1.42 as=0.196 ps=1.47 w=1.12 l=0.15
X4485 th_dif_sw_0.VCP single_9b_cdac_1.cdac_sw_9b_0.S[2] sky130_fd_pr__cap_mim_m3_1 l=2 w=2
X4486 single_9b_cdac_1.cdac_sw_9b_0.cdac_sw_3_1.nooverlap_clk_0.x3.Y single_9b_cdac_1.CF[1] VDPWR VDPWR sky130_fd_pr__pfet_01v8 ad=0.3304 pd=2.83 as=0.3864 ps=2.93 w=1.12 l=0.15
X4487 VGND single_9b_cdac_0.cdac_sw_9b_0.cdac_sw_3_7.nooverlap_clk_0.sky130_fd_sc_hs__inv_8_0.A single_9b_cdac_0.cdac_sw_9b_0.cdac_sw_3_7.nooverlap_clk_0.CLKB0 VGND sky130_fd_pr__nfet_01v8_lvt ad=0.1036 pd=1.02 as=0.1036 ps=1.02 w=0.74 l=0.15
X4488 single_9b_cdac_0.cdac_sw_9b_0.S[2] single_9b_cdac_0.cdac_sw_9b_0.cdac_sw_3_0.tg_sw_3_3.SWN ua[0] VDPWR sky130_fd_pr__pfet_01v8 ad=0.435 pd=3.58 as=0.435 ps=3.58 w=1.5 l=0.5
X4489 VGND VDPWR VGND VGND sky130_fd_pr__nfet_01v8 ad=0.143 pd=1.62 as=0 ps=0 w=0.55 l=0.59
X4490 VDPWR single_9b_cdac_1.cdac_sw_9b_0.cdac_sw_3_1.nooverlap_clk_0.x10.A single_9b_cdac_1.cdac_sw_9b_0.cdac_sw_3_1.tg_sw_3_3.SWN VDPWR sky130_fd_pr__pfet_01v8 ad=0.3864 pd=2.93 as=0.168 ps=1.42 w=1.12 l=0.15
X4491 single_9b_cdac_0.cdac_sw_9b_0.cdac_sw_3_1.tg_sw_3_3.SWN single_9b_cdac_0.cdac_sw_9b_0.cdac_sw_3_1.nooverlap_clk_0.x10.A VGND VGND sky130_fd_pr__nfet_01v8_lvt ad=0.1036 pd=1.02 as=0.1295 ps=1.09 w=0.74 l=0.15
X4492 a_6609_23252# a_5619_23252# a_6483_23618# VGND sky130_fd_pr__special_nfet_01v8 ad=0.066 pd=0.745 as=0.0684 ps=0.74 w=0.36 l=0.15
X4493 single_9b_cdac_1.cdac_sw_9b_0.cdac_sw_3_0.nooverlap_clk_0.sky130_fd_sc_hs__nand2_1_0.Y single_9b_cdac_1.CF[2] VDPWR VDPWR sky130_fd_pr__pfet_01v8 ad=0.168 pd=1.42 as=0.3192 ps=2.81 w=1.12 l=0.15
X4494 a_6436_20354# a_5895_19988# a_6343_20354# VDPWR sky130_fd_pr__pfet_01v8_hvt ad=0.0693 pd=0.75 as=0.06615 ps=0.735 w=0.42 l=0.15
X4495 VGND VDPWR VGND VGND sky130_fd_pr__nfet_01v8 ad=0.143 pd=1.62 as=0 ps=0 w=0.55 l=0.59
X4496 a_13968_23086# a_13053_22714# a_13621_22682# VGND sky130_fd_pr__special_nfet_01v8 ad=0.0711 pd=0.755 as=0.0999 ps=0.985 w=0.36 l=0.15
X4497 a_12961_23802# a_12795_23802# VGND VGND sky130_fd_pr__nfet_01v8 ad=0.1092 pd=1.36 as=0.0567 ps=0.69 w=0.42 l=0.15
X4498 single_9b_cdac_1.cdac_sw_9b_0.cdac_sw_3_1.tg_sw_3_3.SWN single_9b_cdac_1.cdac_sw_9b_0.cdac_sw_3_1.nooverlap_clk_0.x10.A VDPWR VDPWR sky130_fd_pr__pfet_01v8 ad=0.168 pd=1.42 as=0.196 ps=1.47 w=1.12 l=0.15
X4499 a_7345_21594# clk VGND VGND sky130_fd_pr__nfet_01v8 ad=0.0588 pd=0.7 as=0.0588 ps=0.7 w=0.42 l=0.15
X4500 th_dif_sw_0.VCP single_9b_cdac_1.cdac_sw_9b_0.S[1] sky130_fd_pr__cap_mim_m3_1 l=2 w=2
X4501 single_9b_cdac_0.cdac_sw_9b_0.S[2] single_9b_cdac_0.cdac_sw_9b_0.cdac_sw_3_0.nooverlap_clk_0.CLKB0 a_53154_26999# VDPWR sky130_fd_pr__pfet_01v8 ad=0.435 pd=3.58 as=0.435 ps=3.58 w=1.5 l=0.5
X4502 th_dif_sw_0.VCN single_9b_cdac_0.cdac_sw_9b_0.S[1] sky130_fd_pr__cap_mim_m3_1 l=2 w=2
X4503 single_9b_cdac_1.cdac_sw_9b_0.cdac_sw_3_1.nooverlap_clk_0.sky130_fd_sc_hs__inv_1_1.A single_9b_cdac_1.cdac_sw_9b_0.cdac_sw_3_1.nooverlap_clk_0.sky130_fd_sc_hs__nand2_1_0.Y VGND VGND sky130_fd_pr__nfet_01v8_lvt ad=0.2109 pd=2.05 as=0.2627 ps=2.19 w=0.74 l=0.15
X4504 VGND single_9b_cdac_1.cdac_sw_9b_0.cdac_sw_3_1.tg_sw_3_3.SWN single_9b_cdac_1.cdac_sw_9b_0.cdac_sw_3_1.tg_sw_3_3.SWP VGND sky130_fd_pr__nfet_01v8_lvt ad=0.1036 pd=1.02 as=0.1036 ps=1.02 w=0.74 l=0.15
X4505 VGND sar9b_0.clknet_1_0__leaf_CLK a_8471_20538# VGND sky130_fd_pr__nfet_01v8 ad=0.0567 pd=0.69 as=0.1092 ps=1.36 w=0.42 l=0.15
X4506 VGND single_9b_cdac_0.cdac_sw_9b_0.cdac_sw_3_6.nooverlap_clk_0.sky130_fd_sc_hs__inv_8_0.A single_9b_cdac_0.cdac_sw_9b_0.cdac_sw_3_6.nooverlap_clk_0.CLKB0 VGND sky130_fd_pr__nfet_01v8_lvt ad=0.1554 pd=1.16 as=0.1036 ps=1.02 w=0.74 l=0.15
X4507 VDPWR single_9b_cdac_1.cdac_sw_9b_0.cdac_sw_3_8.nooverlap_clk_0.x10.A single_9b_cdac_1.cdac_sw_9b_0.cdac_sw_3_8.tg_sw_3_3.SWN VDPWR sky130_fd_pr__pfet_01v8 ad=0.196 pd=1.47 as=0.168 ps=1.42 w=1.12 l=0.15
X4508 sar9b_0.clk_div_0.COUNT\[0\] a_6651_23520# VDPWR VDPWR sky130_fd_pr__pfet_01v8_hvt ad=0.26 pd=2.52 as=0.135 ps=1.27 w=1 l=0.15
X4509 a_6705_22708# a_6171_22714# a_6610_22708# VDPWR sky130_fd_pr__pfet_01v8_hvt ad=0.07665 pd=0.785 as=0.06825 ps=0.745 w=0.42 l=0.15
X4510 th_dif_sw_0.VCP single_9b_cdac_1.cdac_sw_9b_0.S[0] sky130_fd_pr__cap_mim_m3_1 l=2 w=2
X4511 single_9b_cdac_1.cdac_sw_9b_0.cdac_sw_3_2.nooverlap_clk_0.x6.A single_9b_cdac_1.cdac_sw_9b_0.cdac_sw_3_2.nooverlap_clk_0.x4.A VDPWR VDPWR sky130_fd_pr__pfet_01v8 ad=0.3304 pd=2.83 as=0.3864 ps=2.93 w=1.12 l=0.15
X4512 th_dif_sw_0.VCP single_9b_cdac_1.cdac_sw_9b_0.S[1] sky130_fd_pr__cap_mim_m3_1 l=2 w=2
X4513 VDPWR VGND VDPWR VDPWR sky130_fd_pr__pfet_01v8_hvt ad=0.2262 pd=2.26 as=0 ps=0 w=0.87 l=0.59
X4514 single_9b_cdac_1.cdac_sw_9b_0.cdac_sw_3_8.tg_sw_3_3.SWN single_9b_cdac_1.cdac_sw_9b_0.cdac_sw_3_8.nooverlap_clk_0.x10.A VDPWR VDPWR sky130_fd_pr__pfet_01v8 ad=0.168 pd=1.42 as=0.168 ps=1.42 w=1.12 l=0.15
X4515 th_dif_sw_0.VCP single_9b_cdac_1.cdac_sw_9b_0.S[0] sky130_fd_pr__cap_mim_m3_1 l=2 w=2
X4516 a_11376_26516# sar9b_0.net42 VDPWR VDPWR sky130_fd_pr__pfet_01v8_hvt ad=0.0651 pd=0.73 as=0.1092 ps=1.36 w=0.42 l=0.15
X4517 a_63626_26990# single_9b_cdac_0.cdac_sw_9b_0.cdac_sw_3_2.nooverlap_clk_0.CLK0 single_9b_cdac_0.cdac_sw_9b_0.S[0] VGND sky130_fd_pr__nfet_01v8 ad=0.145 pd=1.58 as=0.145 ps=1.58 w=0.5 l=0.5
X4518 VGND single_9b_cdac_0.SW[0] a_63626_26990# VGND sky130_fd_pr__nfet_01v8 ad=0.145 pd=1.58 as=0.145 ps=1.58 w=0.5 l=0.5
X4519 a_9205_23494# a_8987_23252# VGND VGND sky130_fd_pr__nfet_01v8 ad=0.0999 pd=0.985 as=0.1346 ps=1.15 w=0.64 l=0.15
X4520 a_12474_20532# a_11397_20538# a_12312_20910# VDPWR sky130_fd_pr__pfet_01v8_hvt ad=0.0567 pd=0.69 as=0.0588 ps=0.7 w=0.42 l=0.15
X4521 single_9b_cdac_1.cdac_sw_9b_0.cdac_sw_3_6.nooverlap_clk_0.sky130_fd_sc_hs__inv_8_0.A single_9b_cdac_1.cdac_sw_9b_0.cdac_sw_3_6.nooverlap_clk_0.x1.A VGND VGND sky130_fd_pr__nfet_01v8_lvt ad=0.1184 pd=1.06 as=0.2331 ps=2.11 w=0.74 l=0.15
X4522 a_7059_25402# a_6884_25428# a_7238_25428# VGND sky130_fd_pr__nfet_01v8 ad=0.1092 pd=1.36 as=0.06405 ps=0.725 w=0.42 l=0.15
X4523 a_6070_19721# a_5870_19566# a_6219_19810# VGND sky130_fd_pr__special_nfet_01v8 ad=0.0621 pd=0.705 as=0.0696 ps=0.765 w=0.36 l=0.15
X4524 VGND single_9b_cdac_1.cdac_sw_9b_0.cdac_sw_3_8.tg_sw_3_3.SWN single_9b_cdac_1.cdac_sw_9b_0.cdac_sw_3_8.tg_sw_3_3.SWP VGND sky130_fd_pr__nfet_01v8_lvt ad=0.2146 pd=2.06 as=0.1036 ps=1.02 w=0.74 l=0.15
X4525 VGND single_9b_cdac_1.cdac_sw_9b_0.cdac_sw_3_6.nooverlap_clk_0.sky130_fd_sc_hs__inv_8_0.A single_9b_cdac_1.cdac_sw_9b_0.cdac_sw_3_6.nooverlap_clk_0.CLKB0 VGND sky130_fd_pr__nfet_01v8_lvt ad=0.1295 pd=1.09 as=0.1036 ps=1.02 w=0.74 l=0.15
X4526 th_dif_sw_0.VCN single_9b_cdac_0.cdac_sw_9b_0.S[0] sky130_fd_pr__cap_mim_m3_1 l=2 w=2
X4527 th_dif_sw_0.VCN single_9b_cdac_0.cdac_sw_9b_0.S[0] sky130_fd_pr__cap_mim_m3_1 l=2 w=2
X4528 th_dif_sw_0.VCN single_9b_cdac_0.cdac_sw_9b_0.S[1] sky130_fd_pr__cap_mim_m3_1 l=2 w=2
X4529 a_58824_17740# single_9b_cdac_1.cdac_sw_9b_0.cdac_sw_3_1.nooverlap_clk_0.CLK0 single_9b_cdac_1.cdac_sw_9b_0.S[1] VGND sky130_fd_pr__nfet_01v8 ad=0.145 pd=1.58 as=0.145 ps=1.58 w=0.5 l=0.5
X4530 VGND VDPWR VGND VGND sky130_fd_pr__nfet_01v8 ad=0.143 pd=1.62 as=0 ps=0 w=0.55 l=0.59
X4531 VDPWR single_9b_cdac_1.cdac_sw_9b_0.cdac_sw_3_8.nooverlap_clk_0.x10.A single_9b_cdac_1.cdac_sw_9b_0.cdac_sw_3_8.tg_sw_3_3.SWN VDPWR sky130_fd_pr__pfet_01v8 ad=0.168 pd=1.42 as=0.168 ps=1.42 w=1.12 l=0.15
X4532 a_34814_17740# single_9b_cdac_1.cdac_sw_9b_0.cdac_sw_3_6.nooverlap_clk_0.CLK0 single_9b_cdac_1.cdac_sw_9b_0.S[6] VGND sky130_fd_pr__nfet_01v8 ad=0.145 pd=1.58 as=0.145 ps=1.58 w=0.5 l=0.5
X4533 VDPWR a_5343_25972# sar9b_0.net3 VDPWR sky130_fd_pr__pfet_01v8_hvt ad=0.3 pd=2.6 as=0.14 ps=1.28 w=1 l=0.15
X4534 single_9b_cdac_1.cdac_sw_9b_0.cdac_sw_3_8.tg_sw_3_3.SWN single_9b_cdac_1.cdac_sw_9b_0.cdac_sw_3_8.nooverlap_clk_0.x10.A VDPWR VDPWR sky130_fd_pr__pfet_01v8 ad=0.168 pd=1.42 as=0.196 ps=1.47 w=1.12 l=0.15
X4535 th_dif_sw_0.VCP single_9b_cdac_1.cdac_sw_9b_0.S[1] sky130_fd_pr__cap_mim_m3_1 l=2 w=2
X4536 a_10305_21076# a_9115_21076# a_10196_21076# VGND sky130_fd_pr__special_nfet_01v8 ad=0.0669 pd=0.75 as=0.0711 ps=0.755 w=0.36 l=0.15
X4537 th_dif_sw_0.VCN single_9b_cdac_0.cdac_sw_9b_0.S[1] sky130_fd_pr__cap_mim_m3_1 l=2 w=2
X4538 single_9b_cdac_0.cdac_sw_9b_0.S[5] single_9b_cdac_0.cdac_sw_9b_0.cdac_sw_3_5.tg_sw_3_3.SWN single_9b_cdac_0.cdac_sw_9b_0.S[5] VGND sky130_fd_pr__nfet_01v8 ad=0.145 pd=1.58 as=2.32 ps=25.28 w=0.5 l=0.5
X4539 single_9b_cdac_0.cdac_sw_9b_0.cdac_sw_3_5.nooverlap_clk_0.CLKB0 single_9b_cdac_0.cdac_sw_9b_0.cdac_sw_3_5.nooverlap_clk_0.sky130_fd_sc_hs__inv_8_0.A VGND VGND sky130_fd_pr__nfet_01v8_lvt ad=0.1036 pd=1.02 as=0.1036 ps=1.02 w=0.74 l=0.15
X4540 VDPWR single_9b_cdac_0.cdac_sw_9b_0.cdac_sw_3_2.nooverlap_clk_0.sky130_fd_sc_hs__inv_8_0.A single_9b_cdac_0.cdac_sw_9b_0.cdac_sw_3_2.nooverlap_clk_0.CLKB0 VDPWR sky130_fd_pr__pfet_01v8 ad=0.196 pd=1.47 as=0.168 ps=1.42 w=1.12 l=0.15
X4541 th_dif_sw_0.VCN single_9b_cdac_0.cdac_sw_9b_0.S[0] sky130_fd_pr__cap_mim_m3_1 l=2 w=2
X4542 single_9b_cdac_1.cdac_sw_9b_0.cdac_sw_3_2.tg_sw_3_3.SWP single_9b_cdac_1.cdac_sw_9b_0.cdac_sw_3_2.tg_sw_3_3.SWN VGND VGND sky130_fd_pr__nfet_01v8_lvt ad=0.1036 pd=1.02 as=0.2109 ps=2.05 w=0.74 l=0.15
X4543 VGND single_9b_cdac_0.cdac_sw_9b_0.cdac_sw_3_8.nooverlap_clk_0.x4.A single_9b_cdac_0.cdac_sw_9b_0.cdac_sw_3_8.nooverlap_clk_0.x6.A VGND sky130_fd_pr__nfet_01v8_lvt ad=0.2627 pd=2.19 as=0.2109 ps=2.05 w=0.74 l=0.15
X4544 single_9b_cdac_0.cdac_sw_9b_0.cdac_sw_3_1.nooverlap_clk_0.sky130_fd_sc_hs__inv_8_0.A single_9b_cdac_0.cdac_sw_9b_0.cdac_sw_3_1.nooverlap_clk_0.x1.A VGND VGND sky130_fd_pr__nfet_01v8_lvt ad=0.1036 pd=1.02 as=0.2109 ps=2.05 w=0.74 l=0.15
X4545 a_12114_25428# sar9b_0.net15 VGND VGND sky130_fd_pr__nfet_01v8 ad=0.06405 pd=0.725 as=0.12495 ps=1.015 w=0.42 l=0.15
X4546 th_dif_sw_0.VCN single_9b_cdac_0.cdac_sw_9b_0.S[0] sky130_fd_pr__cap_mim_m3_1 l=2 w=2
X4547 a_12206_22164# sar9b_0.net15 VGND VGND sky130_fd_pr__nfet_01v8 ad=0.06405 pd=0.725 as=0.12495 ps=1.015 w=0.42 l=0.15
X4548 VGND VDPWR VGND VGND sky130_fd_pr__nfet_01v8 ad=0.143 pd=1.62 as=0 ps=0 w=0.55 l=0.59
X4549 ua[0] single_9b_cdac_0.cdac_sw_9b_0.cdac_sw_3_7.tg_sw_3_3.SWP ua[0] VDPWR sky130_fd_pr__pfet_01v8 ad=0.435 pd=3.58 as=0 ps=0 w=1.5 l=0.5
X4550 single_9b_cdac_0.cdac_sw_9b_0.S[2] single_9b_cdac_0.cdac_sw_9b_0.cdac_sw_3_0.tg_sw_3_3.SWN single_9b_cdac_0.cdac_sw_9b_0.S[2] VGND sky130_fd_pr__nfet_01v8 ad=0.145 pd=1.58 as=0 ps=0 w=0.5 l=0.5
X4551 a_13308_18900# sar9b_0.net2 VDPWR VDPWR sky130_fd_pr__pfet_01v8_hvt ad=0.0651 pd=0.73 as=0.1092 ps=1.36 w=0.42 l=0.15
X4552 single_9b_cdac_1.cdac_sw_9b_0.cdac_sw_3_0.tg_sw_3_3.SWP single_9b_cdac_1.cdac_sw_9b_0.cdac_sw_3_0.tg_sw_3_3.SWN VGND VGND sky130_fd_pr__nfet_01v8_lvt ad=0.1036 pd=1.02 as=0.1295 ps=1.09 w=0.74 l=0.15
X4553 th_dif_sw_0.VCP single_9b_cdac_1.cdac_sw_9b_0.S[0] sky130_fd_pr__cap_mim_m3_1 l=2 w=2
X4554 single_9b_cdac_0.cdac_sw_9b_0.cdac_sw_3_2.nooverlap_clk_0.CLKB0 single_9b_cdac_0.cdac_sw_9b_0.cdac_sw_3_2.nooverlap_clk_0.sky130_fd_sc_hs__inv_8_0.A VDPWR VDPWR sky130_fd_pr__pfet_01v8 ad=0.168 pd=1.42 as=0.168 ps=1.42 w=1.12 l=0.15
X4555 VGND VDPWR VGND VGND sky130_fd_pr__nfet_01v8 ad=0.143 pd=1.62 as=0 ps=0 w=0.55 l=0.59
X4556 th_dif_sw_0.VCP single_9b_cdac_1.cdac_sw_9b_0.S[1] sky130_fd_pr__cap_mim_m3_1 l=2 w=2
X4557 single_9b_cdac_1.cdac_sw_9b_0.cdac_sw_3_8.nooverlap_clk_0.x8.A single_9b_cdac_1.cdac_sw_9b_0.cdac_sw_3_8.nooverlap_clk_0.x6.A VGND VGND sky130_fd_pr__nfet_01v8_lvt ad=0.2109 pd=2.05 as=0.2627 ps=2.19 w=0.74 l=0.15
X4558 th_dif_sw_0.VCN single_9b_cdac_0.cdac_sw_9b_0.S[1] sky130_fd_pr__cap_mim_m3_1 l=2 w=2
X4559 VGND VDPWR VGND VGND sky130_fd_pr__nfet_01v8 ad=0.143 pd=1.62 as=0 ps=0 w=0.55 l=0.59
X4560 VGND VDPWR VGND VGND sky130_fd_pr__nfet_01v8 ad=0.143 pd=1.62 as=0 ps=0 w=0.55 l=0.59
X4561 dw_17224_1400# a_21368_4076# sky130_fd_pr__cap_mim_m3_1 l=2 w=2
X4562 VGND single_9b_cdac_0.cdac_sw_9b_0.cdac_sw_3_2.nooverlap_clk_0.CLKB0 single_9b_cdac_0.cdac_sw_9b_0.cdac_sw_3_2.nooverlap_clk_0.CLK0 VGND sky130_fd_pr__nfet_01v8_lvt ad=0.1295 pd=1.09 as=0.1036 ps=1.02 w=0.74 l=0.15
X4563 VGND VDPWR VGND VGND sky130_fd_pr__nfet_01v8 ad=0.143 pd=1.62 as=0 ps=0 w=0.55 l=0.59
X4564 VDPWR sar9b_0.net2 a_10774_20354# VDPWR sky130_fd_pr__pfet_01v8_hvt ad=0.1092 pd=1.36 as=0.0651 ps=0.73 w=0.42 l=0.15
X4565 VDPWR VGND VDPWR VDPWR sky130_fd_pr__pfet_01v8_hvt ad=0.2262 pd=2.26 as=0 ps=0 w=0.87 l=0.59
X4566 VDPWR a_9843_19137# a_9774_19266# VDPWR sky130_fd_pr__pfet_01v8_hvt ad=0.2184 pd=2.2 as=0.12915 ps=1.185 w=0.84 l=0.15
X4567 VDPWR single_9b_cdac_0.cdac_sw_9b_0.cdac_sw_3_2.nooverlap_clk_0.sky130_fd_sc_hs__inv_8_0.A single_9b_cdac_0.cdac_sw_9b_0.cdac_sw_3_2.nooverlap_clk_0.CLKB0 VDPWR sky130_fd_pr__pfet_01v8 ad=0.168 pd=1.42 as=0.168 ps=1.42 w=1.12 l=0.15
X4568 VGND VDPWR VGND VGND sky130_fd_pr__nfet_01v8 ad=0.143 pd=1.62 as=0 ps=0 w=0.55 l=0.59
X4569 a_9447_22164# a_9097_22164# a_9352_22164# VDPWR sky130_fd_pr__pfet_01v8_hvt ad=0.07245 pd=0.765 as=0.0651 ps=0.73 w=0.42 l=0.15
X4570 VDPWR sar9b_0.net8 a_14175_21620# VDPWR sky130_fd_pr__pfet_01v8_hvt ad=0.11455 pd=1.08 as=0.2054 ps=2.1 w=0.79 l=0.15
X4571 single_9b_cdac_1.cdac_sw_9b_0.cdac_sw_3_5.nooverlap_clk_0.x8.A single_9b_cdac_1.cdac_sw_9b_0.cdac_sw_3_5.nooverlap_clk_0.x6.A VDPWR VDPWR sky130_fd_pr__pfet_01v8 ad=0.3304 pd=2.83 as=0.3864 ps=2.93 w=1.12 l=0.15
X4572 th_dif_sw_0.VCP single_9b_cdac_1.cdac_sw_9b_0.S[1] sky130_fd_pr__cap_mim_m3_1 l=2 w=2
X4573 VDPWR a_6778_22682# a_6705_22708# VDPWR sky130_fd_pr__pfet_01v8_hvt ad=0.17887 pd=1.26 as=0.07665 ps=0.785 w=0.42 l=0.15
X4574 VDPWR a_11392_19822# a_11567_19748# VDPWR sky130_fd_pr__pfet_01v8_hvt ad=0.1134 pd=1.38 as=0.0567 ps=0.69 w=0.42 l=0.15
X4575 a_53154_16877# single_9b_cdac_1.SW[2] VDPWR VDPWR sky130_fd_pr__pfet_01v8 ad=0.435 pd=3.58 as=0.435 ps=3.58 w=1.5 l=0.5
X4576 th_dif_sw_0.VCN single_9b_cdac_0.cdac_sw_9b_0.S[1] sky130_fd_pr__cap_mim_m3_1 l=2 w=2
X4577 th_dif_sw_0.VCP single_9b_cdac_1.cdac_sw_9b_0.S[0] sky130_fd_pr__cap_mim_m3_1 l=2 w=2
X4578 single_9b_cdac_0.cdac_sw_9b_0.cdac_sw_3_3.nooverlap_clk_0.CLK0 single_9b_cdac_0.cdac_sw_9b_0.cdac_sw_3_3.nooverlap_clk_0.CLKB0 VDPWR VDPWR sky130_fd_pr__pfet_01v8 ad=0.168 pd=1.42 as=0.196 ps=1.47 w=1.12 l=0.15
X4579 single_9b_cdac_0.cdac_sw_9b_0.S[3] single_9b_cdac_0.cdac_sw_9b_0.cdac_sw_3_4.tg_sw_3_3.SWP single_9b_cdac_0.cdac_sw_9b_0.S[3] VDPWR sky130_fd_pr__pfet_01v8 ad=0.435 pd=3.58 as=0 ps=0 w=1.5 l=0.5
X4580 a_7620_26350# a_6539_25978# a_7273_25946# VDPWR sky130_fd_pr__pfet_01v8_hvt ad=0.0588 pd=0.7 as=0.12915 ps=1.185 w=0.42 l=0.15
X4581 a_9252_22708# a_9038_22708# VDPWR VDPWR sky130_fd_pr__pfet_01v8_hvt ad=0.1155 pd=0.97 as=0.07035 ps=0.755 w=0.42 l=0.15
X4582 a_13308_21076# sar9b_0.net1 VGND VGND sky130_fd_pr__nfet_01v8 ad=0.066 pd=0.745 as=0.2205 ps=1.89 w=0.42 l=0.15
X4583 single_9b_cdac_0.cdac_sw_9b_0.cdac_sw_3_4.nooverlap_clk_0.sky130_fd_sc_hs__inv_8_0.A single_9b_cdac_0.cdac_sw_9b_0.cdac_sw_3_4.nooverlap_clk_0.x1.A VGND VGND sky130_fd_pr__nfet_01v8_lvt ad=0.1184 pd=1.06 as=0.1221 ps=1.07 w=0.74 l=0.15
X4584 a_12480_18722# sar9b_0.net2 VDPWR VDPWR sky130_fd_pr__pfet_01v8_hvt ad=0.0651 pd=0.73 as=0.1092 ps=1.36 w=0.42 l=0.15
X4585 VGND single_9b_cdac_0.cdac_sw_9b_0.cdac_sw_3_0.nooverlap_clk_0.CLKB0 single_9b_cdac_0.cdac_sw_9b_0.cdac_sw_3_0.nooverlap_clk_0.CLK0 VGND sky130_fd_pr__nfet_01v8_lvt ad=0.1554 pd=1.16 as=0.1036 ps=1.02 w=0.74 l=0.15
X4586 VDPWR VGND VDPWR VDPWR sky130_fd_pr__pfet_01v8_hvt ad=0.2262 pd=2.26 as=0 ps=0 w=0.87 l=0.59
X4587 VGND a_6930_20241# sar9b_0.net15 VGND sky130_fd_pr__nfet_01v8 ad=0.18525 pd=1.87 as=0.08775 ps=0.92 w=0.65 l=0.15
X4588 th_dif_sw_0.VCN single_9b_cdac_0.cdac_sw_9b_0.S[0] sky130_fd_pr__cap_mim_m3_1 l=2 w=2
X4589 VGND a_7203_22682# a_7161_23086# VGND sky130_fd_pr__nfet_01v8 ad=0.1092 pd=1.36 as=0.066 ps=0.745 w=0.42 l=0.15
X4590 sar9b_0.clknet_1_1__leaf_CLK a_6149_23770# VDPWR VDPWR sky130_fd_pr__pfet_01v8_hvt ad=0.14 pd=1.28 as=0.1375 ps=1.275 w=1 l=0.15
X4591 VDPWR VGND VDPWR VDPWR sky130_fd_pr__pfet_01v8_hvt ad=0.2262 pd=2.26 as=0 ps=0 w=0.87 l=0.59
X4592 VGND a_12027_22138# a_11961_22164# VGND sky130_fd_pr__nfet_01v8 ad=0.12495 pd=1.015 as=0.0669 ps=0.75 w=0.42 l=0.15
X4593 VDPWR a_7059_21228# sar9b_0._09_ VDPWR sky130_fd_pr__pfet_01v8_hvt ad=0.16655 pd=1.39 as=0.475 ps=2.95 w=1 l=0.15
X4594 VDPWR single_9b_cdac_0.cdac_sw_9b_0.cdac_sw_3_4.nooverlap_clk_0.x10.A single_9b_cdac_0.cdac_sw_9b_0.cdac_sw_3_4.tg_sw_3_3.SWN VDPWR sky130_fd_pr__pfet_01v8 ad=0.3304 pd=2.83 as=0.168 ps=1.42 w=1.12 l=0.15
X4595 single_9b_cdac_0.cdac_sw_9b_0.S[3] single_9b_cdac_0.cdac_sw_9b_0.cdac_sw_3_4.tg_sw_3_3.SWN single_9b_cdac_0.cdac_sw_9b_0.S[3] VGND sky130_fd_pr__nfet_01v8 ad=0.145 pd=1.58 as=0 ps=0 w=0.5 l=0.5
X4596 VGND sar9b_0.net3 a_9157_26338# VGND sky130_fd_pr__nfet_01v8 ad=0.1346 pd=1.15 as=0.0441 ps=0.63 w=0.42 l=0.15
X4597 single_9b_cdac_1.cdac_sw_9b_0.cdac_sw_3_7.nooverlap_clk_0.CLK0 single_9b_cdac_1.cdac_sw_9b_0.cdac_sw_3_7.nooverlap_clk_0.CLKB0 VGND VGND sky130_fd_pr__nfet_01v8_lvt ad=0.1036 pd=1.02 as=0.2109 ps=2.05 w=0.74 l=0.15
X4598 th_dif_sw_0.VCN single_9b_cdac_0.cdac_sw_9b_0.S[0] sky130_fd_pr__cap_mim_m3_1 l=2 w=2
X4599 th_dif_sw_0.VCN single_9b_cdac_0.cdac_sw_9b_0.S[6] sky130_fd_pr__cap_mim_m3_1 l=2 w=2
X4600 single_9b_cdac_0.cdac_sw_9b_0.cdac_sw_3_4.tg_sw_3_3.SWN single_9b_cdac_0.cdac_sw_9b_0.cdac_sw_3_4.nooverlap_clk_0.x10.A VDPWR VDPWR sky130_fd_pr__pfet_01v8 ad=0.168 pd=1.42 as=0.196 ps=1.47 w=1.12 l=0.15
X4601 VDPWR single_9b_cdac_0.cdac_sw_9b_0.cdac_sw_3_4.nooverlap_clk_0.sky130_fd_sc_hs__inv_8_0.A single_9b_cdac_0.cdac_sw_9b_0.cdac_sw_3_4.nooverlap_clk_0.CLKB0 VDPWR sky130_fd_pr__pfet_01v8 ad=0.196 pd=1.47 as=0.168 ps=1.42 w=1.12 l=0.15
X4602 a_13968_21076# a_12887_21076# a_13621_21318# VDPWR sky130_fd_pr__pfet_01v8_hvt ad=0.0588 pd=0.7 as=0.12915 ps=1.185 w=0.42 l=0.15
X4603 VGND single_9b_cdac_1.cdac_sw_9b_0.cdac_sw_3_0.nooverlap_clk_0.x1.A single_9b_cdac_1.cdac_sw_9b_0.cdac_sw_3_0.nooverlap_clk_0.sky130_fd_sc_hs__inv_8_0.A VGND sky130_fd_pr__nfet_01v8_lvt ad=0.1221 pd=1.07 as=0.1184 ps=1.06 w=0.74 l=0.15
X4604 VGND single_9b_cdac_0.cdac_sw_9b_0.cdac_sw_3_1.nooverlap_clk_0.x8.A single_9b_cdac_0.cdac_sw_9b_0.cdac_sw_3_1.nooverlap_clk_0.x10.A VGND sky130_fd_pr__nfet_01v8_lvt ad=0.1221 pd=1.07 as=0.1036 ps=1.02 w=0.74 l=0.15
X4605 a_8909_24174# a_7919_23802# a_8783_23796# VGND sky130_fd_pr__special_nfet_01v8 ad=0.066 pd=0.745 as=0.0684 ps=0.74 w=0.36 l=0.15
X4606 single_9b_cdac_1.cdac_sw_9b_0.cdac_sw_3_2.nooverlap_clk_0.x6.A single_9b_cdac_1.cdac_sw_9b_0.cdac_sw_3_2.nooverlap_clk_0.x4.A VGND VGND sky130_fd_pr__nfet_01v8_lvt ad=0.2109 pd=2.05 as=0.2627 ps=2.19 w=0.74 l=0.15
X4607 single_9b_cdac_0.cdac_sw_9b_0.S[4] single_9b_cdac_0.cdac_sw_9b_0.cdac_sw_3_3.tg_sw_3_3.SWN single_9b_cdac_0.cdac_sw_9b_0.S[4] VGND sky130_fd_pr__nfet_01v8 ad=0.145 pd=1.58 as=2.32 ps=25.28 w=0.5 l=0.5
X4608 single_9b_cdac_0.cdac_sw_9b_0.S[1] single_9b_cdac_0.cdac_sw_9b_0.cdac_sw_3_1.tg_sw_3_3.SWP ua[0] VGND sky130_fd_pr__nfet_01v8 ad=0.145 pd=1.58 as=0.145 ps=1.58 w=0.5 l=0.5
X4609 VGND single_9b_cdac_0.cdac_sw_9b_0.cdac_sw_3_8.tg_sw_3_3.SWN single_9b_cdac_0.cdac_sw_9b_0.cdac_sw_3_8.tg_sw_3_3.SWP VGND sky130_fd_pr__nfet_01v8_lvt ad=0.2109 pd=2.05 as=0.1036 ps=1.02 w=0.74 l=0.15
X4610 VDPWR VGND VDPWR VDPWR sky130_fd_pr__pfet_01v8_hvt ad=0.2262 pd=2.26 as=0 ps=0 w=0.87 l=0.59
X4611 a_9335_20532# a_8637_20538# a_9078_20506# VGND sky130_fd_pr__special_nfet_01v8 ad=0.0684 pd=0.74 as=0.0989 ps=0.995 w=0.36 l=0.15
X4612 sar9b_0.net36 a_13315_18660# VGND VGND sky130_fd_pr__nfet_01v8 ad=0.169 pd=1.82 as=0.2087 ps=2.02 w=0.65 l=0.15
X4613 th_dif_sw_0.VCN single_9b_cdac_0.cdac_sw_9b_0.S[1] sky130_fd_pr__cap_mim_m3_1 l=2 w=2
X4614 tdc_0.phase_detector_0.INN a_16527_10454# VDPWR VDPWR sky130_fd_pr__pfet_01v8 ad=0.3304 pd=2.83 as=0.1988 ps=1.505 w=1.12 l=0.15
X4615 single_9b_cdac_0.cdac_sw_9b_0.cdac_sw_3_4.nooverlap_clk_0.CLKB0 single_9b_cdac_0.cdac_sw_9b_0.cdac_sw_3_4.nooverlap_clk_0.sky130_fd_sc_hs__inv_8_0.A VDPWR VDPWR sky130_fd_pr__pfet_01v8 ad=0.168 pd=1.42 as=0.3864 ps=2.93 w=1.12 l=0.15
X4616 single_9b_cdac_1.cdac_sw_9b_0.cdac_sw_3_7.nooverlap_clk_0.x10.A single_9b_cdac_1.cdac_sw_9b_0.cdac_sw_3_7.nooverlap_clk_0.x8.A VGND VGND sky130_fd_pr__nfet_01v8_lvt ad=0.1036 pd=1.02 as=0.1221 ps=1.07 w=0.74 l=0.15
X4617 th_dif_sw_0.VCN single_9b_cdac_0.cdac_sw_9b_0.S[0] sky130_fd_pr__cap_mim_m3_1 l=2 w=2
X4618 VDPWR VGND VDPWR VDPWR sky130_fd_pr__pfet_01v8_hvt ad=0.2262 pd=2.26 as=0 ps=0 w=0.87 l=0.59
X4619 VGND VDPWR VGND VGND sky130_fd_pr__nfet_01v8 ad=0.143 pd=1.62 as=0 ps=0 w=0.55 l=0.59
X4620 th_dif_sw_0.VCP single_9b_cdac_1.cdac_sw_9b_0.S[0] sky130_fd_pr__cap_mim_m3_1 l=2 w=2
X4621 single_9b_cdac_0.cdac_sw_9b_0.cdac_sw_3_7.tg_sw_3_3.SWP single_9b_cdac_0.cdac_sw_9b_0.cdac_sw_3_7.tg_sw_3_3.SWN VGND VGND sky130_fd_pr__nfet_01v8_lvt ad=0.1036 pd=1.02 as=0.1554 ps=1.16 w=0.74 l=0.15
X4622 VGND VDPWR VGND VGND sky130_fd_pr__nfet_01v8 ad=0.143 pd=1.62 as=0 ps=0 w=0.55 l=0.59
X4623 single_9b_cdac_1.cdac_sw_9b_0.cdac_sw_3_7.tg_sw_3_3.SWN single_9b_cdac_1.cdac_sw_9b_0.cdac_sw_3_7.nooverlap_clk_0.x10.A VGND VGND sky130_fd_pr__nfet_01v8_lvt ad=0.1036 pd=1.02 as=0.1295 ps=1.09 w=0.74 l=0.15
X4624 VGND single_9b_cdac_1.cdac_sw_9b_0.cdac_sw_3_6.nooverlap_clk_0.sky130_fd_sc_hs__inv_8_0.A single_9b_cdac_1.cdac_sw_9b_0.cdac_sw_3_6.nooverlap_clk_0.CLKB0 VGND sky130_fd_pr__nfet_01v8_lvt ad=0.1036 pd=1.02 as=0.1036 ps=1.02 w=0.74 l=0.15
X4625 single_9b_cdac_1.cdac_sw_9b_0.cdac_sw_3_0.nooverlap_clk_0.CLKB0 single_9b_cdac_1.cdac_sw_9b_0.cdac_sw_3_0.nooverlap_clk_0.sky130_fd_sc_hs__inv_8_0.A VGND VGND sky130_fd_pr__nfet_01v8_lvt ad=0.1036 pd=1.02 as=0.1036 ps=1.02 w=0.74 l=0.15
X4626 th_dif_sw_0.VCP single_9b_cdac_1.cdac_sw_9b_0.S[1] sky130_fd_pr__cap_mim_m3_1 l=2 w=2
X4627 VDPWR single_9b_cdac_0.cdac_sw_9b_0.cdac_sw_3_7.nooverlap_clk_0.x10.A single_9b_cdac_0.cdac_sw_9b_0.cdac_sw_3_7.tg_sw_3_3.SWN VDPWR sky130_fd_pr__pfet_01v8 ad=0.196 pd=1.47 as=0.168 ps=1.42 w=1.12 l=0.15
X4628 single_9b_cdac_0.cdac_sw_9b_0.S[6] single_9b_cdac_0.cdac_sw_9b_0.cdac_sw_3_6.nooverlap_clk_0.CLKB0 a_33936_26999# VDPWR sky130_fd_pr__pfet_01v8 ad=0.435 pd=3.58 as=0.435 ps=3.58 w=1.5 l=0.5
X4629 VDPWR a_9132_7271# th_dif_sw_0.th_sw_1.CK VDPWR sky130_fd_pr__pfet_01v8 ad=0.168 pd=1.42 as=0.168 ps=1.42 w=1.12 l=0.15
X4630 single_9b_cdac_1.cdac_sw_9b_0.cdac_sw_3_1.nooverlap_clk_0.CLK0 single_9b_cdac_1.cdac_sw_9b_0.cdac_sw_3_1.nooverlap_clk_0.CLKB0 VGND VGND sky130_fd_pr__nfet_01v8_lvt ad=0.1036 pd=1.02 as=0.1036 ps=1.02 w=0.74 l=0.15
X4631 VGND a_8951_23770# a_8909_24174# VGND sky130_fd_pr__nfet_01v8 ad=0.1092 pd=1.36 as=0.066 ps=0.745 w=0.42 l=0.15
X4632 VDPWR VGND VDPWR VDPWR sky130_fd_pr__pfet_01v8_hvt ad=0.2262 pd=2.26 as=0 ps=0 w=0.87 l=0.59
X4633 VGND single_9b_cdac_1.cdac_sw_9b_0.cdac_sw_3_5.tg_sw_3_3.SWN single_9b_cdac_1.cdac_sw_9b_0.cdac_sw_3_5.tg_sw_3_3.SWP VGND sky130_fd_pr__nfet_01v8_lvt ad=0.2146 pd=2.06 as=0.1036 ps=1.02 w=0.74 l=0.15
X4634 single_9b_cdac_1.cdac_sw_9b_0.S[2] single_9b_cdac_1.cdac_sw_9b_0.cdac_sw_3_0.tg_sw_3_3.SWN single_9b_cdac_1.cdac_sw_9b_0.S[2] VGND sky130_fd_pr__nfet_01v8 ad=0.145 pd=1.58 as=0 ps=0 w=0.5 l=0.5
X4635 single_9b_cdac_0.cdac_sw_9b_0.S[2] single_9b_cdac_0.cdac_sw_9b_0.cdac_sw_3_0.nooverlap_clk_0.CLKB0 a_53154_26999# VDPWR sky130_fd_pr__pfet_01v8 ad=0.435 pd=3.58 as=0.435 ps=3.58 w=1.5 l=0.5
X4636 single_9b_cdac_0.cdac_sw_9b_0.cdac_sw_3_7.tg_sw_3_3.SWN single_9b_cdac_0.cdac_sw_9b_0.cdac_sw_3_7.nooverlap_clk_0.x10.A VDPWR VDPWR sky130_fd_pr__pfet_01v8 ad=0.168 pd=1.42 as=0.168 ps=1.42 w=1.12 l=0.15
X4637 single_9b_cdac_0.cdac_sw_9b_0.cdac_sw_3_5.nooverlap_clk_0.CLKB0 single_9b_cdac_0.cdac_sw_9b_0.cdac_sw_3_5.nooverlap_clk_0.sky130_fd_sc_hs__inv_8_0.A VGND VGND sky130_fd_pr__nfet_01v8_lvt ad=0.1036 pd=1.02 as=0.1295 ps=1.09 w=0.74 l=0.15
X4638 a_13403_26516# a_13053_26516# a_13308_26516# VDPWR sky130_fd_pr__pfet_01v8_hvt ad=0.07245 pd=0.765 as=0.0651 ps=0.73 w=0.42 l=0.15
X4639 single_9b_cdac_0.cdac_sw_9b_0.cdac_sw_3_3.tg_sw_3_3.SWN single_9b_cdac_0.cdac_sw_9b_0.cdac_sw_3_3.nooverlap_clk_0.x10.A VGND VGND sky130_fd_pr__nfet_01v8_lvt ad=0.1036 pd=1.02 as=0.1036 ps=1.02 w=0.74 l=0.15
X4640 a_8895_26350# a_8379_25978# a_8800_26338# VGND sky130_fd_pr__special_nfet_01v8 ad=0.0594 pd=0.69 as=0.066 ps=0.745 w=0.36 l=0.15
X4641 th_dif_sw_0.VCN single_9b_cdac_0.cdac_sw_9b_0.S[0] sky130_fd_pr__cap_mim_m3_1 l=2 w=2
X4642 a_16542_13134# tdc_0.phase_detector_0.pd_out_0.A VGND VGND sky130_fd_pr__nfet_01v8_lvt ad=0.0888 pd=0.98 as=0.12607 ps=1.1 w=0.74 l=0.15
X4643 VGND single_9b_cdac_0.cdac_sw_9b_0.cdac_sw_3_3.nooverlap_clk_0.CLKB0 single_9b_cdac_0.cdac_sw_9b_0.cdac_sw_3_3.nooverlap_clk_0.CLK0 VGND sky130_fd_pr__nfet_01v8_lvt ad=0.1554 pd=1.16 as=0.1036 ps=1.02 w=0.74 l=0.15
X4644 VDPWR VGND VDPWR VDPWR sky130_fd_pr__pfet_01v8_hvt ad=0.2262 pd=2.26 as=0 ps=0 w=0.87 l=0.59
X4645 a_14143_19748# a_13968_19822# a_14322_19810# VGND sky130_fd_pr__nfet_01v8 ad=0.1092 pd=1.36 as=0.06405 ps=0.725 w=0.42 l=0.15
X4646 VDPWR single_9b_cdac_0.cdac_sw_9b_0.cdac_sw_3_7.nooverlap_clk_0.x10.A single_9b_cdac_0.cdac_sw_9b_0.cdac_sw_3_7.tg_sw_3_3.SWN VDPWR sky130_fd_pr__pfet_01v8 ad=0.168 pd=1.42 as=0.168 ps=1.42 w=1.12 l=0.15
X4647 single_9b_cdac_0.cdac_sw_9b_0.cdac_sw_3_2.nooverlap_clk_0.x10.A single_9b_cdac_0.cdac_sw_9b_0.cdac_sw_3_2.nooverlap_clk_0.x8.A VGND VGND sky130_fd_pr__nfet_01v8_lvt ad=0.1036 pd=1.02 as=0.2109 ps=2.05 w=0.74 l=0.15
X4648 VGND VDPWR VGND VGND sky130_fd_pr__nfet_01v8 ad=0.143 pd=1.62 as=0 ps=0 w=0.55 l=0.59
X4649 a_9477_19822# a_8287_19450# a_9368_19822# VGND sky130_fd_pr__special_nfet_01v8 ad=0.0669 pd=0.75 as=0.0711 ps=0.755 w=0.36 l=0.15
X4650 VGND single_9b_cdac_1.cdac_sw_9b_0.cdac_sw_3_4.nooverlap_clk_0.CLKB0 single_9b_cdac_1.cdac_sw_9b_0.cdac_sw_3_4.nooverlap_clk_0.CLK0 VGND sky130_fd_pr__nfet_01v8_lvt ad=0.1554 pd=1.16 as=0.1036 ps=1.02 w=0.74 l=0.15
X4651 dw_17224_1400# a_21368_4076# sky130_fd_pr__cap_mim_m3_1 l=2 w=2
X4652 single_9b_cdac_0.SW[8] a_14451_27060# VGND VGND sky130_fd_pr__nfet_01v8 ad=0.1352 pd=1.56 as=0.0754 ps=0.81 w=0.52 l=0.15
X4653 a_13053_26516# a_12887_26516# VGND VGND sky130_fd_pr__nfet_01v8 ad=0.1092 pd=1.36 as=0.0567 ps=0.69 w=0.42 l=0.15
X4654 VGND VDPWR VGND VGND sky130_fd_pr__nfet_01v8 ad=0.143 pd=1.62 as=0 ps=0 w=0.55 l=0.59
X4655 single_9b_cdac_1.cdac_sw_9b_0.cdac_sw_3_7.nooverlap_clk_0.sky130_fd_sc_hs__inv_1_1.A single_9b_cdac_1.cdac_sw_9b_0.cdac_sw_3_7.nooverlap_clk_0.sky130_fd_sc_hs__nand2_1_0.Y VGND VGND sky130_fd_pr__nfet_01v8_lvt ad=0.2109 pd=2.05 as=0.2627 ps=2.19 w=0.74 l=0.15
X4656 VGND single_9b_cdac_1.cdac_sw_9b_0.cdac_sw_3_5.nooverlap_clk_0.CLKB0 single_9b_cdac_1.cdac_sw_9b_0.cdac_sw_3_5.nooverlap_clk_0.CLK0 VGND sky130_fd_pr__nfet_01v8_lvt ad=0.1036 pd=1.02 as=0.1036 ps=1.02 w=0.74 l=0.15
X4657 th_dif_sw_0.VCP single_9b_cdac_1.cdac_sw_9b_0.S[0] sky130_fd_pr__cap_mim_m3_1 l=2 w=2
X4658 th_dif_sw_0.VCP single_9b_cdac_1.cdac_sw_9b_0.S[0] sky130_fd_pr__cap_mim_m3_1 l=2 w=2
X4659 VGND single_9b_cdac_0.cdac_sw_9b_0.cdac_sw_3_5.nooverlap_clk_0.x4.A single_9b_cdac_0.cdac_sw_9b_0.cdac_sw_3_5.nooverlap_clk_0.x6.A VGND sky130_fd_pr__nfet_01v8_lvt ad=0.2627 pd=2.19 as=0.2109 ps=2.05 w=0.74 l=0.15
X4660 a_43540_16877# single_9b_cdac_1.SW[4] VDPWR VDPWR sky130_fd_pr__pfet_01v8 ad=0.435 pd=3.58 as=0.435 ps=3.58 w=1.5 l=0.5
X4661 a_41357_15501# single_9b_cdac_1.CF[5] single_9b_cdac_1.cdac_sw_9b_0.cdac_sw_3_5.nooverlap_clk_0.sky130_fd_sc_hs__nand2_1_0.Y VGND sky130_fd_pr__nfet_01v8_lvt ad=0.0888 pd=0.98 as=0.2109 ps=2.05 w=0.74 l=0.15
X4662 th_dif_sw_0.VCN single_9b_cdac_0.cdac_sw_9b_0.S[4] sky130_fd_pr__cap_mim_m3_1 l=2 w=2
X4663 VDPWR VGND VDPWR VDPWR sky130_fd_pr__pfet_01v8_hvt ad=0.2262 pd=2.26 as=0 ps=0 w=0.87 l=0.59
X4664 single_9b_cdac_1.cdac_sw_9b_0.cdac_sw_3_6.nooverlap_clk_0.x6.A single_9b_cdac_1.cdac_sw_9b_0.cdac_sw_3_6.nooverlap_clk_0.x4.A VDPWR VDPWR sky130_fd_pr__pfet_01v8 ad=0.3304 pd=2.83 as=0.3864 ps=2.93 w=1.12 l=0.15
X4665 single_9b_cdac_1.cdac_sw_9b_0.cdac_sw_3_4.tg_sw_3_3.SWN single_9b_cdac_1.cdac_sw_9b_0.cdac_sw_3_4.nooverlap_clk_0.x10.A VDPWR VDPWR sky130_fd_pr__pfet_01v8 ad=0.168 pd=1.42 as=0.3304 ps=2.83 w=1.12 l=0.15
X4666 VDPWR sar9b_0.FINAL a_13379_27398# VDPWR sky130_fd_pr__pfet_01v8_hvt ad=0.16655 pd=1.39 as=0.0567 ps=0.69 w=0.42 l=0.15
X4667 a_58824_26990# single_9b_cdac_0.cdac_sw_9b_0.cdac_sw_3_1.nooverlap_clk_0.CLK0 single_9b_cdac_0.cdac_sw_9b_0.S[1] VGND sky130_fd_pr__nfet_01v8 ad=0.145 pd=1.58 as=0.145 ps=1.58 w=0.5 l=0.5
X4668 single_9b_cdac_0.SW[2] a_14175_24340# VDPWR VDPWR sky130_fd_pr__pfet_01v8_hvt ad=0.2054 pd=2.1 as=0.11455 ps=1.08 w=0.79 l=0.15
X4669 VGND single_9b_cdac_1.cdac_sw_9b_0.cdac_sw_3_3.nooverlap_clk_0.x1.A single_9b_cdac_1.cdac_sw_9b_0.cdac_sw_3_3.nooverlap_clk_0.sky130_fd_sc_hs__inv_8_0.A VGND sky130_fd_pr__nfet_01v8_lvt ad=0.1221 pd=1.07 as=0.1184 ps=1.06 w=0.74 l=0.15
X4670 VDPWR single_9b_cdac_1.cdac_sw_9b_0.cdac_sw_3_0.tg_sw_3_3.SWN single_9b_cdac_1.cdac_sw_9b_0.cdac_sw_3_0.tg_sw_3_3.SWP VDPWR sky130_fd_pr__pfet_01v8 ad=0.3864 pd=2.93 as=0.168 ps=1.42 w=1.12 l=0.15
X4671 sar9b_0.clknet_1_1__leaf_CLK a_6149_23770# VGND VGND sky130_fd_pr__nfet_01v8 ad=0.0588 pd=0.7 as=0.1113 ps=1.37 w=0.42 l=0.15
X4672 a_8085_23802# a_7919_23802# VGND VGND sky130_fd_pr__nfet_01v8 ad=0.1092 pd=1.36 as=0.0567 ps=0.69 w=0.42 l=0.15
X4673 th_dif_sw_0.VCP single_9b_cdac_1.cdac_sw_9b_0.S[0] sky130_fd_pr__cap_mim_m3_1 l=2 w=2
X4674 dw_17224_1400# a_21368_4076# sky130_fd_pr__cap_mim_m3_1 l=2 w=2
X4675 th_dif_sw_0.VCN single_9b_cdac_0.cdac_sw_9b_0.S[5] sky130_fd_pr__cap_mim_m3_1 l=2 w=2
X4676 single_9b_cdac_1.cdac_sw_9b_0.S[1] single_9b_cdac_1.cdac_sw_9b_0.cdac_sw_3_1.tg_sw_3_3.SWP ua[0] VGND sky130_fd_pr__nfet_01v8 ad=0.145 pd=1.58 as=0.145 ps=1.58 w=0.5 l=0.5
X4677 single_9b_cdac_1.cdac_sw_9b_0.cdac_sw_3_5.nooverlap_clk_0.x8.A single_9b_cdac_1.cdac_sw_9b_0.cdac_sw_3_5.nooverlap_clk_0.x6.A VGND VGND sky130_fd_pr__nfet_01v8_lvt ad=0.2109 pd=2.05 as=0.2627 ps=2.19 w=0.74 l=0.15
X4678 VGND single_9b_cdac_0.SW[1] a_58824_26990# VGND sky130_fd_pr__nfet_01v8 ad=0.145 pd=1.58 as=0.145 ps=1.58 w=0.5 l=0.5
X4679 a_34814_26990# single_9b_cdac_0.cdac_sw_9b_0.cdac_sw_3_6.nooverlap_clk_0.CLK0 single_9b_cdac_0.cdac_sw_9b_0.S[6] VGND sky130_fd_pr__nfet_01v8 ad=0.145 pd=1.58 as=0.145 ps=1.58 w=0.5 l=0.5
X4680 a_30012_17740# single_9b_cdac_1.cdac_sw_9b_0.cdac_sw_3_7.nooverlap_clk_0.CLK0 single_9b_cdac_1.cdac_sw_9b_0.S[7] VGND sky130_fd_pr__nfet_01v8 ad=0.145 pd=1.58 as=0.145 ps=1.58 w=0.5 l=0.5
X4681 single_9b_cdac_1.cdac_sw_9b_0.cdac_sw_3_0.tg_sw_3_3.SWP single_9b_cdac_1.cdac_sw_9b_0.cdac_sw_3_0.tg_sw_3_3.SWN VDPWR VDPWR sky130_fd_pr__pfet_01v8 ad=0.168 pd=1.42 as=0.196 ps=1.47 w=1.12 l=0.15
X4682 single_9b_cdac_1.cdac_sw_9b_0.S[2] single_9b_cdac_1.cdac_sw_9b_0.cdac_sw_3_0.tg_sw_3_3.SWP single_9b_cdac_1.cdac_sw_9b_0.S[2] VDPWR sky130_fd_pr__pfet_01v8 ad=0.435 pd=3.58 as=0 ps=0 w=1.5 l=0.5
X4683 th_dif_sw_0.VCP single_9b_cdac_1.cdac_sw_9b_0.S[0] sky130_fd_pr__cap_mim_m3_1 l=2 w=2
X4684 VDPWR single_9b_cdac_1.cdac_sw_9b_0.cdac_sw_3_3.nooverlap_clk_0.sky130_fd_sc_hs__inv_8_0.A single_9b_cdac_1.cdac_sw_9b_0.cdac_sw_3_3.nooverlap_clk_0.CLKB0 VDPWR sky130_fd_pr__pfet_01v8 ad=0.196 pd=1.47 as=0.168 ps=1.42 w=1.12 l=0.15
X4685 VDPWR a_7273_25946# a_7163_25972# VDPWR sky130_fd_pr__pfet_01v8_hvt ad=0.07035 pd=0.755 as=0.1155 ps=0.97 w=0.42 l=0.15
X4686 single_9b_cdac_1.cdac_sw_9b_0.cdac_sw_3_6.tg_sw_3_3.SWP single_9b_cdac_1.cdac_sw_9b_0.cdac_sw_3_6.tg_sw_3_3.SWN VGND VGND sky130_fd_pr__nfet_01v8_lvt ad=0.1036 pd=1.02 as=0.1554 ps=1.16 w=0.74 l=0.15
X4687 single_9b_cdac_1.cdac_sw_9b_0.cdac_sw_3_3.nooverlap_clk_0.CLKB0 single_9b_cdac_1.cdac_sw_9b_0.cdac_sw_3_3.nooverlap_clk_0.sky130_fd_sc_hs__inv_8_0.A VGND VGND sky130_fd_pr__nfet_01v8_lvt ad=0.1036 pd=1.02 as=0.1036 ps=1.02 w=0.74 l=0.15
X4688 th_dif_sw_0.VCP single_9b_cdac_1.cdac_sw_9b_0.S[0] sky130_fd_pr__cap_mim_m3_1 l=2 w=2
X4689 VGND single_9b_cdac_1.cdac_sw_9b_0.cdac_sw_3_1.tg_sw_3_3.SWN single_9b_cdac_1.cdac_sw_9b_0.cdac_sw_3_1.tg_sw_3_3.SWP VGND sky130_fd_pr__nfet_01v8_lvt ad=0.1295 pd=1.09 as=0.1036 ps=1.02 w=0.74 l=0.15
X4690 single_9b_cdac_0.cdac_sw_9b_0.cdac_sw_3_1.nooverlap_clk_0.CLK0 single_9b_cdac_0.cdac_sw_9b_0.cdac_sw_3_1.nooverlap_clk_0.CLKB0 VDPWR VDPWR sky130_fd_pr__pfet_01v8 ad=0.168 pd=1.42 as=0.196 ps=1.47 w=1.12 l=0.15
X4691 a_62748_26999# single_9b_cdac_0.SW[0] VDPWR VDPWR sky130_fd_pr__pfet_01v8 ad=0.435 pd=3.58 as=0.435 ps=3.58 w=1.5 l=0.5
X4692 a_12303_26350# a_11857_25978# a_12207_26350# VGND sky130_fd_pr__special_nfet_01v8 ad=0.1401 pd=1.1 as=0.0594 ps=0.69 w=0.36 l=0.15
X4693 VGND sar9b_0.net15 a_11089_25250# VGND sky130_fd_pr__nfet_01v8 ad=0.1346 pd=1.15 as=0.0441 ps=0.63 w=0.42 l=0.15
X4694 a_13621_24858# a_13403_25262# VDPWR VDPWR sky130_fd_pr__pfet_01v8_hvt ad=0.12915 pd=1.185 as=0.2184 ps=2.2 w=0.84 l=0.15
X4695 th_dif_sw_0.VCN single_9b_cdac_0.cdac_sw_9b_0.S[4] sky130_fd_pr__cap_mim_m3_1 l=2 w=2
X4696 a_10187_22138# sar9b_0.net15 VDPWR VDPWR sky130_fd_pr__pfet_01v8_hvt ad=0.0567 pd=0.69 as=0.0819 ps=0.81 w=0.42 l=0.15
X4697 VGND VDPWR VGND VGND sky130_fd_pr__nfet_01v8 ad=0.143 pd=1.62 as=0 ps=0 w=0.55 l=0.59
X4698 a_5884_21326# sar9b_0._08_ a_5711_21076# VGND sky130_fd_pr__nfet_01v8 ad=0.169 pd=1.82 as=0.10075 ps=0.96 w=0.65 l=0.15
X4699 single_9b_cdac_1.cdac_sw_9b_0.cdac_sw_3_3.nooverlap_clk_0.CLKB0 single_9b_cdac_1.cdac_sw_9b_0.cdac_sw_3_3.nooverlap_clk_0.sky130_fd_sc_hs__inv_8_0.A VDPWR VDPWR sky130_fd_pr__pfet_01v8 ad=0.168 pd=1.42 as=0.168 ps=1.42 w=1.12 l=0.15
X4700 th_dif_sw_0.VCP single_9b_cdac_1.cdac_sw_9b_0.S[0] sky130_fd_pr__cap_mim_m3_1 l=2 w=2
X4701 th_dif_sw_0.VCN single_9b_cdac_0.cdac_sw_9b_0.S[0] sky130_fd_pr__cap_mim_m3_1 l=2 w=2
X4702 th_dif_sw_0.VCN single_9b_cdac_0.cdac_sw_9b_0.S[3] sky130_fd_pr__cap_mim_m3_1 l=2 w=2
X4703 ua[0] single_9b_cdac_0.cdac_sw_9b_0.cdac_sw_3_7.tg_sw_3_3.SWP ua[0] VDPWR sky130_fd_pr__pfet_01v8 ad=0.435 pd=3.58 as=0 ps=0 w=1.5 l=0.5
X4704 VDPWR a_5483_19676# sar9b_0.net16 VDPWR sky130_fd_pr__pfet_01v8_hvt ad=0.135 pd=1.27 as=0.26 ps=2.52 w=1 l=0.15
X4705 a_48343_16877# single_9b_cdac_1.SW[3] VDPWR VDPWR sky130_fd_pr__pfet_01v8 ad=0.435 pd=3.58 as=0.435 ps=3.58 w=1.5 l=0.5
X4706 a_10827_23252# a_10311_23252# a_10732_23252# VGND sky130_fd_pr__special_nfet_01v8 ad=0.0594 pd=0.69 as=0.066 ps=0.745 w=0.36 l=0.15
X4707 single_9b_cdac_0.cdac_sw_9b_0.cdac_sw_3_7.nooverlap_clk_0.sky130_fd_sc_hs__inv_8_0.A single_9b_cdac_0.cdac_sw_9b_0.cdac_sw_3_7.nooverlap_clk_0.x1.A VGND VGND sky130_fd_pr__nfet_01v8_lvt ad=0.1036 pd=1.02 as=0.2109 ps=2.05 w=0.74 l=0.15
X4708 sar9b_0.FINAL a_11935_25402# VGND VGND sky130_fd_pr__nfet_01v8 ad=0.08775 pd=0.92 as=0.2087 ps=2.02 w=0.65 l=0.15
X4709 VGND sar9b_0.net15 a_11733_24162# VGND sky130_fd_pr__nfet_01v8 ad=0.1346 pd=1.15 as=0.0441 ps=0.63 w=0.42 l=0.15
X4710 ua[0] single_9b_cdac_1.cdac_sw_9b_0.cdac_sw_3_7.tg_sw_3_3.SWN ua[0] VGND sky130_fd_pr__nfet_01v8 ad=0.145 pd=1.58 as=0 ps=0 w=0.5 l=0.5
X4711 th_dif_sw_0.VCP single_9b_cdac_1.cdac_sw_9b_0.S[0] sky130_fd_pr__cap_mim_m3_1 l=2 w=2
X4712 th_dif_sw_0.VCN single_9b_cdac_0.cdac_sw_9b_0.S[2] sky130_fd_pr__cap_mim_m3_1 l=2 w=2
X4713 sar9b_0.net10 a_12027_22138# VGND VGND sky130_fd_pr__nfet_01v8 ad=0.169 pd=1.82 as=0.2087 ps=2.02 w=0.65 l=0.15
X4714 VGND sar9b_0.net8 a_14175_21620# VGND sky130_fd_pr__nfet_01v8 ad=0.0754 pd=0.81 as=0.1352 ps=1.56 w=0.52 l=0.15
X4715 VDPWR single_9b_cdac_1.cdac_sw_9b_0.cdac_sw_3_3.nooverlap_clk_0.sky130_fd_sc_hs__inv_8_0.A single_9b_cdac_1.cdac_sw_9b_0.cdac_sw_3_3.nooverlap_clk_0.CLKB0 VDPWR sky130_fd_pr__pfet_01v8 ad=0.168 pd=1.42 as=0.168 ps=1.42 w=1.12 l=0.15
X4716 ua[0] single_9b_cdac_1.cdac_sw_9b_0.cdac_sw_3_1.tg_sw_3_3.SWN ua[0] VGND sky130_fd_pr__nfet_01v8 ad=0.145 pd=1.58 as=0 ps=0 w=0.5 l=0.5
X4717 th_dif_sw_0.VCN single_9b_cdac_0.cdac_sw_9b_0.S[0] sky130_fd_pr__cap_mim_m3_1 l=2 w=2
X4718 VDPWR VGND VDPWR VDPWR sky130_fd_pr__pfet_01v8_hvt ad=0.2262 pd=2.26 as=0 ps=0 w=0.87 l=0.59
X4719 VGND single_9b_cdac_0.cdac_sw_9b_0.cdac_sw_3_8.tg_sw_3_3.SWN single_9b_cdac_0.cdac_sw_9b_0.cdac_sw_3_8.tg_sw_3_3.SWP VGND sky130_fd_pr__nfet_01v8_lvt ad=0.1036 pd=1.02 as=0.1036 ps=1.02 w=0.74 l=0.15
X4720 ua[0] single_9b_cdac_0.cdac_sw_9b_0.cdac_sw_3_7.tg_sw_3_3.SWN ua[0] VGND sky130_fd_pr__nfet_01v8 ad=0.145 pd=1.58 as=0 ps=0 w=0.5 l=0.5
X4721 sar9b_0.net32 a_14143_25188# VGND VGND sky130_fd_pr__nfet_01v8 ad=0.169 pd=1.82 as=0.2087 ps=2.02 w=0.65 l=0.15
X4722 VDPWR sar9b_0.net10 a_13623_23252# VDPWR sky130_fd_pr__pfet_01v8_hvt ad=0.11455 pd=1.08 as=0.2054 ps=2.1 w=0.79 l=0.15
X4723 VDPWR sar9b_0.net7 a_12887_21076# VDPWR sky130_fd_pr__pfet_01v8_hvt ad=0.0864 pd=0.91 as=0.1664 ps=1.8 w=0.64 l=0.15
X4724 VDPWR single_9b_cdac_1.cdac_sw_9b_0.cdac_sw_3_8.nooverlap_clk_0.CLKB0 single_9b_cdac_1.cdac_sw_9b_0.cdac_sw_3_8.nooverlap_clk_0.CLK0 VDPWR sky130_fd_pr__pfet_01v8 ad=0.196 pd=1.47 as=0.168 ps=1.42 w=1.12 l=0.15
X4725 single_9b_cdac_1.cdac_sw_9b_0.cdac_sw_3_3.nooverlap_clk_0.CLKB0 single_9b_cdac_1.cdac_sw_9b_0.cdac_sw_3_3.nooverlap_clk_0.sky130_fd_sc_hs__inv_8_0.A VDPWR VDPWR sky130_fd_pr__pfet_01v8 ad=0.168 pd=1.42 as=0.196 ps=1.47 w=1.12 l=0.15
X4726 VDPWR sar9b_0.net36 a_14451_18356# VDPWR sky130_fd_pr__pfet_01v8_hvt ad=0.11455 pd=1.08 as=0.2054 ps=2.1 w=0.79 l=0.15
X4727 th_dif_sw_0.VCP single_9b_cdac_1.cdac_sw_9b_0.S[0] sky130_fd_pr__cap_mim_m3_1 l=2 w=2
X4728 th_dif_sw_0.VCN single_9b_cdac_0.cdac_sw_9b_0.S[0] sky130_fd_pr__cap_mim_m3_1 l=2 w=2
X4729 VGND single_9b_cdac_0.cdac_sw_9b_0.cdac_sw_3_6.nooverlap_clk_0.CLKB0 single_9b_cdac_0.cdac_sw_9b_0.cdac_sw_3_6.nooverlap_clk_0.CLK0 VGND sky130_fd_pr__nfet_01v8_lvt ad=0.1295 pd=1.09 as=0.1036 ps=1.02 w=0.74 l=0.15
X4730 VGND single_9b_cdac_0.cdac_sw_9b_0.cdac_sw_3_5.tg_sw_3_3.SWN single_9b_cdac_0.cdac_sw_9b_0.cdac_sw_3_5.tg_sw_3_3.SWP VGND sky130_fd_pr__nfet_01v8_lvt ad=0.2109 pd=2.05 as=0.1036 ps=1.02 w=0.74 l=0.15
X4731 ua[0] single_9b_cdac_1.cdac_sw_9b_0.cdac_sw_3_2.tg_sw_3_3.SWP ua[0] VDPWR sky130_fd_pr__pfet_01v8 ad=0.435 pd=3.58 as=0 ps=0 w=1.5 l=0.5
X4732 single_9b_cdac_1.cdac_sw_9b_0.cdac_sw_3_8.nooverlap_clk_0.CLK0 single_9b_cdac_1.cdac_sw_9b_0.cdac_sw_3_8.nooverlap_clk_0.CLKB0 VDPWR VDPWR sky130_fd_pr__pfet_01v8 ad=0.168 pd=1.42 as=0.168 ps=1.42 w=1.12 l=0.15
X4733 a_13053_19988# a_12887_19988# VGND VGND sky130_fd_pr__nfet_01v8 ad=0.1092 pd=1.36 as=0.0567 ps=0.69 w=0.42 l=0.15
X4734 single_9b_cdac_0.cdac_sw_9b_0.S[2] single_9b_cdac_0.cdac_sw_9b_0.cdac_sw_3_0.tg_sw_3_3.SWP ua[0] VGND sky130_fd_pr__nfet_01v8 ad=0.145 pd=1.58 as=0.145 ps=1.58 w=0.5 l=0.5
X4735 VDPWR sar9b_0.net37 a_13071_20532# VDPWR sky130_fd_pr__pfet_01v8_hvt ad=0.11455 pd=1.08 as=0.2054 ps=2.1 w=0.79 l=0.15
X4736 a_6249_19988# sar9b_0._01_ VDPWR VDPWR sky130_fd_pr__pfet_01v8_hvt ad=0.0672 pd=0.74 as=0.1092 ps=1.36 w=0.42 l=0.15
X4737 VDPWR single_9b_cdac_0.cdac_sw_9b_0.cdac_sw_3_5.tg_sw_3_3.SWN single_9b_cdac_0.cdac_sw_9b_0.cdac_sw_3_5.tg_sw_3_3.SWP VDPWR sky130_fd_pr__pfet_01v8 ad=0.3304 pd=2.83 as=0.168 ps=1.42 w=1.12 l=0.15
X4738 VDPWR single_9b_cdac_1.cdac_sw_9b_0.cdac_sw_3_8.nooverlap_clk_0.CLKB0 single_9b_cdac_1.cdac_sw_9b_0.cdac_sw_3_8.nooverlap_clk_0.CLK0 VDPWR sky130_fd_pr__pfet_01v8 ad=0.168 pd=1.42 as=0.168 ps=1.42 w=1.12 l=0.15
X4739 a_8892_23252# sar9b_0.net2 VDPWR VDPWR sky130_fd_pr__pfet_01v8_hvt ad=0.0651 pd=0.73 as=0.1092 ps=1.36 w=0.42 l=0.15
X4740 VGND VDPWR VGND VGND sky130_fd_pr__nfet_01v8 ad=0.143 pd=1.62 as=0 ps=0 w=0.55 l=0.59
X4741 sar9b_0.net31 a_14051_24100# VDPWR VDPWR sky130_fd_pr__pfet_01v8_hvt ad=0.26 pd=2.52 as=0.3012 ps=2.66 w=1 l=0.15
X4742 single_9b_cdac_1.cdac_sw_9b_0.cdac_sw_3_2.tg_sw_3_3.SWP single_9b_cdac_1.cdac_sw_9b_0.cdac_sw_3_2.tg_sw_3_3.SWN VGND VGND sky130_fd_pr__nfet_01v8_lvt ad=0.1036 pd=1.02 as=0.1036 ps=1.02 w=0.74 l=0.15
X4743 single_9b_cdac_0.cdac_sw_9b_0.cdac_sw_3_5.tg_sw_3_3.SWP single_9b_cdac_0.cdac_sw_9b_0.cdac_sw_3_5.tg_sw_3_3.SWN VDPWR VDPWR sky130_fd_pr__pfet_01v8 ad=0.168 pd=1.42 as=0.196 ps=1.47 w=1.12 l=0.15
X4744 a_10196_21076# a_9281_21076# a_9849_21318# VGND sky130_fd_pr__special_nfet_01v8 ad=0.0711 pd=0.755 as=0.0999 ps=0.985 w=0.36 l=0.15
X4745 th_dif_sw_0.VCN single_9b_cdac_0.cdac_sw_9b_0.S[1] sky130_fd_pr__cap_mim_m3_1 l=2 w=2
X4746 VGND single_9b_cdac_0.SW[0] a_63626_26990# VGND sky130_fd_pr__nfet_01v8 ad=0.145 pd=1.58 as=0.145 ps=1.58 w=0.5 l=0.5
X4747 single_9b_cdac_1.cdac_sw_9b_0.cdac_sw_3_8.nooverlap_clk_0.CLK0 single_9b_cdac_1.cdac_sw_9b_0.cdac_sw_3_8.nooverlap_clk_0.CLKB0 VDPWR VDPWR sky130_fd_pr__pfet_01v8 ad=0.168 pd=1.42 as=0.196 ps=1.47 w=1.12 l=0.15
X4748 VGND a_8613_26681# uo_out[6] VGND sky130_fd_pr__nfet_01v8 ad=0.0754 pd=0.81 as=0.1352 ps=1.56 w=0.52 l=0.15
X4749 VDPWR sar9b_0._09_ a_7735_21076# VDPWR sky130_fd_pr__pfet_01v8_hvt ad=0.0567 pd=0.69 as=0.1092 ps=1.36 w=0.42 l=0.15
X4750 sar9b_0.net4 a_7735_17812# VDPWR VDPWR sky130_fd_pr__pfet_01v8_hvt ad=0.135 pd=1.27 as=0.1625 ps=1.325 w=1 l=0.15
X4751 single_9b_cdac_1.cdac_sw_9b_0.cdac_sw_3_0.nooverlap_clk_0.sky130_fd_sc_hs__inv_1_1.A single_9b_cdac_1.cdac_sw_9b_0.cdac_sw_3_0.nooverlap_clk_0.sky130_fd_sc_hs__nand2_1_0.Y VDPWR VDPWR sky130_fd_pr__pfet_01v8 ad=0.3304 pd=2.83 as=0.3864 ps=2.93 w=1.12 l=0.15
X4752 single_9b_cdac_0.cdac_sw_9b_0.cdac_sw_3_3.tg_sw_3_3.SWN single_9b_cdac_0.cdac_sw_9b_0.cdac_sw_3_3.nooverlap_clk_0.x10.A VGND VGND sky130_fd_pr__nfet_01v8_lvt ad=0.1036 pd=1.02 as=0.1295 ps=1.09 w=0.74 l=0.15
X4753 VDPWR single_9b_cdac_0.cdac_sw_9b_0.cdac_sw_3_1.nooverlap_clk_0.x8.A single_9b_cdac_0.cdac_sw_9b_0.cdac_sw_3_1.nooverlap_clk_0.x10.A VDPWR sky130_fd_pr__pfet_01v8 ad=0.3304 pd=2.83 as=0.168 ps=1.42 w=1.12 l=0.15
X4754 VGND single_9b_cdac_1.SW[1] a_58824_17740# VGND sky130_fd_pr__nfet_01v8 ad=0.145 pd=1.58 as=0.145 ps=1.58 w=0.5 l=0.5
X4755 VGND single_9b_cdac_0.cdac_sw_9b_0.cdac_sw_3_0.nooverlap_clk_0.x8.A single_9b_cdac_0.cdac_sw_9b_0.cdac_sw_3_0.nooverlap_clk_0.x10.A VGND sky130_fd_pr__nfet_01v8_lvt ad=0.2331 pd=2.11 as=0.1184 ps=1.06 w=0.74 l=0.15
X4756 sar9b_0.net2 a_12427_17812# VDPWR VDPWR sky130_fd_pr__pfet_01v8_hvt ad=0.135 pd=1.27 as=0.1625 ps=1.325 w=1 l=0.15
X4757 VDPWR VGND VDPWR VDPWR sky130_fd_pr__pfet_01v8_hvt ad=0.2262 pd=2.26 as=0 ps=0 w=0.87 l=0.59
X4758 th_dif_sw_0.VCN single_9b_cdac_0.cdac_sw_9b_0.S[3] sky130_fd_pr__cap_mim_m3_1 l=2 w=2
X4759 a_7974_26338# sar9b_0.net3 VGND VGND sky130_fd_pr__nfet_01v8 ad=0.06405 pd=0.725 as=0.12495 ps=1.015 w=0.42 l=0.15
X4760 a_9739_21442# a_9115_21076# a_9631_21076# VDPWR sky130_fd_pr__pfet_01v8_hvt ad=0.1155 pd=0.97 as=0.07245 ps=0.765 w=0.42 l=0.15
X4761 a_5973_23252# sar9b_0._02_ VDPWR VDPWR sky130_fd_pr__pfet_01v8_hvt ad=0.05775 pd=0.695 as=0.1092 ps=1.36 w=0.42 l=0.15
X4762 single_9b_cdac_0.cdac_sw_9b_0.cdac_sw_3_6.nooverlap_clk_0.sky130_fd_sc_hs__inv_8_0.A single_9b_cdac_0.cdac_sw_9b_0.cdac_sw_3_6.nooverlap_clk_0.x1.A VDPWR VDPWR sky130_fd_pr__pfet_01v8 ad=0.168 pd=1.42 as=0.168 ps=1.42 w=1.12 l=0.15
X4763 VGND single_9b_cdac_1.cdac_sw_9b_0.cdac_sw_3_7.nooverlap_clk_0.x10.A single_9b_cdac_1.cdac_sw_9b_0.cdac_sw_3_7.tg_sw_3_3.SWN VGND sky130_fd_pr__nfet_01v8_lvt ad=0.2146 pd=2.06 as=0.1036 ps=1.02 w=0.74 l=0.15
X4764 VGND single_9b_cdac_1.cdac_sw_9b_0.cdac_sw_3_3.tg_sw_3_3.SWN single_9b_cdac_1.cdac_sw_9b_0.cdac_sw_3_3.tg_sw_3_3.SWP VGND sky130_fd_pr__nfet_01v8_lvt ad=0.1036 pd=1.02 as=0.1036 ps=1.02 w=0.74 l=0.15
X4765 VGND single_9b_cdac_0.cdac_sw_9b_0.cdac_sw_3_5.nooverlap_clk_0.x1.A single_9b_cdac_0.cdac_sw_9b_0.cdac_sw_3_5.nooverlap_clk_0.sky130_fd_sc_hs__inv_8_0.A VGND sky130_fd_pr__nfet_01v8_lvt ad=0.1221 pd=1.07 as=0.1036 ps=1.02 w=0.74 l=0.15
X4766 th_dif_sw_0.VCN single_9b_cdac_0.cdac_sw_9b_0.S[0] sky130_fd_pr__cap_mim_m3_1 l=2 w=2
X4767 th_dif_sw_0.VCN single_9b_cdac_0.cdac_sw_9b_0.S[0] sky130_fd_pr__cap_mim_m3_1 l=2 w=2
X4768 a_6427_25794# sar9b_0.net3 VDPWR VDPWR sky130_fd_pr__pfet_01v8_hvt ad=0.1092 pd=1.36 as=0.07035 ps=0.755 w=0.42 l=0.15
X4769 a_11045_19418# a_10827_19822# VDPWR VDPWR sky130_fd_pr__pfet_01v8_hvt ad=0.12915 pd=1.185 as=0.2184 ps=2.2 w=0.84 l=0.15
X4770 a_13621_19142# a_13403_18900# VGND VGND sky130_fd_pr__nfet_01v8 ad=0.0999 pd=0.985 as=0.1346 ps=1.15 w=0.64 l=0.15
X4771 VDPWR VGND VDPWR VDPWR sky130_fd_pr__pfet_01v8_hvt ad=0.2262 pd=2.26 as=0 ps=0 w=0.87 l=0.59
X4772 VDPWR single_9b_cdac_0.cdac_sw_9b_0.cdac_sw_3_6.nooverlap_clk_0.x1.A single_9b_cdac_0.cdac_sw_9b_0.cdac_sw_3_6.nooverlap_clk_0.sky130_fd_sc_hs__inv_8_0.A VDPWR sky130_fd_pr__pfet_01v8 ad=0.168 pd=1.42 as=0.168 ps=1.42 w=1.12 l=0.15
X4773 a_11579_19266# sar9b_0.net15 VDPWR VDPWR sky130_fd_pr__pfet_01v8_hvt ad=0.1092 pd=1.36 as=0.07035 ps=0.755 w=0.42 l=0.15
X4774 VDPWR a_13621_19142# a_13511_19266# VDPWR sky130_fd_pr__pfet_01v8_hvt ad=0.07035 pd=0.755 as=0.1155 ps=0.97 w=0.42 l=0.15
X4775 a_29134_26999# single_9b_cdac_0.SW[7] VDPWR VDPWR sky130_fd_pr__pfet_01v8 ad=0.435 pd=3.58 as=0.435 ps=3.58 w=1.5 l=0.5
X4776 single_9b_cdac_0.cdac_sw_9b_0.S[2] single_9b_cdac_0.cdac_sw_9b_0.cdac_sw_3_0.tg_sw_3_3.SWN single_9b_cdac_0.cdac_sw_9b_0.S[2] VGND sky130_fd_pr__nfet_01v8 ad=0.145 pd=1.58 as=0 ps=0 w=0.5 l=0.5
X4777 VDPWR VGND VDPWR VDPWR sky130_fd_pr__pfet_01v8_hvt ad=0.2262 pd=2.26 as=0 ps=0 w=0.87 l=0.59
X4778 a_13499_19822# a_13053_19450# a_13403_19822# VGND sky130_fd_pr__special_nfet_01v8 ad=0.1401 pd=1.1 as=0.0594 ps=0.69 w=0.36 l=0.15
X4779 dw_17224_1400# a_21368_4076# sky130_fd_pr__cap_mim_m3_1 l=2 w=2
X4780 th_dif_sw_0.VCN single_9b_cdac_0.cdac_sw_9b_0.S[2] sky130_fd_pr__cap_mim_m3_1 l=2 w=2
X4781 VDPWR a_13968_26516# a_14143_26490# VDPWR sky130_fd_pr__pfet_01v8_hvt ad=0.1134 pd=1.38 as=0.0567 ps=0.69 w=0.42 l=0.15
X4782 single_9b_cdac_0.cdac_sw_9b_0.cdac_sw_3_6.nooverlap_clk_0.sky130_fd_sc_hs__inv_8_0.A single_9b_cdac_0.cdac_sw_9b_0.cdac_sw_3_6.nooverlap_clk_0.x1.A VDPWR VDPWR sky130_fd_pr__pfet_01v8 ad=0.168 pd=1.42 as=0.3304 ps=2.83 w=1.12 l=0.15
X4783 single_9b_cdac_1.cdac_sw_9b_0.cdac_sw_3_7.nooverlap_clk_0.CLK0 single_9b_cdac_1.cdac_sw_9b_0.cdac_sw_3_7.nooverlap_clk_0.CLKB0 VGND VGND sky130_fd_pr__nfet_01v8_lvt ad=0.1036 pd=1.02 as=0.1036 ps=1.02 w=0.74 l=0.15
X4784 VGND VDPWR VGND VGND sky130_fd_pr__nfet_01v8 ad=0.143 pd=1.62 as=0 ps=0 w=0.55 l=0.59
X4785 dw_17224_1400# a_21368_4076# sky130_fd_pr__cap_mim_m3_1 l=2 w=2
X4786 th_dif_sw_0.VCN single_9b_cdac_0.cdac_sw_9b_0.S[0] sky130_fd_pr__cap_mim_m3_1 l=2 w=2
X4787 a_11869_25428# a_10679_25428# a_11760_25428# VGND sky130_fd_pr__special_nfet_01v8 ad=0.0669 pd=0.75 as=0.0711 ps=0.755 w=0.36 l=0.15
X4788 VDPWR single_9b_cdac_1.cdac_sw_9b_0.cdac_sw_3_1.nooverlap_clk_0.sky130_fd_sc_hs__inv_8_0.A single_9b_cdac_1.cdac_sw_9b_0.cdac_sw_3_1.nooverlap_clk_0.CLKB0 VDPWR sky130_fd_pr__pfet_01v8 ad=0.196 pd=1.47 as=0.168 ps=1.42 w=1.12 l=0.15
X4789 th_dif_sw_0.VCP single_9b_cdac_1.cdac_sw_9b_0.S[1] sky130_fd_pr__cap_mim_m3_1 l=2 w=2
X4790 th_dif_sw_0.VCP single_9b_cdac_1.cdac_sw_9b_0.S[0] sky130_fd_pr__cap_mim_m3_1 l=2 w=2
X4791 VGND sar9b_0.net10 a_12795_23802# VGND sky130_fd_pr__nfet_01v8 ad=0.0567 pd=0.69 as=0.1092 ps=1.36 w=0.42 l=0.15
X4792 th_dif_sw_0.VCN single_9b_cdac_0.cdac_sw_9b_0.S[1] sky130_fd_pr__cap_mim_m3_1 l=2 w=2
X4793 th_dif_sw_0.VCN single_9b_cdac_0.cdac_sw_9b_0.S[2] sky130_fd_pr__cap_mim_m3_1 l=2 w=2
X4794 single_9b_cdac_1.cdac_sw_9b_0.cdac_sw_3_2.nooverlap_clk_0.CLKB0 single_9b_cdac_1.cdac_sw_9b_0.cdac_sw_3_2.nooverlap_clk_0.sky130_fd_sc_hs__inv_8_0.A VGND VGND sky130_fd_pr__nfet_01v8_lvt ad=0.1036 pd=1.02 as=0.1554 ps=1.16 w=0.74 l=0.15
X4795 single_9b_cdac_1.cdac_sw_9b_0.cdac_sw_3_1.nooverlap_clk_0.CLKB0 single_9b_cdac_1.cdac_sw_9b_0.cdac_sw_3_1.nooverlap_clk_0.sky130_fd_sc_hs__inv_8_0.A VDPWR VDPWR sky130_fd_pr__pfet_01v8 ad=0.168 pd=1.42 as=0.168 ps=1.42 w=1.12 l=0.15
X4796 VGND tdc_0.OUTN a_10311_17812# VGND sky130_fd_pr__nfet_01v8 ad=0.06825 pd=0.745 as=0.1113 ps=1.37 w=0.42 l=0.15
X4797 VDPWR VGND VDPWR VDPWR sky130_fd_pr__pfet_01v8_hvt ad=0.2262 pd=2.26 as=0 ps=0 w=0.87 l=0.59
X4798 single_9b_cdac_1.cdac_sw_9b_0.cdac_sw_3_0.nooverlap_clk_0.sky130_fd_sc_hs__inv_8_0.A single_9b_cdac_1.cdac_sw_9b_0.cdac_sw_3_0.nooverlap_clk_0.x1.A VGND VGND sky130_fd_pr__nfet_01v8_lvt ad=0.1036 pd=1.02 as=0.1221 ps=1.07 w=0.74 l=0.15
X4799 single_9b_cdac_0.cdac_sw_9b_0.cdac_sw_3_1.nooverlap_clk_0.x10.A single_9b_cdac_0.cdac_sw_9b_0.cdac_sw_3_1.nooverlap_clk_0.x8.A VGND VGND sky130_fd_pr__nfet_01v8_lvt ad=0.1184 pd=1.06 as=0.1221 ps=1.07 w=0.74 l=0.15
X4800 VGND VDPWR VGND VGND sky130_fd_pr__nfet_01v8 ad=0.143 pd=1.62 as=0 ps=0 w=0.55 l=0.59
X4801 single_9b_cdac_1.cdac_sw_9b_0.cdac_sw_3_4.tg_sw_3_3.SWP single_9b_cdac_1.cdac_sw_9b_0.cdac_sw_3_4.tg_sw_3_3.SWN VGND VGND sky130_fd_pr__nfet_01v8_lvt ad=0.1036 pd=1.02 as=0.1295 ps=1.09 w=0.74 l=0.15
X4802 th_dif_sw_0.VCP single_9b_cdac_1.cdac_sw_9b_0.S[1] sky130_fd_pr__cap_mim_m3_1 l=2 w=2
X4803 th_dif_sw_0.VCP single_9b_cdac_1.cdac_sw_9b_0.S[1] sky130_fd_pr__cap_mim_m3_1 l=2 w=2
X4804 VGND a_9132_7271# th_dif_sw_0.th_sw_1.CK VGND sky130_fd_pr__nfet_01v8_lvt ad=0.1036 pd=1.02 as=0.1036 ps=1.02 w=0.74 l=0.15
X4805 single_9b_cdac_1.cdac_sw_9b_0.S[0] single_9b_cdac_1.cdac_sw_9b_0.cdac_sw_3_2.tg_sw_3_3.SWP ua[0] VGND sky130_fd_pr__nfet_01v8 ad=0.145 pd=1.58 as=0.145 ps=1.58 w=0.5 l=0.5
X4806 VDPWR single_9b_cdac_1.cdac_sw_9b_0.cdac_sw_3_1.nooverlap_clk_0.sky130_fd_sc_hs__inv_8_0.A single_9b_cdac_1.cdac_sw_9b_0.cdac_sw_3_1.nooverlap_clk_0.CLKB0 VDPWR sky130_fd_pr__pfet_01v8 ad=0.168 pd=1.42 as=0.168 ps=1.42 w=1.12 l=0.15
X4807 a_9536_26516# sar9b_0.net41 VGND VGND sky130_fd_pr__nfet_01v8 ad=0.066 pd=0.745 as=0.2205 ps=1.89 w=0.42 l=0.15
X4808 single_9b_cdac_0.cdac_sw_9b_0.S[3] single_9b_cdac_0.cdac_sw_9b_0.cdac_sw_3_4.tg_sw_3_3.SWN single_9b_cdac_0.cdac_sw_9b_0.S[3] VGND sky130_fd_pr__nfet_01v8 ad=0.145 pd=1.58 as=0 ps=0 w=0.5 l=0.5
X4809 VDPWR sar9b_0.net6 a_13623_21620# VDPWR sky130_fd_pr__pfet_01v8_hvt ad=0.11455 pd=1.08 as=0.2054 ps=2.1 w=0.79 l=0.15
X4810 a_30012_26990# single_9b_cdac_0.cdac_sw_9b_0.cdac_sw_3_7.nooverlap_clk_0.CLK0 single_9b_cdac_0.cdac_sw_9b_0.S[7] VGND sky130_fd_pr__nfet_01v8 ad=0.145 pd=1.58 as=0.145 ps=1.58 w=0.5 l=0.5
X4811 VDPWR a_9503_20506# a_9419_20532# VDPWR sky130_fd_pr__pfet_01v8_hvt ad=0.1113 pd=1.37 as=0.0882 ps=0.84 w=0.42 l=0.15
X4812 VGND single_9b_cdac_1.SW[0] a_63626_17740# VGND sky130_fd_pr__nfet_01v8 ad=0.145 pd=1.58 as=0.145 ps=1.58 w=0.5 l=0.5
X4813 single_9b_cdac_0.cdac_sw_9b_0.cdac_sw_3_7.tg_sw_3_3.SWP single_9b_cdac_0.cdac_sw_9b_0.cdac_sw_3_7.tg_sw_3_3.SWN VGND VGND sky130_fd_pr__nfet_01v8_lvt ad=0.1036 pd=1.02 as=0.1295 ps=1.09 w=0.74 l=0.15
X4814 VGND single_9b_cdac_0.cdac_sw_9b_0.cdac_sw_3_5.tg_sw_3_3.SWN single_9b_cdac_0.cdac_sw_9b_0.cdac_sw_3_5.tg_sw_3_3.SWP VGND sky130_fd_pr__nfet_01v8_lvt ad=0.1036 pd=1.02 as=0.1036 ps=1.02 w=0.74 l=0.15
X4815 single_9b_cdac_0.cdac_sw_9b_0.cdac_sw_3_0.nooverlap_clk_0.CLK0 single_9b_cdac_0.cdac_sw_9b_0.cdac_sw_3_0.nooverlap_clk_0.CLKB0 VGND VGND sky130_fd_pr__nfet_01v8_lvt ad=0.1036 pd=1.02 as=0.1554 ps=1.16 w=0.74 l=0.15
X4816 single_9b_cdac_1.cdac_sw_9b_0.cdac_sw_3_1.nooverlap_clk_0.CLKB0 single_9b_cdac_1.cdac_sw_9b_0.cdac_sw_3_1.nooverlap_clk_0.sky130_fd_sc_hs__inv_8_0.A VDPWR VDPWR sky130_fd_pr__pfet_01v8 ad=0.168 pd=1.42 as=0.196 ps=1.47 w=1.12 l=0.15
X4817 single_9b_cdac_1.cdac_sw_9b_0.cdac_sw_3_0.nooverlap_clk_0.CLKB0 single_9b_cdac_1.cdac_sw_9b_0.cdac_sw_3_0.nooverlap_clk_0.sky130_fd_sc_hs__inv_8_0.A VGND VGND sky130_fd_pr__nfet_01v8_lvt ad=0.1036 pd=1.02 as=0.1295 ps=1.09 w=0.74 l=0.15
X4818 single_9b_cdac_0.cdac_sw_9b_0.S[5] single_9b_cdac_0.cdac_sw_9b_0.cdac_sw_3_5.tg_sw_3_3.SWP single_9b_cdac_0.cdac_sw_9b_0.S[5] VDPWR sky130_fd_pr__pfet_01v8 ad=0.435 pd=3.58 as=0 ps=0 w=1.5 l=0.5
X4819 VDPWR single_9b_cdac_1.cdac_sw_9b_0.cdac_sw_3_1.nooverlap_clk_0.x1.A single_9b_cdac_1.cdac_sw_9b_0.cdac_sw_3_1.nooverlap_clk_0.x4.A VDPWR sky130_fd_pr__pfet_01v8 ad=0.3192 pd=2.81 as=0.168 ps=1.42 w=1.12 l=0.15
X4820 single_9b_cdac_0.cdac_sw_9b_0.cdac_sw_3_5.nooverlap_clk_0.sky130_fd_sc_hs__inv_8_0.A single_9b_cdac_0.cdac_sw_9b_0.cdac_sw_3_5.nooverlap_clk_0.x1.A VDPWR VDPWR sky130_fd_pr__pfet_01v8 ad=0.168 pd=1.42 as=0.168 ps=1.42 w=1.12 l=0.15
X4821 a_10637_27279# sar9b_0.net22 VDPWR VDPWR sky130_fd_pr__pfet_01v8_hvt ad=0.2054 pd=2.1 as=0.11455 ps=1.08 w=0.79 l=0.15
X4822 single_9b_cdac_1.cdac_sw_9b_0.cdac_sw_3_8.nooverlap_clk_0.x1.A single_9b_cdac_1.cdac_sw_9b_0.cdac_sw_3_8.nooverlap_clk_0.sky130_fd_sc_hs__inv_1_1.A VDPWR VDPWR sky130_fd_pr__pfet_01v8 ad=0.3304 pd=2.83 as=0.3864 ps=2.93 w=1.12 l=0.15
X4823 a_48343_16877# single_9b_cdac_1.SW[3] VDPWR VDPWR sky130_fd_pr__pfet_01v8 ad=0.435 pd=3.58 as=0.435 ps=3.58 w=1.5 l=0.5
X4824 single_9b_cdac_1.cdac_sw_9b_0.cdac_sw_3_1.nooverlap_clk_0.x4.A single_9b_cdac_1.cdac_sw_9b_0.cdac_sw_3_1.nooverlap_clk_0.x3.Y VDPWR VDPWR sky130_fd_pr__pfet_01v8 ad=0.168 pd=1.42 as=0.3192 ps=2.81 w=1.12 l=0.15
X4825 single_9b_cdac_1.cdac_sw_9b_0.S[5] single_9b_cdac_1.cdac_sw_9b_0.cdac_sw_3_5.tg_sw_3_3.SWN single_9b_cdac_1.cdac_sw_9b_0.S[5] VGND sky130_fd_pr__nfet_01v8 ad=0.145 pd=1.58 as=0 ps=0 w=0.5 l=0.5
X4826 th_dif_sw_0.VCP single_9b_cdac_1.cdac_sw_9b_0.S[1] sky130_fd_pr__cap_mim_m3_1 l=2 w=2
X4827 th_dif_sw_0.VCN single_9b_cdac_0.cdac_sw_9b_0.S[0] sky130_fd_pr__cap_mim_m3_1 l=2 w=2
X4828 VDPWR single_9b_cdac_0.cdac_sw_9b_0.cdac_sw_3_5.nooverlap_clk_0.x1.A single_9b_cdac_0.cdac_sw_9b_0.cdac_sw_3_5.nooverlap_clk_0.sky130_fd_sc_hs__inv_8_0.A VDPWR sky130_fd_pr__pfet_01v8 ad=0.168 pd=1.42 as=0.168 ps=1.42 w=1.12 l=0.15
X4829 VGND VDPWR VGND VGND sky130_fd_pr__nfet_01v8 ad=0.143 pd=1.62 as=0 ps=0 w=0.55 l=0.59
X4830 single_9b_cdac_0.cdac_sw_9b_0.cdac_sw_3_7.nooverlap_clk_0.CLK0 single_9b_cdac_0.cdac_sw_9b_0.cdac_sw_3_7.nooverlap_clk_0.CLKB0 VDPWR VDPWR sky130_fd_pr__pfet_01v8 ad=0.168 pd=1.42 as=0.196 ps=1.47 w=1.12 l=0.15
X4831 a_11100_25428# sar9b_0.net13 VDPWR VDPWR sky130_fd_pr__pfet_01v8_hvt ad=0.0651 pd=0.73 as=0.1092 ps=1.36 w=0.42 l=0.15
X4832 a_14143_18874# a_13968_18900# a_14322_18900# VGND sky130_fd_pr__nfet_01v8 ad=0.1092 pd=1.36 as=0.06405 ps=0.725 w=0.42 l=0.15
X4833 th_dif_sw_0.VCP single_9b_cdac_1.cdac_sw_9b_0.S[0] sky130_fd_pr__cap_mim_m3_1 l=2 w=2
X4834 th_dif_sw_0.VCN single_9b_cdac_0.cdac_sw_9b_0.S[0] sky130_fd_pr__cap_mim_m3_1 l=2 w=2
X4835 a_33936_26999# single_9b_cdac_0.SW[6] VDPWR VDPWR sky130_fd_pr__pfet_01v8 ad=0.435 pd=3.58 as=0.435 ps=3.58 w=1.5 l=0.5
X4836 VGND single_9b_cdac_1.cdac_sw_9b_0.cdac_sw_3_5.nooverlap_clk_0.CLKB0 single_9b_cdac_1.cdac_sw_9b_0.cdac_sw_3_5.nooverlap_clk_0.CLK0 VGND sky130_fd_pr__nfet_01v8_lvt ad=0.1295 pd=1.09 as=0.1036 ps=1.02 w=0.74 l=0.15
X4837 a_6169_26758# a_5951_26516# VGND VGND sky130_fd_pr__nfet_01v8 ad=0.0999 pd=0.985 as=0.1346 ps=1.15 w=0.64 l=0.15
X4838 single_9b_cdac_0.cdac_sw_9b_0.cdac_sw_3_6.tg_sw_3_3.SWP single_9b_cdac_0.cdac_sw_9b_0.cdac_sw_3_6.tg_sw_3_3.SWN VGND VGND sky130_fd_pr__nfet_01v8_lvt ad=0.1036 pd=1.02 as=0.2146 ps=2.06 w=0.74 l=0.15
X4839 single_9b_cdac_0.cdac_sw_9b_0.cdac_sw_3_5.nooverlap_clk_0.sky130_fd_sc_hs__inv_8_0.A single_9b_cdac_0.cdac_sw_9b_0.cdac_sw_3_5.nooverlap_clk_0.x1.A VDPWR VDPWR sky130_fd_pr__pfet_01v8 ad=0.168 pd=1.42 as=0.3304 ps=2.83 w=1.12 l=0.15
X4840 VDPWR sar9b_0.clk_div_0.COUNT\[3\] sar9b_0._06_ VDPWR sky130_fd_pr__pfet_01v8_hvt ad=0.26 pd=2.52 as=0.135 ps=1.27 w=1 l=0.15
X4841 a_9368_19822# a_8453_19450# a_9021_19418# VGND sky130_fd_pr__special_nfet_01v8 ad=0.0711 pd=0.755 as=0.0999 ps=0.985 w=0.36 l=0.15
X4842 single_9b_cdac_1.cdac_sw_9b_0.S[3] single_9b_cdac_1.cdac_sw_9b_0.cdac_sw_3_4.tg_sw_3_3.SWN ua[0] VDPWR sky130_fd_pr__pfet_01v8 ad=0.435 pd=3.58 as=0.435 ps=3.58 w=1.5 l=0.5
X4843 th_dif_sw_0.VCP single_9b_cdac_1.cdac_sw_9b_0.S[1] sky130_fd_pr__cap_mim_m3_1 l=2 w=2
X4844 th_dif_sw_0.VCN single_9b_cdac_0.cdac_sw_9b_0.S[1] sky130_fd_pr__cap_mim_m3_1 l=2 w=2
X4845 single_9b_cdac_1.cdac_sw_9b_0.S[0] single_9b_cdac_1.cdac_sw_9b_0.cdac_sw_3_2.nooverlap_clk_0.CLKB0 a_62748_16877# VDPWR sky130_fd_pr__pfet_01v8 ad=0.435 pd=3.58 as=0.435 ps=3.58 w=1.5 l=0.5
X4846 a_6047_26516# a_5601_26516# a_5951_26516# VGND sky130_fd_pr__special_nfet_01v8 ad=0.1401 pd=1.1 as=0.0594 ps=0.69 w=0.36 l=0.15
X4847 VGND sar9b_0.net37 a_13071_20532# VGND sky130_fd_pr__nfet_01v8 ad=0.0754 pd=0.81 as=0.1352 ps=1.56 w=0.52 l=0.15
X4848 th_dif_sw_0.VCP single_9b_cdac_1.cdac_sw_9b_0.S[1] sky130_fd_pr__cap_mim_m3_1 l=2 w=2
X4849 a_9635_26276# a_9460_26350# a_9814_26338# VGND sky130_fd_pr__nfet_01v8 ad=0.1092 pd=1.36 as=0.06405 ps=0.725 w=0.42 l=0.15
X4850 VDPWR VGND VDPWR VDPWR sky130_fd_pr__pfet_01v8_hvt ad=0.2262 pd=2.26 as=0 ps=0 w=0.87 l=0.59
X4851 VGND VDPWR VGND VGND sky130_fd_pr__nfet_01v8 ad=0.143 pd=1.62 as=0 ps=0 w=0.55 l=0.59
X4852 th_dif_sw_0.VCN single_9b_cdac_0.cdac_sw_9b_0.S[0] sky130_fd_pr__cap_mim_m3_1 l=2 w=2
X4853 a_6759_20354# a_6061_19988# a_6502_20124# VGND sky130_fd_pr__special_nfet_01v8 ad=0.0657 pd=0.725 as=0.0989 ps=0.995 w=0.36 l=0.15
X4854 th_dif_sw_0.VCN single_9b_cdac_0.cdac_sw_9b_0.S[0] sky130_fd_pr__cap_mim_m3_1 l=2 w=2
X4855 VDPWR VGND VDPWR VDPWR sky130_fd_pr__pfet_01v8_hvt ad=0.2262 pd=2.26 as=0 ps=0 w=0.87 l=0.59
X4856 VGND single_9b_cdac_0.cdac_sw_9b_0.cdac_sw_3_8.nooverlap_clk_0.sky130_fd_sc_hs__inv_8_0.A single_9b_cdac_0.cdac_sw_9b_0.cdac_sw_3_8.nooverlap_clk_0.CLKB0 VGND sky130_fd_pr__nfet_01v8_lvt ad=0.1295 pd=1.09 as=0.1036 ps=1.02 w=0.74 l=0.15
X4857 VGND single_9b_cdac_0.cdac_sw_9b_0.cdac_sw_3_3.nooverlap_clk_0.x8.A single_9b_cdac_0.cdac_sw_9b_0.cdac_sw_3_3.nooverlap_clk_0.x10.A VGND sky130_fd_pr__nfet_01v8_lvt ad=0.1221 pd=1.07 as=0.1036 ps=1.02 w=0.74 l=0.15
X4858 VDPWR single_9b_cdac_0.cdac_sw_9b_0.cdac_sw_3_8.nooverlap_clk_0.x10.A single_9b_cdac_0.cdac_sw_9b_0.cdac_sw_3_8.tg_sw_3_3.SWN VDPWR sky130_fd_pr__pfet_01v8 ad=0.3304 pd=2.83 as=0.168 ps=1.42 w=1.12 l=0.15
X4859 VGND sar9b_0.net15 a_9157_24340# VGND sky130_fd_pr__nfet_01v8 ad=0.1346 pd=1.15 as=0.0441 ps=0.63 w=0.42 l=0.15
X4860 ua[0] single_9b_cdac_1.cdac_sw_9b_0.cdac_sw_3_6.tg_sw_3_3.SWP ua[0] VDPWR sky130_fd_pr__pfet_01v8 ad=0.435 pd=3.58 as=0 ps=0 w=1.5 l=0.5
X4861 single_9b_cdac_1.cdac_sw_9b_0.cdac_sw_3_3.nooverlap_clk_0.sky130_fd_sc_hs__inv_8_0.A single_9b_cdac_1.cdac_sw_9b_0.cdac_sw_3_3.nooverlap_clk_0.x1.A VGND VGND sky130_fd_pr__nfet_01v8_lvt ad=0.1036 pd=1.02 as=0.1221 ps=1.07 w=0.74 l=0.15
X4862 a_6401_27426# sar9b_0.net3 VGND VGND sky130_fd_pr__nfet_01v8 ad=0.0441 pd=0.63 as=0.1346 ps=1.15 w=0.42 l=0.15
X4863 VGND VDPWR VGND VGND sky130_fd_pr__nfet_01v8 ad=0.143 pd=1.62 as=0 ps=0 w=0.55 l=0.59
X4864 VGND VDPWR VGND VGND sky130_fd_pr__nfet_01v8 ad=0.143 pd=1.62 as=0 ps=0 w=0.55 l=0.59
X4865 single_9b_cdac_1.cdac_sw_9b_0.S[2] single_9b_cdac_1.cdac_sw_9b_0.cdac_sw_3_0.nooverlap_clk_0.CLKB0 a_53154_16877# VDPWR sky130_fd_pr__pfet_01v8 ad=0.435 pd=3.58 as=0.435 ps=3.58 w=1.5 l=0.5
X4866 a_21177_7457# th_dif_sw_0.CKB VGND VGND sky130_fd_pr__nfet_01v8_lvt ad=0.1295 pd=1.09 as=0.11655 ps=1.055 w=0.74 l=0.15
X4867 VDPWR single_9b_cdac_1.cdac_sw_9b_0.cdac_sw_3_2.tg_sw_3_3.SWN single_9b_cdac_1.cdac_sw_9b_0.cdac_sw_3_2.tg_sw_3_3.SWP VDPWR sky130_fd_pr__pfet_01v8 ad=0.196 pd=1.47 as=0.168 ps=1.42 w=1.12 l=0.15
X4868 a_14077_25428# a_12887_25428# a_13968_25428# VGND sky130_fd_pr__special_nfet_01v8 ad=0.0669 pd=0.75 as=0.0711 ps=0.755 w=0.36 l=0.15
X4869 a_11567_19748# sar9b_0.net15 VDPWR VDPWR sky130_fd_pr__pfet_01v8_hvt ad=0.0567 pd=0.69 as=0.0819 ps=0.81 w=0.42 l=0.15
X4870 dw_17224_1400# a_21368_4076# sky130_fd_pr__cap_mim_m3_1 l=2 w=2
X4871 th_dif_sw_0.VCN single_9b_cdac_0.cdac_sw_9b_0.S[1] sky130_fd_pr__cap_mim_m3_1 l=2 w=2
X4872 single_9b_cdac_0.cdac_sw_9b_0.cdac_sw_3_8.tg_sw_3_3.SWN single_9b_cdac_0.cdac_sw_9b_0.cdac_sw_3_8.nooverlap_clk_0.x10.A VDPWR VDPWR sky130_fd_pr__pfet_01v8 ad=0.168 pd=1.42 as=0.196 ps=1.47 w=1.12 l=0.15
X4873 single_9b_cdac_0.cdac_sw_9b_0.cdac_sw_3_3.nooverlap_clk_0.CLK0 single_9b_cdac_0.cdac_sw_9b_0.cdac_sw_3_3.nooverlap_clk_0.CLKB0 VGND VGND sky130_fd_pr__nfet_01v8_lvt ad=0.1036 pd=1.02 as=0.1554 ps=1.16 w=0.74 l=0.15
X4874 single_9b_cdac_1.cdac_sw_9b_0.cdac_sw_3_3.nooverlap_clk_0.CLKB0 single_9b_cdac_1.cdac_sw_9b_0.cdac_sw_3_3.nooverlap_clk_0.sky130_fd_sc_hs__inv_8_0.A VGND VGND sky130_fd_pr__nfet_01v8_lvt ad=0.1036 pd=1.02 as=0.1295 ps=1.09 w=0.74 l=0.15
X4875 VGND single_9b_cdac_1.cdac_sw_9b_0.cdac_sw_3_1.tg_sw_3_3.SWN single_9b_cdac_1.cdac_sw_9b_0.cdac_sw_3_1.tg_sw_3_3.SWP VGND sky130_fd_pr__nfet_01v8_lvt ad=0.1554 pd=1.16 as=0.1036 ps=1.02 w=0.74 l=0.15
X4876 a_58824_26990# single_9b_cdac_0.cdac_sw_9b_0.cdac_sw_3_1.nooverlap_clk_0.CLK0 single_9b_cdac_0.cdac_sw_9b_0.S[1] VGND sky130_fd_pr__nfet_01v8 ad=0.145 pd=1.58 as=0.145 ps=1.58 w=0.5 l=0.5
X4877 a_12207_26350# a_11857_25978# a_12112_26338# VDPWR sky130_fd_pr__pfet_01v8_hvt ad=0.07245 pd=0.765 as=0.0651 ps=0.73 w=0.42 l=0.15
X4878 VDPWR sar9b_0.clknet_0_CLK a_6149_23770# VDPWR sky130_fd_pr__pfet_01v8_hvt ad=0.265 pd=2.53 as=0.14 ps=1.28 w=1 l=0.15
X4879 VDPWR a_11392_23252# a_11567_23226# VDPWR sky130_fd_pr__pfet_01v8_hvt ad=0.1134 pd=1.38 as=0.0567 ps=0.69 w=0.42 l=0.15
X4880 single_9b_cdac_1.cdac_sw_9b_0.cdac_sw_3_4.nooverlap_clk_0.CLK0 single_9b_cdac_1.cdac_sw_9b_0.cdac_sw_3_4.nooverlap_clk_0.CLKB0 VGND VGND sky130_fd_pr__nfet_01v8_lvt ad=0.1036 pd=1.02 as=0.1554 ps=1.16 w=0.74 l=0.15
X4881 single_9b_cdac_1.cdac_sw_9b_0.cdac_sw_3_2.tg_sw_3_3.SWP single_9b_cdac_1.cdac_sw_9b_0.cdac_sw_3_2.tg_sw_3_3.SWN VDPWR VDPWR sky130_fd_pr__pfet_01v8 ad=0.168 pd=1.42 as=0.168 ps=1.42 w=1.12 l=0.15
X4882 VGND single_9b_cdac_0.SW[1] a_58824_26990# VGND sky130_fd_pr__nfet_01v8 ad=0.145 pd=1.58 as=0.145 ps=1.58 w=0.5 l=0.5
X4883 single_9b_cdac_1.cdac_sw_9b_0.S[3] single_9b_cdac_1.cdac_sw_9b_0.cdac_sw_3_4.tg_sw_3_3.SWN single_9b_cdac_1.cdac_sw_9b_0.S[3] VGND sky130_fd_pr__nfet_01v8 ad=0.145 pd=1.58 as=0 ps=0 w=0.5 l=0.5
X4884 VGND sar9b_0.clk_div_0.COUNT\[1\] a_7817_23252# VGND sky130_fd_pr__nfet_01v8 ad=0.10725 pd=0.98 as=0.08775 ps=0.92 w=0.65 l=0.15
X4885 VGND VDPWR VGND VGND sky130_fd_pr__nfet_01v8 ad=0.143 pd=1.62 as=0 ps=0 w=0.55 l=0.59
X4886 single_9b_cdac_0.cdac_sw_9b_0.S[4] single_9b_cdac_0.cdac_sw_9b_0.cdac_sw_3_3.tg_sw_3_3.SWP single_9b_cdac_0.cdac_sw_9b_0.S[4] VDPWR sky130_fd_pr__pfet_01v8 ad=0.435 pd=3.58 as=0 ps=0 w=1.5 l=0.5
X4887 a_8526_23770# a_8358_23796# VDPWR VDPWR sky130_fd_pr__pfet_01v8_hvt ad=0.1095 pd=1.075 as=0.17887 ps=1.26 w=0.75 l=0.15
X4888 a_13403_23086# a_12887_22714# a_13308_23074# VGND sky130_fd_pr__special_nfet_01v8 ad=0.0594 pd=0.69 as=0.066 ps=0.745 w=0.36 l=0.15
X4889 single_9b_cdac_1.cdac_sw_9b_0.cdac_sw_3_8.nooverlap_clk_0.CLKB0 single_9b_cdac_1.cdac_sw_9b_0.cdac_sw_3_8.nooverlap_clk_0.sky130_fd_sc_hs__inv_8_0.A VGND VGND sky130_fd_pr__nfet_01v8_lvt ad=0.1036 pd=1.02 as=0.2109 ps=2.05 w=0.74 l=0.15
X4890 single_9b_cdac_1.cdac_sw_9b_0.S[7] single_9b_cdac_1.cdac_sw_9b_0.cdac_sw_3_7.tg_sw_3_3.SWP ua[0] VGND sky130_fd_pr__nfet_01v8 ad=0.145 pd=1.58 as=0.145 ps=1.58 w=0.5 l=0.5
X4891 th_dif_sw_0.VCP single_9b_cdac_1.cdac_sw_9b_0.S[1] sky130_fd_pr__cap_mim_m3_1 l=2 w=2
X4892 a_6943_22316# sar9b_0.clk_div_0.COUNT\[2\] VGND VGND sky130_fd_pr__nfet_01v8 ad=0.1092 pd=1.36 as=0.06195 ps=0.715 w=0.42 l=0.15
X4893 VDPWR a_6930_20241# sar9b_0.net15 VDPWR sky130_fd_pr__pfet_01v8_hvt ad=0.28 pd=2.56 as=0.135 ps=1.27 w=1 l=0.15
X4894 VDPWR single_9b_cdac_1.cdac_sw_9b_0.cdac_sw_3_2.tg_sw_3_3.SWN single_9b_cdac_1.cdac_sw_9b_0.cdac_sw_3_2.tg_sw_3_3.SWP VDPWR sky130_fd_pr__pfet_01v8 ad=0.168 pd=1.42 as=0.168 ps=1.42 w=1.12 l=0.15
X4895 VDPWR sar9b_0._09_ a_6451_21326# VDPWR sky130_fd_pr__pfet_01v8_hvt ad=0.14 pd=1.28 as=0.265 ps=2.53 w=1 l=0.15
X4896 single_9b_cdac_1.SW[5] a_13899_20532# VDPWR VDPWR sky130_fd_pr__pfet_01v8_hvt ad=0.2054 pd=2.1 as=0.11455 ps=1.08 w=0.79 l=0.15
X4897 single_9b_cdac_1.cdac_sw_9b_0.S[8] single_9b_cdac_1.cdac_sw_9b_0.cdac_sw_3_8.tg_sw_3_3.SWN ua[0] VDPWR sky130_fd_pr__pfet_01v8 ad=0.435 pd=3.58 as=0.435 ps=3.58 w=1.5 l=0.5
X4898 th_dif_sw_0.VCP single_9b_cdac_1.cdac_sw_9b_0.S[0] sky130_fd_pr__cap_mim_m3_1 l=2 w=2
X4899 th_dif_sw_0.VCN single_9b_cdac_0.cdac_sw_9b_0.S[2] sky130_fd_pr__cap_mim_m3_1 l=2 w=2
X4900 VGND single_9b_cdac_1.CF[6] single_9b_cdac_0.cdac_sw_9b_0.cdac_sw_3_6.nooverlap_clk_0.x3.Y VGND sky130_fd_pr__nfet_01v8_lvt ad=0.2627 pd=2.19 as=0.2109 ps=2.05 w=0.74 l=0.15
X4901 th_dif_sw_0.VCN single_9b_cdac_0.cdac_sw_9b_0.S[0] sky130_fd_pr__cap_mim_m3_1 l=2 w=2
X4902 single_9b_cdac_0.cdac_sw_9b_0.cdac_sw_3_7.tg_sw_3_3.SWN single_9b_cdac_0.cdac_sw_9b_0.cdac_sw_3_7.nooverlap_clk_0.x10.A VGND VGND sky130_fd_pr__nfet_01v8_lvt ad=0.1036 pd=1.02 as=0.1554 ps=1.16 w=0.74 l=0.15
X4903 single_9b_cdac_0.SW[0] a_13623_24340# VDPWR VDPWR sky130_fd_pr__pfet_01v8_hvt ad=0.2054 pd=2.1 as=0.11455 ps=1.08 w=0.79 l=0.15
X4904 a_8358_23796# a_8085_23802# a_8273_23796# VDPWR sky130_fd_pr__pfet_01v8_hvt ad=0.06825 pd=0.745 as=0.05775 ps=0.695 w=0.42 l=0.15
X4905 single_9b_cdac_1.cdac_sw_9b_0.S[4] single_9b_cdac_1.cdac_sw_9b_0.cdac_sw_3_3.tg_sw_3_3.SWN single_9b_cdac_1.cdac_sw_9b_0.S[4] VGND sky130_fd_pr__nfet_01v8 ad=0.145 pd=1.58 as=0 ps=0 w=0.5 l=0.5
X4906 VDPWR single_9b_cdac_1.cdac_sw_9b_0.cdac_sw_3_4.nooverlap_clk_0.sky130_fd_sc_hs__inv_8_0.A single_9b_cdac_1.cdac_sw_9b_0.cdac_sw_3_4.nooverlap_clk_0.CLKB0 VDPWR sky130_fd_pr__pfet_01v8 ad=0.3864 pd=2.93 as=0.168 ps=1.42 w=1.12 l=0.15
X4907 single_9b_cdac_1.cdac_sw_9b_0.cdac_sw_3_2.tg_sw_3_3.SWP single_9b_cdac_1.cdac_sw_9b_0.cdac_sw_3_2.tg_sw_3_3.SWN VDPWR VDPWR sky130_fd_pr__pfet_01v8 ad=0.168 pd=1.42 as=0.196 ps=1.47 w=1.12 l=0.15
X4908 th_dif_sw_0.VCN single_9b_cdac_0.cdac_sw_9b_0.S[0] sky130_fd_pr__cap_mim_m3_1 l=2 w=2
X4909 VGND sar9b_0.net7 a_12887_21076# VGND sky130_fd_pr__nfet_01v8 ad=0.0567 pd=0.69 as=0.1092 ps=1.36 w=0.42 l=0.15
X4910 single_9b_cdac_1.cdac_sw_9b_0.cdac_sw_3_4.nooverlap_clk_0.CLKB0 single_9b_cdac_1.cdac_sw_9b_0.cdac_sw_3_4.nooverlap_clk_0.sky130_fd_sc_hs__inv_8_0.A VDPWR VDPWR sky130_fd_pr__pfet_01v8 ad=0.168 pd=1.42 as=0.196 ps=1.47 w=1.12 l=0.15
X4911 single_9b_cdac_0.cdac_sw_9b_0.S[8] single_9b_cdac_0.cdac_sw_9b_0.cdac_sw_3_8.tg_sw_3_3.SWP single_9b_cdac_0.cdac_sw_9b_0.S[8] VDPWR sky130_fd_pr__pfet_01v8 ad=0.435 pd=3.58 as=0 ps=0 w=1.5 l=0.5
X4912 VGND sar9b_0.net12 a_14175_23252# VGND sky130_fd_pr__nfet_01v8 ad=0.0754 pd=0.81 as=0.1352 ps=1.56 w=0.52 l=0.15
X4913 single_9b_cdac_1.SW[8] a_13071_21620# VDPWR VDPWR sky130_fd_pr__pfet_01v8_hvt ad=0.2054 pd=2.1 as=0.11455 ps=1.08 w=0.79 l=0.15
X4914 VGND VDPWR VGND VGND sky130_fd_pr__nfet_01v8 ad=0.143 pd=1.62 as=0 ps=0 w=0.55 l=0.59
X4915 ua[0] single_9b_cdac_0.cdac_sw_9b_0.cdac_sw_3_7.tg_sw_3_3.SWN ua[0] VGND sky130_fd_pr__nfet_01v8 ad=0.145 pd=1.58 as=0 ps=0 w=0.5 l=0.5
X4916 a_6888_19988# a_5895_19988# a_6759_20354# VGND sky130_fd_pr__special_nfet_01v8 ad=0.066 pd=0.745 as=0.0657 ps=0.725 w=0.36 l=0.15
X4917 VDPWR single_9b_cdac_1.cdac_sw_9b_0.cdac_sw_3_4.tg_sw_3_3.SWN single_9b_cdac_1.cdac_sw_9b_0.cdac_sw_3_4.tg_sw_3_3.SWP VDPWR sky130_fd_pr__pfet_01v8 ad=0.196 pd=1.47 as=0.168 ps=1.42 w=1.12 l=0.15
X4918 th_dif_sw_0.VCN single_9b_cdac_0.cdac_sw_9b_0.S[0] sky130_fd_pr__cap_mim_m3_1 l=2 w=2
X4919 single_9b_cdac_1.cdac_sw_9b_0.S[3] single_9b_cdac_1.cdac_sw_9b_0.cdac_sw_3_4.tg_sw_3_3.SWP single_9b_cdac_1.cdac_sw_9b_0.S[3] VDPWR sky130_fd_pr__pfet_01v8 ad=0.435 pd=3.58 as=0 ps=0 w=1.5 l=0.5
X4920 th_dif_sw_0.VCP single_9b_cdac_1.cdac_sw_9b_0.S[0] sky130_fd_pr__cap_mim_m3_1 l=2 w=2
X4921 sar9b_0.clk_div_0.COUNT\[2\] a_7203_22682# VDPWR VDPWR sky130_fd_pr__pfet_01v8_hvt ad=0.26 pd=2.52 as=0.135 ps=1.27 w=1 l=0.15
X4922 single_9b_cdac_1.cdac_sw_9b_0.cdac_sw_3_8.tg_sw_3_3.SWN single_9b_cdac_1.cdac_sw_9b_0.cdac_sw_3_8.nooverlap_clk_0.x10.A VDPWR VDPWR sky130_fd_pr__pfet_01v8 ad=0.168 pd=1.42 as=0.3304 ps=2.83 w=1.12 l=0.15
X4923 th_dif_sw_0.VCP single_9b_cdac_1.cdac_sw_9b_0.S[2] sky130_fd_pr__cap_mim_m3_1 l=2 w=2
X4924 th_dif_sw_0.VCP single_9b_cdac_1.cdac_sw_9b_0.S[4] sky130_fd_pr__cap_mim_m3_1 l=2 w=2
X4925 sar9b_0.net12 a_9635_24314# VDPWR VDPWR sky130_fd_pr__pfet_01v8_hvt ad=0.26 pd=2.52 as=0.3012 ps=2.66 w=1 l=0.15
X4926 VDPWR single_9b_cdac_1.cdac_sw_9b_0.cdac_sw_3_7.nooverlap_clk_0.sky130_fd_sc_hs__inv_8_0.A single_9b_cdac_1.cdac_sw_9b_0.cdac_sw_3_7.nooverlap_clk_0.CLKB0 VDPWR sky130_fd_pr__pfet_01v8 ad=0.196 pd=1.47 as=0.168 ps=1.42 w=1.12 l=0.15
X4927 single_9b_cdac_1.cdac_sw_9b_0.cdac_sw_3_4.tg_sw_3_3.SWP single_9b_cdac_1.cdac_sw_9b_0.cdac_sw_3_4.tg_sw_3_3.SWN VDPWR VDPWR sky130_fd_pr__pfet_01v8 ad=0.168 pd=1.42 as=0.3304 ps=2.83 w=1.12 l=0.15
X4928 VGND sar9b_0.net6 a_13623_21620# VGND sky130_fd_pr__nfet_01v8 ad=0.0754 pd=0.81 as=0.1352 ps=1.56 w=0.52 l=0.15
X4929 VGND single_9b_cdac_1.cdac_sw_9b_0.cdac_sw_3_3.tg_sw_3_3.SWN single_9b_cdac_1.cdac_sw_9b_0.cdac_sw_3_3.tg_sw_3_3.SWP VGND sky130_fd_pr__nfet_01v8_lvt ad=0.1295 pd=1.09 as=0.1036 ps=1.02 w=0.74 l=0.15
X4930 a_11760_25428# a_10679_25428# a_11413_25670# VDPWR sky130_fd_pr__pfet_01v8_hvt ad=0.0588 pd=0.7 as=0.12915 ps=1.185 w=0.42 l=0.15
X4931 single_9b_cdac_1.cdac_sw_9b_0.cdac_sw_3_7.nooverlap_clk_0.CLKB0 single_9b_cdac_1.cdac_sw_9b_0.cdac_sw_3_7.nooverlap_clk_0.sky130_fd_sc_hs__inv_8_0.A VDPWR VDPWR sky130_fd_pr__pfet_01v8 ad=0.168 pd=1.42 as=0.168 ps=1.42 w=1.12 l=0.15
X4932 single_9b_cdac_1.cdac_sw_9b_0.cdac_sw_3_6.nooverlap_clk_0.CLKB0 single_9b_cdac_1.cdac_sw_9b_0.cdac_sw_3_6.nooverlap_clk_0.sky130_fd_sc_hs__inv_8_0.A VGND VGND sky130_fd_pr__nfet_01v8_lvt ad=0.1036 pd=1.02 as=0.1554 ps=1.16 w=0.74 l=0.15
X4933 VGND single_9b_cdac_1.cdac_sw_9b_0.cdac_sw_3_0.nooverlap_clk_0.sky130_fd_sc_hs__inv_8_0.A single_9b_cdac_1.cdac_sw_9b_0.cdac_sw_3_0.nooverlap_clk_0.CLKB0 VGND sky130_fd_pr__nfet_01v8_lvt ad=0.2146 pd=2.06 as=0.1036 ps=1.02 w=0.74 l=0.15
X4934 th_dif_sw_0.VCN single_9b_cdac_0.cdac_sw_9b_0.S[1] sky130_fd_pr__cap_mim_m3_1 l=2 w=2
X4935 a_6451_21326# sar9b_0.net15 VDPWR VDPWR sky130_fd_pr__pfet_01v8_hvt ad=0.135 pd=1.27 as=0.14 ps=1.28 w=1 l=0.15
X4936 a_10935_19444# sar9b_0.net15 VDPWR VDPWR sky130_fd_pr__pfet_01v8_hvt ad=0.1092 pd=1.36 as=0.07035 ps=0.755 w=0.42 l=0.15
X4937 a_12837_18722# a_12793_18330# a_12671_18734# VGND sky130_fd_pr__nfet_01v8 ad=0.0441 pd=0.63 as=0.1401 ps=1.1 w=0.42 l=0.15
X4938 VDPWR VGND VDPWR VDPWR sky130_fd_pr__pfet_01v8_hvt ad=0.2262 pd=2.26 as=0 ps=0 w=0.87 l=0.59
X4939 VGND single_9b_cdac_1.cdac_sw_9b_0.cdac_sw_3_1.nooverlap_clk_0.CLKB0 single_9b_cdac_1.cdac_sw_9b_0.cdac_sw_3_1.nooverlap_clk_0.CLK0 VGND sky130_fd_pr__nfet_01v8_lvt ad=0.2146 pd=2.06 as=0.1036 ps=1.02 w=0.74 l=0.15
X4940 a_5924_27060# a_5487_27034# VDPWR VDPWR sky130_fd_pr__pfet_01v8_hvt ad=0.0567 pd=0.69 as=0.0819 ps=0.81 w=0.42 l=0.15
X4941 VGND single_9b_cdac_0.cdac_sw_9b_0.cdac_sw_3_8.nooverlap_clk_0.sky130_fd_sc_hs__inv_8_0.A single_9b_cdac_0.cdac_sw_9b_0.cdac_sw_3_8.nooverlap_clk_0.CLKB0 VGND sky130_fd_pr__nfet_01v8_lvt ad=0.2109 pd=2.05 as=0.1036 ps=1.02 w=0.74 l=0.15
X4942 ua[0] single_9b_cdac_0.cdac_sw_9b_0.cdac_sw_3_5.tg_sw_3_3.SWN ua[0] VGND sky130_fd_pr__nfet_01v8 ad=0.145 pd=1.58 as=0 ps=0 w=0.5 l=0.5
X4943 VGND single_9b_cdac_0.SW[0] a_63626_26990# VGND sky130_fd_pr__nfet_01v8 ad=0.145 pd=1.58 as=0.145 ps=1.58 w=0.5 l=0.5
X4944 a_11567_23226# a_11392_23252# a_11746_23252# VGND sky130_fd_pr__nfet_01v8 ad=0.1092 pd=1.36 as=0.06405 ps=0.725 w=0.42 l=0.15
X4945 sar9b_0.net29 a_14143_22138# VDPWR VDPWR sky130_fd_pr__pfet_01v8_hvt ad=0.26 pd=2.52 as=0.3012 ps=2.66 w=1 l=0.15
X4946 VDPWR single_9b_cdac_1.cdac_sw_9b_0.cdac_sw_3_7.nooverlap_clk_0.sky130_fd_sc_hs__inv_8_0.A single_9b_cdac_1.cdac_sw_9b_0.cdac_sw_3_7.nooverlap_clk_0.CLKB0 VDPWR sky130_fd_pr__pfet_01v8 ad=0.168 pd=1.42 as=0.168 ps=1.42 w=1.12 l=0.15
X4947 th_dif_sw_0.VCN single_9b_cdac_0.cdac_sw_9b_0.S[0] sky130_fd_pr__cap_mim_m3_1 l=2 w=2
X4948 a_58824_17740# single_9b_cdac_1.cdac_sw_9b_0.cdac_sw_3_1.nooverlap_clk_0.CLK0 single_9b_cdac_1.cdac_sw_9b_0.S[1] VGND sky130_fd_pr__nfet_01v8 ad=0.145 pd=1.58 as=0.145 ps=1.58 w=0.5 l=0.5
X4949 single_9b_cdac_0.cdac_sw_9b_0.S[5] single_9b_cdac_0.cdac_sw_9b_0.cdac_sw_3_5.tg_sw_3_3.SWP single_9b_cdac_0.cdac_sw_9b_0.S[5] VDPWR sky130_fd_pr__pfet_01v8 ad=0.435 pd=3.58 as=0 ps=0 w=1.5 l=0.5
X4950 single_9b_cdac_0.cdac_sw_9b_0.cdac_sw_3_5.nooverlap_clk_0.sky130_fd_sc_hs__inv_8_0.A single_9b_cdac_0.cdac_sw_9b_0.cdac_sw_3_5.nooverlap_clk_0.x1.A VGND VGND sky130_fd_pr__nfet_01v8_lvt ad=0.1184 pd=1.06 as=0.1221 ps=1.07 w=0.74 l=0.15
X4951 VGND a_9503_20506# a_9461_20910# VGND sky130_fd_pr__nfet_01v8 ad=0.1092 pd=1.36 as=0.066 ps=0.745 w=0.42 l=0.15
X4952 single_9b_cdac_1.cdac_sw_9b_0.S[6] single_9b_cdac_1.cdac_sw_9b_0.cdac_sw_3_6.tg_sw_3_3.SWP ua[0] VGND sky130_fd_pr__nfet_01v8 ad=0.145 pd=1.58 as=0.145 ps=1.58 w=0.5 l=0.5
X4953 th_dif_sw_0.VCP single_9b_cdac_1.cdac_sw_9b_0.S[0] sky130_fd_pr__cap_mim_m3_1 l=2 w=2
X4954 th_dif_sw_0.VCP single_9b_cdac_1.cdac_sw_9b_0.S[1] sky130_fd_pr__cap_mim_m3_1 l=2 w=2
X4955 th_dif_sw_0.VCN single_9b_cdac_0.cdac_sw_9b_0.S[2] sky130_fd_pr__cap_mim_m3_1 l=2 w=2
X4956 sar9b_0.net14 a_13379_27398# VDPWR VDPWR sky130_fd_pr__pfet_01v8_hvt ad=0.475 pd=2.95 as=0.16655 ps=1.39 w=1 l=0.15
X4957 VGND single_9b_cdac_0.cdac_sw_9b_0.cdac_sw_3_8.tg_sw_3_3.SWN single_9b_cdac_0.cdac_sw_9b_0.cdac_sw_3_8.tg_sw_3_3.SWP VGND sky130_fd_pr__nfet_01v8_lvt ad=0.1554 pd=1.16 as=0.1036 ps=1.02 w=0.74 l=0.15
X4958 single_9b_cdac_0.cdac_sw_9b_0.cdac_sw_3_2.nooverlap_clk_0.CLKB0 single_9b_cdac_0.cdac_sw_9b_0.cdac_sw_3_2.nooverlap_clk_0.sky130_fd_sc_hs__inv_8_0.A VGND VGND sky130_fd_pr__nfet_01v8_lvt ad=0.1036 pd=1.02 as=0.1036 ps=1.02 w=0.74 l=0.15
X4959 VDPWR VGND VDPWR VDPWR sky130_fd_pr__pfet_01v8_hvt ad=0.2262 pd=2.26 as=0 ps=0 w=0.87 l=0.59
X4960 single_9b_cdac_1.cdac_sw_9b_0.cdac_sw_3_7.nooverlap_clk_0.CLKB0 single_9b_cdac_1.cdac_sw_9b_0.cdac_sw_3_7.nooverlap_clk_0.sky130_fd_sc_hs__inv_8_0.A VDPWR VDPWR sky130_fd_pr__pfet_01v8 ad=0.168 pd=1.42 as=0.196 ps=1.47 w=1.12 l=0.15
X4961 a_14130_20354# a_13053_19988# a_13968_19988# VDPWR sky130_fd_pr__pfet_01v8_hvt ad=0.0567 pd=0.69 as=0.0588 ps=0.7 w=0.42 l=0.15
X4962 th_dif_sw_0.VCN single_9b_cdac_0.cdac_sw_9b_0.S[1] sky130_fd_pr__cap_mim_m3_1 l=2 w=2
X4963 single_9b_cdac_0.cdac_sw_9b_0.S[5] single_9b_cdac_0.cdac_sw_9b_0.cdac_sw_3_5.tg_sw_3_3.SWN single_9b_cdac_0.cdac_sw_9b_0.S[5] VGND sky130_fd_pr__nfet_01v8 ad=0.145 pd=1.58 as=0 ps=0 w=0.5 l=0.5
X4964 VGND sar9b_0.net15 a_9249_23252# VGND sky130_fd_pr__nfet_01v8 ad=0.1346 pd=1.15 as=0.0441 ps=0.63 w=0.42 l=0.15
X4965 th_dif_sw_0.VCN single_9b_cdac_0.cdac_sw_9b_0.S[8] sky130_fd_pr__cap_mim_m3_1 l=2 w=2
X4966 VGND single_9b_cdac_0.cdac_sw_9b_0.cdac_sw_3_1.nooverlap_clk_0.sky130_fd_sc_hs__nand2_1_0.Y single_9b_cdac_0.cdac_sw_9b_0.cdac_sw_3_1.nooverlap_clk_0.sky130_fd_sc_hs__inv_1_1.A VGND sky130_fd_pr__nfet_01v8_lvt ad=0.2627 pd=2.19 as=0.2109 ps=2.05 w=0.74 l=0.15
X4967 VGND VDPWR VGND VGND sky130_fd_pr__nfet_01v8 ad=0.143 pd=1.62 as=0 ps=0 w=0.55 l=0.59
X4968 VGND VDPWR VGND VGND sky130_fd_pr__nfet_01v8 ad=0.143 pd=1.62 as=0 ps=0 w=0.55 l=0.59
X4969 VGND single_9b_cdac_0.cdac_sw_9b_0.cdac_sw_3_6.nooverlap_clk_0.x3.Y a_35519_29917# VGND sky130_fd_pr__nfet_01v8_lvt ad=0.2109 pd=2.05 as=0.0888 ps=0.98 w=0.74 l=0.15
X4970 single_9b_cdac_1.cdac_sw_9b_0.S[8] single_9b_cdac_1.cdac_sw_9b_0.cdac_sw_3_8.tg_sw_3_3.SWP single_9b_cdac_1.cdac_sw_9b_0.S[8] VDPWR sky130_fd_pr__pfet_01v8 ad=0.435 pd=3.58 as=0 ps=0 w=1.5 l=0.5
X4971 VGND a_10371_21050# a_10305_21076# VGND sky130_fd_pr__nfet_01v8 ad=0.12495 pd=1.015 as=0.0669 ps=0.75 w=0.42 l=0.15
X4972 a_11567_21076# a_11121_21076# a_11471_21076# VGND sky130_fd_pr__special_nfet_01v8 ad=0.1401 pd=1.1 as=0.0594 ps=0.69 w=0.36 l=0.15
X4973 th_dif_sw_0.VCP single_9b_cdac_1.cdac_sw_9b_0.S[1] sky130_fd_pr__cap_mim_m3_1 l=2 w=2
X4974 th_dif_sw_0.th_sw_1.CK a_9132_7271# VGND VGND sky130_fd_pr__nfet_01v8_lvt ad=0.1036 pd=1.02 as=0.1036 ps=1.02 w=0.74 l=0.15
X4975 VDPWR a_21177_7457# th_dif_sw_0.th_sw_1.CKB VDPWR sky130_fd_pr__pfet_01v8 ad=0.168 pd=1.42 as=0.168 ps=1.42 w=1.12 l=0.15
X4976 VDPWR single_9b_cdac_0.cdac_sw_9b_0.cdac_sw_3_8.nooverlap_clk_0.CLKB0 single_9b_cdac_0.cdac_sw_9b_0.cdac_sw_3_8.nooverlap_clk_0.CLK0 VDPWR sky130_fd_pr__pfet_01v8 ad=0.3304 pd=2.83 as=0.168 ps=1.42 w=1.12 l=0.15
X4977 a_7119_22708# a_6337_22714# a_7035_22708# VDPWR sky130_fd_pr__pfet_01v8_hvt ad=0.0882 pd=0.84 as=0.0567 ps=0.69 w=0.42 l=0.15
X4978 VGND single_9b_cdac_1.cdac_sw_9b_0.cdac_sw_3_8.nooverlap_clk_0.x8.A single_9b_cdac_1.cdac_sw_9b_0.cdac_sw_3_8.nooverlap_clk_0.x10.A VGND sky130_fd_pr__nfet_01v8_lvt ad=0.1221 pd=1.07 as=0.1184 ps=1.06 w=0.74 l=0.15
X4979 th_dif_sw_0.VCN single_9b_cdac_0.cdac_sw_9b_0.S[0] sky130_fd_pr__cap_mim_m3_1 l=2 w=2
X4980 VDPWR VGND VDPWR VDPWR sky130_fd_pr__pfet_01v8_hvt ad=0.2262 pd=2.26 as=0 ps=0 w=0.87 l=0.59
X4981 single_9b_cdac_1.cdac_sw_9b_0.cdac_sw_3_1.nooverlap_clk_0.x1.A single_9b_cdac_1.cdac_sw_9b_0.cdac_sw_3_1.nooverlap_clk_0.sky130_fd_sc_hs__inv_1_1.A VGND VGND sky130_fd_pr__nfet_01v8_lvt ad=0.2109 pd=2.05 as=0.2627 ps=2.19 w=0.74 l=0.15
X4982 VGND single_9b_cdac_1.cdac_sw_9b_0.cdac_sw_3_8.nooverlap_clk_0.x8.A a_26951_15501# VGND sky130_fd_pr__nfet_01v8_lvt ad=0.2109 pd=2.05 as=0.0888 ps=0.98 w=0.74 l=0.15
X4983 th_dif_sw_0.VCP single_9b_cdac_1.cdac_sw_9b_0.S[0] sky130_fd_pr__cap_mim_m3_1 l=2 w=2
X4984 single_9b_cdac_0.cdac_sw_9b_0.cdac_sw_3_8.nooverlap_clk_0.CLK0 single_9b_cdac_0.cdac_sw_9b_0.cdac_sw_3_8.nooverlap_clk_0.CLKB0 VDPWR VDPWR sky130_fd_pr__pfet_01v8 ad=0.168 pd=1.42 as=0.196 ps=1.47 w=1.12 l=0.15
X4985 single_9b_cdac_0.cdac_sw_9b_0.S[4] single_9b_cdac_0.cdac_sw_9b_0.cdac_sw_3_3.tg_sw_3_3.SWP ua[0] VGND sky130_fd_pr__nfet_01v8 ad=0.145 pd=1.58 as=0.145 ps=1.58 w=0.5 l=0.5
X4986 th_dif_sw_0.VCP single_9b_cdac_1.cdac_sw_9b_0.S[1] sky130_fd_pr__cap_mim_m3_1 l=2 w=2
X4987 th_dif_sw_0.VCP single_9b_cdac_1.cdac_sw_9b_0.S[2] sky130_fd_pr__cap_mim_m3_1 l=2 w=2
X4988 a_13499_22164# a_13053_22164# a_13403_22164# VGND sky130_fd_pr__special_nfet_01v8 ad=0.1401 pd=1.1 as=0.0594 ps=0.69 w=0.36 l=0.15
X4989 a_11652_20898# sar9b_0.net7 VDPWR VDPWR sky130_fd_pr__pfet_01v8_hvt ad=0.0651 pd=0.73 as=0.1092 ps=1.36 w=0.42 l=0.15
X4990 ua[0] single_9b_cdac_1.cdac_sw_9b_0.cdac_sw_3_8.tg_sw_3_3.SWP ua[0] VDPWR sky130_fd_pr__pfet_01v8 ad=0.435 pd=3.58 as=0 ps=0 w=1.5 l=0.5
X4991 th_dif_sw_0.VCP single_9b_cdac_1.cdac_sw_9b_0.S[0] sky130_fd_pr__cap_mim_m3_1 l=2 w=2
X4992 th_dif_sw_0.VCN single_9b_cdac_0.cdac_sw_9b_0.S[0] sky130_fd_pr__cap_mim_m3_1 l=2 w=2
X4993 single_9b_cdac_1.cdac_sw_9b_0.cdac_sw_3_2.nooverlap_clk_0.x8.A single_9b_cdac_1.cdac_sw_9b_0.cdac_sw_3_2.nooverlap_clk_0.x6.A VDPWR VDPWR sky130_fd_pr__pfet_01v8 ad=0.3304 pd=2.83 as=0.3864 ps=2.93 w=1.12 l=0.15
X4994 a_25915_29917# single_9b_cdac_0.cdac_sw_9b_0.cdac_sw_3_8.nooverlap_clk_0.x1.A single_9b_cdac_0.cdac_sw_9b_0.cdac_sw_3_8.nooverlap_clk_0.x4.A VGND sky130_fd_pr__nfet_01v8_lvt ad=0.0888 pd=0.98 as=0.2109 ps=2.05 w=0.74 l=0.15
X4995 a_7620_26350# a_6705_25978# a_7273_25946# VGND sky130_fd_pr__special_nfet_01v8 ad=0.0711 pd=0.755 as=0.0999 ps=0.985 w=0.36 l=0.15
X4996 single_9b_cdac_1.cdac_sw_9b_0.S[6] single_9b_cdac_1.cdac_sw_9b_0.cdac_sw_3_6.nooverlap_clk_0.CLKB0 a_33936_16877# VDPWR sky130_fd_pr__pfet_01v8 ad=0.435 pd=3.58 as=0.435 ps=3.58 w=1.5 l=0.5
X4997 VGND single_9b_cdac_0.cdac_sw_9b_0.cdac_sw_3_4.nooverlap_clk_0.x8.A single_9b_cdac_0.cdac_sw_9b_0.cdac_sw_3_4.nooverlap_clk_0.x10.A VGND sky130_fd_pr__nfet_01v8_lvt ad=0.2331 pd=2.11 as=0.1184 ps=1.06 w=0.74 l=0.15
X4998 VGND VDPWR VGND VGND sky130_fd_pr__nfet_01v8 ad=0.143 pd=1.62 as=0 ps=0 w=0.55 l=0.59
X4999 VDPWR a_6701_20506# sar9b_0.clknet_1_0__leaf_CLK VDPWR sky130_fd_pr__pfet_01v8_hvt ad=0.14 pd=1.28 as=0.14 ps=1.28 w=1 l=0.15
X5000 VGND sar9b_0.net15 a_11089_19810# VGND sky130_fd_pr__nfet_01v8 ad=0.1346 pd=1.15 as=0.0441 ps=0.63 w=0.42 l=0.15
X5001 a_11922_25794# a_10845_25428# a_11760_25428# VDPWR sky130_fd_pr__pfet_01v8_hvt ad=0.0567 pd=0.69 as=0.0588 ps=0.7 w=0.42 l=0.15
X5002 a_10142_20354# a_10016_20256# a_9738_20240# VGND sky130_fd_pr__special_nfet_01v8 ad=0.0999 pd=0.985 as=0.0711 ps=0.755 w=0.36 l=0.15
X5003 a_13511_19444# a_12887_19450# a_13403_19822# VDPWR sky130_fd_pr__pfet_01v8_hvt ad=0.1155 pd=0.97 as=0.07245 ps=0.765 w=0.42 l=0.15
X5004 single_9b_cdac_0.cdac_sw_9b_0.cdac_sw_3_0.nooverlap_clk_0.CLK0 single_9b_cdac_0.cdac_sw_9b_0.cdac_sw_3_0.nooverlap_clk_0.CLKB0 VGND VGND sky130_fd_pr__nfet_01v8_lvt ad=0.1036 pd=1.02 as=0.1295 ps=1.09 w=0.74 l=0.15
X5005 VGND a_6907_19444# sar9b_0.clkload0.X VGND sky130_fd_pr__nfet_01v8 ad=0.1218 pd=1.42 as=0.0588 ps=0.7 w=0.42 l=0.15
X5006 single_9b_cdac_1.cdac_sw_9b_0.cdac_sw_3_8.tg_sw_3_3.SWN single_9b_cdac_1.cdac_sw_9b_0.cdac_sw_3_8.nooverlap_clk_0.x10.A VGND VGND sky130_fd_pr__nfet_01v8_lvt ad=0.1036 pd=1.02 as=0.1036 ps=1.02 w=0.74 l=0.15
X5007 VGND single_9b_cdac_1.cdac_sw_9b_0.cdac_sw_3_3.nooverlap_clk_0.sky130_fd_sc_hs__inv_8_0.A single_9b_cdac_1.cdac_sw_9b_0.cdac_sw_3_3.nooverlap_clk_0.CLKB0 VGND sky130_fd_pr__nfet_01v8_lvt ad=0.2146 pd=2.06 as=0.1036 ps=1.02 w=0.74 l=0.15
X5008 single_9b_cdac_1.cdac_sw_9b_0.S[2] single_9b_cdac_1.cdac_sw_9b_0.cdac_sw_3_0.nooverlap_clk_0.CLKB0 a_53154_16877# VDPWR sky130_fd_pr__pfet_01v8 ad=0.435 pd=3.58 as=0.435 ps=3.58 w=1.5 l=0.5
X5009 VDPWR sar9b_0.net31 a_14175_25972# VDPWR sky130_fd_pr__pfet_01v8_hvt ad=0.11455 pd=1.08 as=0.2054 ps=2.1 w=0.79 l=0.15
X5010 th_dif_sw_0.VCN single_9b_cdac_0.cdac_sw_9b_0.S[2] sky130_fd_pr__cap_mim_m3_1 l=2 w=2
X5011 VGND a_10637_27279# uo_out[4] VGND sky130_fd_pr__nfet_01v8 ad=0.0754 pd=0.81 as=0.1352 ps=1.56 w=0.52 l=0.15
X5012 a_53154_26999# single_9b_cdac_0.SW[2] VDPWR VDPWR sky130_fd_pr__pfet_01v8 ad=0.435 pd=3.58 as=0.435 ps=3.58 w=1.5 l=0.5
X5013 VGND sar9b_0.net15 a_8669_23074# VGND sky130_fd_pr__nfet_01v8 ad=0.12495 pd=1.015 as=0.06405 ps=0.725 w=0.42 l=0.15
X5014 VGND a_7039_22138# a_6679_22316# VGND sky130_fd_pr__nfet_01v8 ad=0.1092 pd=1.36 as=0.05985 ps=0.705 w=0.42 l=0.15
X5015 th_dif_sw_0.VCP single_9b_cdac_1.cdac_sw_9b_0.S[0] sky130_fd_pr__cap_mim_m3_1 l=2 w=2
X5016 ua[0] single_9b_cdac_0.cdac_sw_9b_0.cdac_sw_3_3.tg_sw_3_3.SWN ua[0] VGND sky130_fd_pr__nfet_01v8 ad=0.145 pd=1.58 as=0 ps=0 w=0.5 l=0.5
X5017 VDPWR sar9b_0.net3 a_6859_21710# VDPWR sky130_fd_pr__pfet_01v8_hvt ad=0.1092 pd=1.36 as=0.1092 ps=1.36 w=0.42 l=0.15
X5018 sar9b_0.net8 a_12487_20836# VGND VGND sky130_fd_pr__nfet_01v8 ad=0.169 pd=1.82 as=0.2087 ps=2.02 w=0.65 l=0.15
X5019 th_dif_sw_0.VCN single_9b_cdac_0.cdac_sw_9b_0.S[1] sky130_fd_pr__cap_mim_m3_1 l=2 w=2
X5020 single_9b_cdac_0.cdac_sw_9b_0.S[3] single_9b_cdac_0.cdac_sw_9b_0.cdac_sw_3_4.tg_sw_3_3.SWN single_9b_cdac_0.cdac_sw_9b_0.S[3] VGND sky130_fd_pr__nfet_01v8 ad=0.145 pd=1.58 as=0 ps=0 w=0.5 l=0.5
X5021 single_9b_cdac_1.SW[5] a_13899_20532# VGND VGND sky130_fd_pr__nfet_01v8 ad=0.1352 pd=1.56 as=0.0754 ps=0.81 w=0.52 l=0.15
X5022 VDPWR single_9b_cdac_1.cdac_sw_9b_0.cdac_sw_3_6.tg_sw_3_3.SWN single_9b_cdac_1.cdac_sw_9b_0.cdac_sw_3_6.tg_sw_3_3.SWP VDPWR sky130_fd_pr__pfet_01v8 ad=0.196 pd=1.47 as=0.168 ps=1.42 w=1.12 l=0.15
X5023 single_9b_cdac_0.cdac_sw_9b_0.S[4] single_9b_cdac_0.cdac_sw_9b_0.cdac_sw_3_3.tg_sw_3_3.SWP single_9b_cdac_0.cdac_sw_9b_0.S[4] VDPWR sky130_fd_pr__pfet_01v8 ad=0.435 pd=3.58 as=0 ps=0 w=1.5 l=0.5
X5024 a_30012_26990# single_9b_cdac_0.cdac_sw_9b_0.cdac_sw_3_7.nooverlap_clk_0.CLK0 single_9b_cdac_0.cdac_sw_9b_0.S[7] VGND sky130_fd_pr__nfet_01v8 ad=0.145 pd=1.58 as=0.145 ps=1.58 w=0.5 l=0.5
X5025 single_9b_cdac_1.cdac_sw_9b_0.cdac_sw_3_6.tg_sw_3_3.SWP single_9b_cdac_1.cdac_sw_9b_0.cdac_sw_3_6.tg_sw_3_3.SWN VDPWR VDPWR sky130_fd_pr__pfet_01v8 ad=0.168 pd=1.42 as=0.168 ps=1.42 w=1.12 l=0.15
X5026 VGND single_9b_cdac_1.cdac_sw_9b_0.cdac_sw_3_5.nooverlap_clk_0.CLKB0 single_9b_cdac_1.cdac_sw_9b_0.cdac_sw_3_5.nooverlap_clk_0.CLK0 VGND sky130_fd_pr__nfet_01v8_lvt ad=0.1554 pd=1.16 as=0.1036 ps=1.02 w=0.74 l=0.15
X5027 tdc_0.OUTP tdc_0.phase_detector_0.pd_out_0.B a_16555_12124# VGND sky130_fd_pr__nfet_01v8_lvt ad=0.2109 pd=2.05 as=0.0888 ps=0.98 w=0.74 l=0.15
X5028 VGND single_9b_cdac_0.cdac_sw_9b_0.cdac_sw_3_1.nooverlap_clk_0.CLKB0 single_9b_cdac_0.cdac_sw_9b_0.cdac_sw_3_1.nooverlap_clk_0.CLK0 VGND sky130_fd_pr__nfet_01v8_lvt ad=0.2109 pd=2.05 as=0.1036 ps=1.02 w=0.74 l=0.15
X5029 th_dif_sw_0.VCN single_9b_cdac_0.cdac_sw_9b_0.S[0] sky130_fd_pr__cap_mim_m3_1 l=2 w=2
X5030 a_13968_25428# a_12887_25428# a_13621_25670# VDPWR sky130_fd_pr__pfet_01v8_hvt ad=0.0588 pd=0.7 as=0.12915 ps=1.185 w=0.42 l=0.15
X5031 VDPWR single_9b_cdac_0.cdac_sw_9b_0.cdac_sw_3_3.nooverlap_clk_0.sky130_fd_sc_hs__inv_8_0.A single_9b_cdac_0.cdac_sw_9b_0.cdac_sw_3_3.nooverlap_clk_0.CLKB0 VDPWR sky130_fd_pr__pfet_01v8 ad=0.3304 pd=2.83 as=0.168 ps=1.42 w=1.12 l=0.15
X5032 single_9b_cdac_0.cdac_sw_9b_0.S[4] single_9b_cdac_0.cdac_sw_9b_0.cdac_sw_3_3.tg_sw_3_3.SWN single_9b_cdac_0.cdac_sw_9b_0.S[4] VGND sky130_fd_pr__nfet_01v8 ad=0.145 pd=1.58 as=0 ps=0 w=0.5 l=0.5
X5033 single_9b_cdac_0.cdac_sw_9b_0.cdac_sw_3_4.nooverlap_clk_0.CLK0 single_9b_cdac_0.cdac_sw_9b_0.cdac_sw_3_4.nooverlap_clk_0.CLKB0 VGND VGND sky130_fd_pr__nfet_01v8_lvt ad=0.1036 pd=1.02 as=0.2146 ps=2.06 w=0.74 l=0.15
X5034 VGND single_9b_cdac_1.SW[6] a_34814_17740# VGND sky130_fd_pr__nfet_01v8 ad=0.145 pd=1.58 as=0.145 ps=1.58 w=0.5 l=0.5
X5035 a_7163_25972# a_6539_25978# a_7055_26350# VDPWR sky130_fd_pr__pfet_01v8_hvt ad=0.1155 pd=0.97 as=0.07245 ps=0.765 w=0.42 l=0.15
X5036 a_13621_25670# a_13403_25428# VDPWR VDPWR sky130_fd_pr__pfet_01v8_hvt ad=0.12915 pd=1.185 as=0.2184 ps=2.2 w=0.84 l=0.15
X5037 VDPWR single_9b_cdac_1.cdac_sw_9b_0.cdac_sw_3_6.tg_sw_3_3.SWN single_9b_cdac_1.cdac_sw_9b_0.cdac_sw_3_6.tg_sw_3_3.SWP VDPWR sky130_fd_pr__pfet_01v8 ad=0.168 pd=1.42 as=0.168 ps=1.42 w=1.12 l=0.15
X5038 single_9b_cdac_1.SW[8] a_13071_21620# VGND VGND sky130_fd_pr__nfet_01v8 ad=0.1352 pd=1.56 as=0.0754 ps=0.81 w=0.52 l=0.15
X5039 VDPWR single_9b_cdac_1.cdac_sw_9b_0.cdac_sw_3_6.nooverlap_clk_0.CLKB0 single_9b_cdac_1.cdac_sw_9b_0.cdac_sw_3_6.nooverlap_clk_0.CLK0 VDPWR sky130_fd_pr__pfet_01v8 ad=0.3864 pd=2.93 as=0.168 ps=1.42 w=1.12 l=0.15
X5040 th_dif_sw_0.VCP single_9b_cdac_1.cdac_sw_9b_0.S[6] sky130_fd_pr__cap_mim_m3_1 l=2 w=2
X5041 single_9b_cdac_0.cdac_sw_9b_0.cdac_sw_3_3.nooverlap_clk_0.CLKB0 single_9b_cdac_0.cdac_sw_9b_0.cdac_sw_3_3.nooverlap_clk_0.sky130_fd_sc_hs__inv_8_0.A VDPWR VDPWR sky130_fd_pr__pfet_01v8 ad=0.168 pd=1.42 as=0.196 ps=1.47 w=1.12 l=0.15
X5042 single_9b_cdac_0.cdac_sw_9b_0.S[1] single_9b_cdac_0.cdac_sw_9b_0.cdac_sw_3_1.nooverlap_clk_0.CLKB0 a_57946_26999# VDPWR sky130_fd_pr__pfet_01v8 ad=0.435 pd=3.58 as=0.435 ps=3.58 w=1.5 l=0.5
X5043 VDPWR a_11413_25670# a_11303_25794# VDPWR sky130_fd_pr__pfet_01v8_hvt ad=0.07035 pd=0.755 as=0.1155 ps=0.97 w=0.42 l=0.15
X5044 VGND VDPWR VGND VGND sky130_fd_pr__nfet_01v8 ad=0.143 pd=1.62 as=0 ps=0 w=0.55 l=0.59
X5045 single_9b_cdac_1.cdac_sw_9b_0.cdac_sw_3_6.tg_sw_3_3.SWP single_9b_cdac_1.cdac_sw_9b_0.cdac_sw_3_6.tg_sw_3_3.SWN VDPWR VDPWR sky130_fd_pr__pfet_01v8 ad=0.168 pd=1.42 as=0.196 ps=1.47 w=1.12 l=0.15
X5046 th_dif_sw_0.VCP single_9b_cdac_1.cdac_sw_9b_0.S[1] sky130_fd_pr__cap_mim_m3_1 l=2 w=2
X5047 VGND single_9b_cdac_0.cdac_sw_9b_0.cdac_sw_3_8.nooverlap_clk_0.sky130_fd_sc_hs__inv_8_0.A single_9b_cdac_0.cdac_sw_9b_0.cdac_sw_3_8.nooverlap_clk_0.CLKB0 VGND sky130_fd_pr__nfet_01v8_lvt ad=0.1036 pd=1.02 as=0.1036 ps=1.02 w=0.74 l=0.15
X5048 VDPWR VGND VDPWR VDPWR sky130_fd_pr__pfet_01v8_hvt ad=0.2262 pd=2.26 as=0 ps=0 w=0.87 l=0.59
X5049 th_dif_sw_0.VCN single_9b_cdac_0.cdac_sw_9b_0.S[0] sky130_fd_pr__cap_mim_m3_1 l=2 w=2
X5050 VGND single_9b_cdac_1.cdac_sw_9b_0.cdac_sw_3_2.tg_sw_3_3.SWN single_9b_cdac_1.cdac_sw_9b_0.cdac_sw_3_2.tg_sw_3_3.SWP VGND sky130_fd_pr__nfet_01v8_lvt ad=0.2146 pd=2.06 as=0.1036 ps=1.02 w=0.74 l=0.15
X5051 VGND VDPWR VGND VGND sky130_fd_pr__nfet_01v8 ad=0.143 pd=1.62 as=0 ps=0 w=0.55 l=0.59
X5052 VGND VDPWR VGND VGND sky130_fd_pr__nfet_01v8 ad=0.143 pd=1.62 as=0 ps=0 w=0.55 l=0.59
X5053 th_dif_sw_0.VCP single_9b_cdac_1.cdac_sw_9b_0.S[3] sky130_fd_pr__cap_mim_m3_1 l=2 w=2
X5054 th_dif_sw_0.VCP single_9b_cdac_1.cdac_sw_9b_0.S[0] sky130_fd_pr__cap_mim_m3_1 l=2 w=2
X5055 a_62748_16877# single_9b_cdac_1.SW[0] VDPWR VDPWR sky130_fd_pr__pfet_01v8 ad=0.435 pd=3.58 as=0.435 ps=3.58 w=1.5 l=0.5
X5056 a_6587_21852# sar9b_0._07_ VGND VGND sky130_fd_pr__nfet_01v8 ad=0.0567 pd=0.69 as=0.10025 ps=0.985 w=0.42 l=0.15
X5057 single_9b_cdac_1.cdac_sw_9b_0.cdac_sw_3_6.nooverlap_clk_0.CLK0 single_9b_cdac_1.cdac_sw_9b_0.cdac_sw_3_6.nooverlap_clk_0.CLKB0 VDPWR VDPWR sky130_fd_pr__pfet_01v8 ad=0.168 pd=1.42 as=0.196 ps=1.47 w=1.12 l=0.15
X5058 single_9b_cdac_0.cdac_sw_9b_0.cdac_sw_3_3.nooverlap_clk_0.x10.A single_9b_cdac_0.cdac_sw_9b_0.cdac_sw_3_3.nooverlap_clk_0.x8.A VGND VGND sky130_fd_pr__nfet_01v8_lvt ad=0.1184 pd=1.06 as=0.1221 ps=1.07 w=0.74 l=0.15
X5059 single_9b_cdac_0.cdac_sw_9b_0.cdac_sw_3_2.nooverlap_clk_0.CLKB0 single_9b_cdac_0.cdac_sw_9b_0.cdac_sw_3_2.nooverlap_clk_0.sky130_fd_sc_hs__inv_8_0.A VGND VGND sky130_fd_pr__nfet_01v8_lvt ad=0.1036 pd=1.02 as=0.1295 ps=1.09 w=0.74 l=0.15
X5060 single_9b_cdac_0.SW[3] a_14451_24340# VDPWR VDPWR sky130_fd_pr__pfet_01v8_hvt ad=0.2054 pd=2.1 as=0.11455 ps=1.08 w=0.79 l=0.15
X5061 single_9b_cdac_0.cdac_sw_9b_0.cdac_sw_3_3.nooverlap_clk_0.CLK0 single_9b_cdac_0.cdac_sw_9b_0.cdac_sw_3_3.nooverlap_clk_0.CLKB0 VGND VGND sky130_fd_pr__nfet_01v8_lvt ad=0.1036 pd=1.02 as=0.1295 ps=1.09 w=0.74 l=0.15
X5062 sar9b_0.net22 a_9635_26276# VDPWR VDPWR sky130_fd_pr__pfet_01v8_hvt ad=0.26 pd=2.52 as=0.3012 ps=2.66 w=1 l=0.15
X5063 a_11689_19142# a_11471_18900# VDPWR VDPWR sky130_fd_pr__pfet_01v8_hvt ad=0.12915 pd=1.185 as=0.2184 ps=2.2 w=0.84 l=0.15
X5064 th_dif_sw_0.VCN single_9b_cdac_0.cdac_sw_9b_0.S[2] sky130_fd_pr__cap_mim_m3_1 l=2 w=2
X5065 single_9b_cdac_0.cdac_sw_9b_0.cdac_sw_3_3.nooverlap_clk_0.x10.A single_9b_cdac_0.cdac_sw_9b_0.cdac_sw_3_3.nooverlap_clk_0.x8.A VDPWR VDPWR sky130_fd_pr__pfet_01v8 ad=0.168 pd=1.42 as=0.168 ps=1.42 w=1.12 l=0.15
X5066 VGND single_9b_cdac_0.cdac_sw_9b_0.cdac_sw_3_5.tg_sw_3_3.SWN single_9b_cdac_0.cdac_sw_9b_0.cdac_sw_3_5.tg_sw_3_3.SWP VGND sky130_fd_pr__nfet_01v8_lvt ad=0.1554 pd=1.16 as=0.1036 ps=1.02 w=0.74 l=0.15
X5067 a_9893_21076# a_9849_21318# a_9727_21076# VGND sky130_fd_pr__nfet_01v8 ad=0.0441 pd=0.63 as=0.1401 ps=1.1 w=0.42 l=0.15
X5068 th_dif_sw_0.VCP single_9b_cdac_1.cdac_sw_9b_0.S[3] sky130_fd_pr__cap_mim_m3_1 l=2 w=2
X5069 th_dif_sw_0.VCN single_9b_cdac_0.cdac_sw_9b_0.S[0] sky130_fd_pr__cap_mim_m3_1 l=2 w=2
X5070 a_6691_26490# sar9b_0.net3 VDPWR VDPWR sky130_fd_pr__pfet_01v8_hvt ad=0.0567 pd=0.69 as=0.0819 ps=0.81 w=0.42 l=0.15
X5071 VGND single_9b_cdac_0.cdac_sw_9b_0.cdac_sw_3_2.nooverlap_clk_0.x4.A single_9b_cdac_0.cdac_sw_9b_0.cdac_sw_3_2.nooverlap_clk_0.x6.A VGND sky130_fd_pr__nfet_01v8_lvt ad=0.2627 pd=2.19 as=0.2109 ps=2.05 w=0.74 l=0.15
X5072 a_65367_15501# single_9b_cdac_1.CF[0] single_9b_cdac_1.cdac_sw_9b_0.cdac_sw_3_2.nooverlap_clk_0.sky130_fd_sc_hs__nand2_1_0.Y VGND sky130_fd_pr__nfet_01v8_lvt ad=0.0888 pd=0.98 as=0.2109 ps=2.05 w=0.74 l=0.15
X5073 VGND single_9b_cdac_1.cdac_sw_9b_0.cdac_sw_3_2.nooverlap_clk_0.CLKB0 single_9b_cdac_1.cdac_sw_9b_0.cdac_sw_3_2.nooverlap_clk_0.CLK0 VGND sky130_fd_pr__nfet_01v8_lvt ad=0.1036 pd=1.02 as=0.1036 ps=1.02 w=0.74 l=0.15
X5074 single_9b_cdac_1.cdac_sw_9b_0.cdac_sw_3_1.nooverlap_clk_0.x6.A single_9b_cdac_1.cdac_sw_9b_0.cdac_sw_3_1.nooverlap_clk_0.x4.A VDPWR VDPWR sky130_fd_pr__pfet_01v8 ad=0.3304 pd=2.83 as=0.3864 ps=2.93 w=1.12 l=0.15
X5075 VDPWR single_9b_cdac_0.cdac_sw_9b_0.cdac_sw_3_3.nooverlap_clk_0.x8.A single_9b_cdac_0.cdac_sw_9b_0.cdac_sw_3_3.nooverlap_clk_0.x10.A VDPWR sky130_fd_pr__pfet_01v8 ad=0.168 pd=1.42 as=0.168 ps=1.42 w=1.12 l=0.15
X5076 a_14051_24100# sar9b_0.net15 VDPWR VDPWR sky130_fd_pr__pfet_01v8_hvt ad=0.0567 pd=0.69 as=0.0819 ps=0.81 w=0.42 l=0.15
X5077 VGND VDPWR VGND VGND sky130_fd_pr__nfet_01v8 ad=0.143 pd=1.62 as=0 ps=0 w=0.55 l=0.59
X5078 VGND single_9b_cdac_0.cdac_sw_9b_0.cdac_sw_3_6.nooverlap_clk_0.x6.A single_9b_cdac_0.cdac_sw_9b_0.cdac_sw_3_6.nooverlap_clk_0.x8.A VGND sky130_fd_pr__nfet_01v8_lvt ad=0.2627 pd=2.19 as=0.2109 ps=2.05 w=0.74 l=0.15
X5079 VGND single_9b_cdac_1.cdac_sw_9b_0.cdac_sw_3_5.nooverlap_clk_0.x8.A single_9b_cdac_1.cdac_sw_9b_0.cdac_sw_3_5.nooverlap_clk_0.x10.A VGND sky130_fd_pr__nfet_01v8_lvt ad=0.1221 pd=1.07 as=0.1184 ps=1.06 w=0.74 l=0.15
X5080 single_9b_cdac_1.cdac_sw_9b_0.cdac_sw_3_2.nooverlap_clk_0.x8.A single_9b_cdac_1.cdac_sw_9b_0.cdac_sw_3_2.nooverlap_clk_0.x6.A VGND VGND sky130_fd_pr__nfet_01v8_lvt ad=0.2109 pd=2.05 as=0.2627 ps=2.19 w=0.74 l=0.15
X5081 a_6473_27426# a_6094_27060# a_6401_27426# VGND sky130_fd_pr__nfet_01v8 ad=0.1401 pd=1.1 as=0.0441 ps=0.63 w=0.42 l=0.15
X5082 single_9b_cdac_0.cdac_sw_9b_0.cdac_sw_3_3.nooverlap_clk_0.x10.A single_9b_cdac_0.cdac_sw_9b_0.cdac_sw_3_3.nooverlap_clk_0.x8.A VDPWR VDPWR sky130_fd_pr__pfet_01v8 ad=0.168 pd=1.42 as=0.3304 ps=2.83 w=1.12 l=0.15
X5083 single_9b_cdac_0.cdac_sw_9b_0.cdac_sw_3_0.nooverlap_clk_0.CLKB0 single_9b_cdac_0.cdac_sw_9b_0.cdac_sw_3_0.nooverlap_clk_0.sky130_fd_sc_hs__inv_8_0.A VGND VGND sky130_fd_pr__nfet_01v8_lvt ad=0.1036 pd=1.02 as=0.1554 ps=1.16 w=0.74 l=0.15
X5084 VGND VDPWR VGND VGND sky130_fd_pr__nfet_01v8 ad=0.143 pd=1.62 as=0 ps=0 w=0.55 l=0.59
X5085 VDPWR a_6502_20124# a_6436_20354# VDPWR sky130_fd_pr__pfet_01v8_hvt ad=0.17887 pd=1.26 as=0.0693 ps=0.75 w=0.42 l=0.15
X5086 th_dif_sw_0.VCN single_9b_cdac_0.cdac_sw_9b_0.S[0] sky130_fd_pr__cap_mim_m3_1 l=2 w=2
X5087 a_58824_26990# single_9b_cdac_0.cdac_sw_9b_0.cdac_sw_3_1.nooverlap_clk_0.CLK0 single_9b_cdac_0.cdac_sw_9b_0.S[1] VGND sky130_fd_pr__nfet_01v8 ad=0.145 pd=1.58 as=0.145 ps=1.58 w=0.5 l=0.5
X5088 a_13511_19266# sar9b_0.net15 VDPWR VDPWR sky130_fd_pr__pfet_01v8_hvt ad=0.1092 pd=1.36 as=0.07035 ps=0.755 w=0.42 l=0.15
X5089 th_dif_sw_0.VCN single_9b_cdac_0.cdac_sw_9b_0.S[0] sky130_fd_pr__cap_mim_m3_1 l=2 w=2
X5090 a_13857_27279# sar9b_0.net25 VGND VGND sky130_fd_pr__nfet_01v8 ad=0.1352 pd=1.56 as=0.0754 ps=0.81 w=0.52 l=0.15
X5091 dw_12589_1395# a_10166_3438# sky130_fd_pr__cap_mim_m3_1 l=2 w=2
X5092 VGND a_9132_7271# th_dif_sw_0.th_sw_1.CK VGND sky130_fd_pr__nfet_01v8_lvt ad=0.1036 pd=1.02 as=0.1036 ps=1.02 w=0.74 l=0.15
X5093 a_63626_17740# single_9b_cdac_1.cdac_sw_9b_0.cdac_sw_3_2.nooverlap_clk_0.CLK0 single_9b_cdac_1.cdac_sw_9b_0.S[0] VGND sky130_fd_pr__nfet_01v8 ad=0.145 pd=1.58 as=0.145 ps=1.58 w=0.5 l=0.5
X5094 VDPWR VGND VDPWR VDPWR sky130_fd_pr__pfet_01v8_hvt ad=0.2262 pd=2.26 as=0 ps=0 w=0.87 l=0.59
X5095 single_9b_cdac_0.cdac_sw_9b_0.S[0] single_9b_cdac_0.cdac_sw_9b_0.cdac_sw_3_2.tg_sw_3_3.SWN ua[0] VDPWR sky130_fd_pr__pfet_01v8 ad=0.435 pd=3.58 as=0.435 ps=3.58 w=1.5 l=0.5
X5096 VGND single_9b_cdac_1.cdac_sw_9b_0.cdac_sw_3_7.nooverlap_clk_0.CLKB0 single_9b_cdac_1.cdac_sw_9b_0.cdac_sw_3_7.nooverlap_clk_0.CLK0 VGND sky130_fd_pr__nfet_01v8_lvt ad=0.2146 pd=2.06 as=0.1036 ps=1.02 w=0.74 l=0.15
X5097 VDPWR single_9b_cdac_1.cdac_sw_9b_0.cdac_sw_3_0.nooverlap_clk_0.CLKB0 single_9b_cdac_1.cdac_sw_9b_0.cdac_sw_3_0.nooverlap_clk_0.CLK0 VDPWR sky130_fd_pr__pfet_01v8 ad=0.196 pd=1.47 as=0.168 ps=1.42 w=1.12 l=0.15
X5098 a_40321_29917# single_9b_cdac_0.cdac_sw_9b_0.cdac_sw_3_5.nooverlap_clk_0.x1.A single_9b_cdac_0.cdac_sw_9b_0.cdac_sw_3_5.nooverlap_clk_0.x4.A VGND sky130_fd_pr__nfet_01v8_lvt ad=0.0888 pd=0.98 as=0.2109 ps=2.05 w=0.74 l=0.15
X5099 VGND a_6930_20241# sar9b_0.net15 VGND sky130_fd_pr__nfet_01v8 ad=0.09262 pd=0.935 as=0.08775 ps=0.92 w=0.65 l=0.15
X5100 single_9b_cdac_0.SW[2] a_14175_24340# VGND VGND sky130_fd_pr__nfet_01v8 ad=0.1352 pd=1.56 as=0.0754 ps=0.81 w=0.52 l=0.15
X5101 sar9b_0.net41 a_9727_23226# VDPWR VDPWR sky130_fd_pr__pfet_01v8_hvt ad=0.26 pd=2.52 as=0.3012 ps=2.66 w=1 l=0.15
X5102 a_30012_17740# single_9b_cdac_1.cdac_sw_9b_0.cdac_sw_3_7.nooverlap_clk_0.CLK0 single_9b_cdac_1.cdac_sw_9b_0.S[7] VGND sky130_fd_pr__nfet_01v8 ad=0.145 pd=1.58 as=0.145 ps=1.58 w=0.5 l=0.5
X5103 dw_12589_1395# a_10166_3438# sky130_fd_pr__cap_mim_m3_1 l=2 w=2
X5104 th_dif_sw_0.VCP single_9b_cdac_1.cdac_sw_9b_0.S[4] sky130_fd_pr__cap_mim_m3_1 l=2 w=2
X5105 th_dif_sw_0.VCP single_9b_cdac_1.cdac_sw_9b_0.S[3] sky130_fd_pr__cap_mim_m3_1 l=2 w=2
X5106 th_dif_sw_0.VCP single_9b_cdac_1.cdac_sw_9b_0.S[0] sky130_fd_pr__cap_mim_m3_1 l=2 w=2
X5107 single_9b_cdac_1.cdac_sw_9b_0.cdac_sw_3_1.tg_sw_3_3.SWP single_9b_cdac_1.cdac_sw_9b_0.cdac_sw_3_1.tg_sw_3_3.SWN VGND VGND sky130_fd_pr__nfet_01v8_lvt ad=0.1036 pd=1.02 as=0.1554 ps=1.16 w=0.74 l=0.15
X5108 single_9b_cdac_1.cdac_sw_9b_0.cdac_sw_3_3.nooverlap_clk_0.CLKB0 single_9b_cdac_1.cdac_sw_9b_0.cdac_sw_3_3.nooverlap_clk_0.sky130_fd_sc_hs__inv_8_0.A VDPWR VDPWR sky130_fd_pr__pfet_01v8 ad=0.168 pd=1.42 as=0.3304 ps=2.83 w=1.12 l=0.15
X5109 single_9b_cdac_1.cdac_sw_9b_0.cdac_sw_3_5.tg_sw_3_3.SWN single_9b_cdac_1.cdac_sw_9b_0.cdac_sw_3_5.nooverlap_clk_0.x10.A VGND VGND sky130_fd_pr__nfet_01v8_lvt ad=0.1036 pd=1.02 as=0.1036 ps=1.02 w=0.74 l=0.15
X5110 single_9b_cdac_1.cdac_sw_9b_0.cdac_sw_3_0.nooverlap_clk_0.CLK0 single_9b_cdac_1.cdac_sw_9b_0.cdac_sw_3_0.nooverlap_clk_0.CLKB0 VDPWR VDPWR sky130_fd_pr__pfet_01v8 ad=0.168 pd=1.42 as=0.168 ps=1.42 w=1.12 l=0.15
X5111 single_9b_cdac_0.cdac_sw_9b_0.cdac_sw_3_6.nooverlap_clk_0.CLKB0 single_9b_cdac_0.cdac_sw_9b_0.cdac_sw_3_6.nooverlap_clk_0.sky130_fd_sc_hs__inv_8_0.A VGND VGND sky130_fd_pr__nfet_01v8_lvt ad=0.1036 pd=1.02 as=0.1036 ps=1.02 w=0.74 l=0.15
X5112 VGND VDPWR VGND VGND sky130_fd_pr__nfet_01v8 ad=0.143 pd=1.62 as=0 ps=0 w=0.55 l=0.59
X5113 a_6149_23770# sar9b_0.clknet_0_CLK VDPWR VDPWR sky130_fd_pr__pfet_01v8_hvt ad=0.14 pd=1.28 as=0.14 ps=1.28 w=1 l=0.15
X5114 th_dif_sw_0.VCP single_9b_cdac_1.cdac_sw_9b_0.S[3] sky130_fd_pr__cap_mim_m3_1 l=2 w=2
X5115 th_dif_sw_0.VCN single_9b_cdac_0.cdac_sw_9b_0.S[0] sky130_fd_pr__cap_mim_m3_1 l=2 w=2
X5116 VDPWR single_9b_cdac_1.cdac_sw_9b_0.cdac_sw_3_5.nooverlap_clk_0.CLKB0 single_9b_cdac_1.cdac_sw_9b_0.cdac_sw_3_5.nooverlap_clk_0.CLK0 VDPWR sky130_fd_pr__pfet_01v8 ad=0.3864 pd=2.93 as=0.168 ps=1.42 w=1.12 l=0.15
X5117 th_dif_sw_0.VCP single_9b_cdac_1.cdac_sw_9b_0.S[5] sky130_fd_pr__cap_mim_m3_1 l=2 w=2
X5118 VDPWR single_9b_cdac_1.cdac_sw_9b_0.cdac_sw_3_0.nooverlap_clk_0.CLKB0 single_9b_cdac_1.cdac_sw_9b_0.cdac_sw_3_0.nooverlap_clk_0.CLK0 VDPWR sky130_fd_pr__pfet_01v8 ad=0.168 pd=1.42 as=0.168 ps=1.42 w=1.12 l=0.15
X5119 single_9b_cdac_1.cdac_sw_9b_0.S[0] single_9b_cdac_1.cdac_sw_9b_0.cdac_sw_3_2.tg_sw_3_3.SWN ua[0] VDPWR sky130_fd_pr__pfet_01v8 ad=0.435 pd=3.58 as=0.435 ps=3.58 w=1.5 l=0.5
X5120 single_9b_cdac_0.cdac_sw_9b_0.cdac_sw_3_0.tg_sw_3_3.SWP single_9b_cdac_0.cdac_sw_9b_0.cdac_sw_3_0.tg_sw_3_3.SWN VGND VGND sky130_fd_pr__nfet_01v8_lvt ad=0.1036 pd=1.02 as=0.1036 ps=1.02 w=0.74 l=0.15
X5121 VGND single_9b_cdac_0.cdac_sw_9b_0.cdac_sw_3_7.nooverlap_clk_0.sky130_fd_sc_hs__nand2_1_0.Y single_9b_cdac_0.cdac_sw_9b_0.cdac_sw_3_7.nooverlap_clk_0.sky130_fd_sc_hs__inv_1_1.A VGND sky130_fd_pr__nfet_01v8_lvt ad=0.2627 pd=2.19 as=0.2109 ps=2.05 w=0.74 l=0.15
X5122 a_9635_24314# a_9460_24340# a_9814_24340# VGND sky130_fd_pr__nfet_01v8 ad=0.1092 pd=1.36 as=0.06405 ps=0.725 w=0.42 l=0.15
X5123 a_8825_20532# sar9b_0._05_ VDPWR VDPWR sky130_fd_pr__pfet_01v8_hvt ad=0.05775 pd=0.695 as=0.1092 ps=1.36 w=0.42 l=0.15
X5124 single_9b_cdac_1.cdac_sw_9b_0.cdac_sw_3_5.nooverlap_clk_0.CLK0 single_9b_cdac_1.cdac_sw_9b_0.cdac_sw_3_5.nooverlap_clk_0.CLKB0 VDPWR VDPWR sky130_fd_pr__pfet_01v8 ad=0.168 pd=1.42 as=0.196 ps=1.47 w=1.12 l=0.15
X5125 th_dif_sw_0.VCP single_9b_cdac_1.cdac_sw_9b_0.S[1] sky130_fd_pr__cap_mim_m3_1 l=2 w=2
X5126 a_9352_22164# sar9b_0.net2 VGND VGND sky130_fd_pr__nfet_01v8 ad=0.066 pd=0.745 as=0.2205 ps=1.89 w=0.42 l=0.15
X5127 single_9b_cdac_0.cdac_sw_9b_0.S[2] single_9b_cdac_0.cdac_sw_9b_0.cdac_sw_3_0.tg_sw_3_3.SWP single_9b_cdac_0.cdac_sw_9b_0.S[2] VDPWR sky130_fd_pr__pfet_01v8 ad=0.435 pd=3.58 as=0 ps=0 w=1.5 l=0.5
X5128 a_13126_26338# sar9b_0.net3 VGND VGND sky130_fd_pr__nfet_01v8 ad=0.06405 pd=0.725 as=0.12495 ps=1.015 w=0.42 l=0.15
X5129 a_13308_21076# sar9b_0.net1 VDPWR VDPWR sky130_fd_pr__pfet_01v8_hvt ad=0.0651 pd=0.73 as=0.1092 ps=1.36 w=0.42 l=0.15
X5130 ua[0] single_9b_cdac_1.cdac_sw_9b_0.cdac_sw_3_8.tg_sw_3_3.SWP ua[0] VDPWR sky130_fd_pr__pfet_01v8 ad=0.435 pd=3.58 as=0 ps=0 w=1.5 l=0.5
X5131 ua[0] single_9b_cdac_1.cdac_sw_9b_0.cdac_sw_3_7.tg_sw_3_3.SWN ua[0] VGND sky130_fd_pr__nfet_01v8 ad=0.145 pd=1.58 as=0 ps=0 w=0.5 l=0.5
X5132 single_9b_cdac_1.cdac_sw_9b_0.cdac_sw_3_0.nooverlap_clk_0.CLK0 single_9b_cdac_1.cdac_sw_9b_0.cdac_sw_3_0.nooverlap_clk_0.CLKB0 VDPWR VDPWR sky130_fd_pr__pfet_01v8 ad=0.168 pd=1.42 as=0.196 ps=1.47 w=1.12 l=0.15
X5133 th_dif_sw_0.VCP single_9b_cdac_1.cdac_sw_9b_0.S[3] sky130_fd_pr__cap_mim_m3_1 l=2 w=2
X5134 VGND single_9b_cdac_0.cdac_sw_9b_0.cdac_sw_3_1.nooverlap_clk_0.CLKB0 single_9b_cdac_0.cdac_sw_9b_0.cdac_sw_3_1.nooverlap_clk_0.CLK0 VGND sky130_fd_pr__nfet_01v8_lvt ad=0.1036 pd=1.02 as=0.1036 ps=1.02 w=0.74 l=0.15
X5135 single_9b_cdac_1.SW[3] a_13347_20532# VDPWR VDPWR sky130_fd_pr__pfet_01v8_hvt ad=0.2054 pd=2.1 as=0.11455 ps=1.08 w=0.79 l=0.15
X5136 VGND single_9b_cdac_1.cdac_sw_9b_0.cdac_sw_3_3.tg_sw_3_3.SWN single_9b_cdac_1.cdac_sw_9b_0.cdac_sw_3_3.tg_sw_3_3.SWP VGND sky130_fd_pr__nfet_01v8_lvt ad=0.1554 pd=1.16 as=0.1036 ps=1.02 w=0.74 l=0.15
X5137 ua[0] single_9b_cdac_0.cdac_sw_9b_0.cdac_sw_3_7.tg_sw_3_3.SWN ua[0] VGND sky130_fd_pr__nfet_01v8 ad=0.145 pd=1.58 as=0 ps=0 w=0.5 l=0.5
X5138 single_9b_cdac_0.cdac_sw_9b_0.S[5] single_9b_cdac_0.cdac_sw_9b_0.cdac_sw_3_5.nooverlap_clk_0.CLKB0 a_38738_26999# VDPWR sky130_fd_pr__pfet_01v8 ad=0.435 pd=3.58 as=0.435 ps=3.58 w=1.5 l=0.5
X5139 VGND single_9b_cdac_0.cdac_sw_9b_0.cdac_sw_3_2.tg_sw_3_3.SWN single_9b_cdac_0.cdac_sw_9b_0.cdac_sw_3_2.tg_sw_3_3.SWP VGND sky130_fd_pr__nfet_01v8_lvt ad=0.2109 pd=2.05 as=0.1036 ps=1.02 w=0.74 l=0.15
X5140 single_9b_cdac_1.cdac_sw_9b_0.cdac_sw_3_7.nooverlap_clk_0.x1.A single_9b_cdac_1.cdac_sw_9b_0.cdac_sw_3_7.nooverlap_clk_0.sky130_fd_sc_hs__inv_1_1.A VGND VGND sky130_fd_pr__nfet_01v8_lvt ad=0.2109 pd=2.05 as=0.2627 ps=2.19 w=0.74 l=0.15
X5141 a_29134_16877# single_9b_cdac_1.SW[7] VDPWR VDPWR sky130_fd_pr__pfet_01v8 ad=0.435 pd=3.58 as=0.435 ps=3.58 w=1.5 l=0.5
X5142 th_dif_sw_0.VCP single_9b_cdac_1.cdac_sw_9b_0.S[1] sky130_fd_pr__cap_mim_m3_1 l=2 w=2
X5143 th_dif_sw_0.VCN single_9b_cdac_0.cdac_sw_9b_0.S[1] sky130_fd_pr__cap_mim_m3_1 l=2 w=2
X5144 VGND VDPWR VGND VGND sky130_fd_pr__nfet_01v8 ad=0.143 pd=1.62 as=0 ps=0 w=0.55 l=0.59
X5145 VGND sar9b_0.FINAL a_6539_25978# VGND sky130_fd_pr__nfet_01v8 ad=0.0567 pd=0.69 as=0.1092 ps=1.36 w=0.42 l=0.15
X5146 VDPWR VGND VDPWR VDPWR sky130_fd_pr__pfet_01v8_hvt ad=0.2262 pd=2.26 as=0 ps=0 w=0.87 l=0.59
X5147 sar9b_0._06_ sar9b_0.clk_div_0.COUNT\[3\] VDPWR VDPWR sky130_fd_pr__pfet_01v8_hvt ad=0.135 pd=1.27 as=0.26 ps=2.52 w=1 l=0.15
X5148 single_9b_cdac_1.cdac_sw_9b_0.cdac_sw_3_6.nooverlap_clk_0.x8.A single_9b_cdac_1.cdac_sw_9b_0.cdac_sw_3_6.nooverlap_clk_0.x6.A VDPWR VDPWR sky130_fd_pr__pfet_01v8 ad=0.3304 pd=2.83 as=0.3864 ps=2.93 w=1.12 l=0.15
X5149 th_dif_sw_0.VCN single_9b_cdac_0.cdac_sw_9b_0.S[0] sky130_fd_pr__cap_mim_m3_1 l=2 w=2
X5150 th_dif_sw_0.VCN single_9b_cdac_0.cdac_sw_9b_0.S[0] sky130_fd_pr__cap_mim_m3_1 l=2 w=2
X5151 VDPWR single_9b_cdac_0.cdac_sw_9b_0.cdac_sw_3_1.nooverlap_clk_0.sky130_fd_sc_hs__inv_8_0.A single_9b_cdac_0.cdac_sw_9b_0.cdac_sw_3_1.nooverlap_clk_0.CLKB0 VDPWR sky130_fd_pr__pfet_01v8 ad=0.3304 pd=2.83 as=0.168 ps=1.42 w=1.12 l=0.15
X5152 VDPWR single_9b_cdac_0.cdac_sw_9b_0.cdac_sw_3_2.tg_sw_3_3.SWN single_9b_cdac_0.cdac_sw_9b_0.cdac_sw_3_2.tg_sw_3_3.SWP VDPWR sky130_fd_pr__pfet_01v8 ad=0.3304 pd=2.83 as=0.168 ps=1.42 w=1.12 l=0.15
X5153 a_6219_22316# sar9b_0._13_ VDPWR VDPWR sky130_fd_pr__pfet_01v8_hvt ad=0.06615 pd=0.735 as=0.14222 ps=1.335 w=0.42 l=0.15
X5154 single_9b_cdac_0.cdac_sw_9b_0.cdac_sw_3_3.nooverlap_clk_0.CLKB0 single_9b_cdac_0.cdac_sw_9b_0.cdac_sw_3_3.nooverlap_clk_0.sky130_fd_sc_hs__inv_8_0.A VGND VGND sky130_fd_pr__nfet_01v8_lvt ad=0.1036 pd=1.02 as=0.1554 ps=1.16 w=0.74 l=0.15
X5155 VDPWR VGND VDPWR VDPWR sky130_fd_pr__pfet_01v8_hvt ad=0.2262 pd=2.26 as=0 ps=0 w=0.87 l=0.59
X5156 VGND sar9b_0.net10 a_13623_23252# VGND sky130_fd_pr__nfet_01v8 ad=0.0754 pd=0.81 as=0.1352 ps=1.56 w=0.52 l=0.15
X5157 single_9b_cdac_0.cdac_sw_9b_0.cdac_sw_3_5.tg_sw_3_3.SWP single_9b_cdac_0.cdac_sw_9b_0.cdac_sw_3_5.tg_sw_3_3.SWN VDPWR VDPWR sky130_fd_pr__pfet_01v8 ad=0.168 pd=1.42 as=0.196 ps=1.47 w=1.12 l=0.15
X5158 a_12390_24162# sar9b_0.net15 VGND VGND sky130_fd_pr__nfet_01v8 ad=0.06405 pd=0.725 as=0.12495 ps=1.015 w=0.42 l=0.15
X5159 VGND VDPWR VGND VGND sky130_fd_pr__nfet_01v8 ad=0.143 pd=1.62 as=0 ps=0 w=0.55 l=0.59
X5160 single_9b_cdac_0.cdac_sw_9b_0.S[2] single_9b_cdac_0.cdac_sw_9b_0.cdac_sw_3_0.tg_sw_3_3.SWP ua[0] VGND sky130_fd_pr__nfet_01v8 ad=0.145 pd=1.58 as=0.145 ps=1.58 w=0.5 l=0.5
X5161 single_9b_cdac_0.cdac_sw_9b_0.cdac_sw_3_1.nooverlap_clk_0.CLKB0 single_9b_cdac_0.cdac_sw_9b_0.cdac_sw_3_1.nooverlap_clk_0.sky130_fd_sc_hs__inv_8_0.A VDPWR VDPWR sky130_fd_pr__pfet_01v8 ad=0.168 pd=1.42 as=0.196 ps=1.47 w=1.12 l=0.15
X5162 th_dif_sw_0.VCN single_9b_cdac_0.cdac_sw_9b_0.S[2] sky130_fd_pr__cap_mim_m3_1 l=2 w=2
X5163 th_dif_sw_0.VCN single_9b_cdac_0.cdac_sw_9b_0.S[1] sky130_fd_pr__cap_mim_m3_1 l=2 w=2
X5164 VDPWR single_9b_cdac_0.cdac_sw_9b_0.cdac_sw_3_4.nooverlap_clk_0.x1.A single_9b_cdac_0.cdac_sw_9b_0.cdac_sw_3_4.nooverlap_clk_0.sky130_fd_sc_hs__inv_8_0.A VDPWR sky130_fd_pr__pfet_01v8 ad=0.3304 pd=2.83 as=0.168 ps=1.42 w=1.12 l=0.15
X5165 single_9b_cdac_0.cdac_sw_9b_0.cdac_sw_3_2.tg_sw_3_3.SWP single_9b_cdac_0.cdac_sw_9b_0.cdac_sw_3_2.tg_sw_3_3.SWN VDPWR VDPWR sky130_fd_pr__pfet_01v8 ad=0.168 pd=1.42 as=0.196 ps=1.47 w=1.12 l=0.15
X5166 th_dif_sw_0.VCN single_9b_cdac_0.cdac_sw_9b_0.S[1] sky130_fd_pr__cap_mim_m3_1 l=2 w=2
X5167 VDPWR a_6149_23770# sar9b_0.clknet_1_1__leaf_CLK VDPWR sky130_fd_pr__pfet_01v8_hvt ad=0.1375 pd=1.275 as=0.14 ps=1.28 w=1 l=0.15
X5168 a_14322_25250# sar9b_0.net15 VGND VGND sky130_fd_pr__nfet_01v8 ad=0.06405 pd=0.725 as=0.12495 ps=1.015 w=0.42 l=0.15
X5169 VDPWR sar9b_0._12_ a_6219_22316# VDPWR sky130_fd_pr__pfet_01v8_hvt ad=0.0567 pd=0.69 as=0.06615 ps=0.735 w=0.42 l=0.15
X5170 single_9b_cdac_1.cdac_sw_9b_0.cdac_sw_3_8.nooverlap_clk_0.CLK0 single_9b_cdac_1.cdac_sw_9b_0.cdac_sw_3_8.nooverlap_clk_0.CLKB0 VGND VGND sky130_fd_pr__nfet_01v8_lvt ad=0.1036 pd=1.02 as=0.2109 ps=2.05 w=0.74 l=0.15
X5171 th_dif_sw_0.VCN single_9b_cdac_0.cdac_sw_9b_0.S[0] sky130_fd_pr__cap_mim_m3_1 l=2 w=2
X5172 th_dif_sw_0.VCN single_9b_cdac_0.cdac_sw_9b_0.S[1] sky130_fd_pr__cap_mim_m3_1 l=2 w=2
X5173 th_dif_sw_0.VCN single_9b_cdac_0.cdac_sw_9b_0.S[0] sky130_fd_pr__cap_mim_m3_1 l=2 w=2
X5174 VDPWR single_9b_cdac_0.cdac_sw_9b_0.cdac_sw_3_0.nooverlap_clk_0.x10.A single_9b_cdac_0.cdac_sw_9b_0.cdac_sw_3_0.tg_sw_3_3.SWN VDPWR sky130_fd_pr__pfet_01v8 ad=0.196 pd=1.47 as=0.168 ps=1.42 w=1.12 l=0.15
X5175 a_9370_19152# a_9648_19168# a_9604_19266# VDPWR sky130_fd_pr__pfet_01v8_hvt ad=0.0588 pd=0.7 as=0.0567 ps=0.69 w=0.42 l=0.15
X5176 VDPWR a_9687_19042# a_9648_19168# VDPWR sky130_fd_pr__pfet_01v8_hvt ad=0.0864 pd=0.91 as=0.1664 ps=1.8 w=0.64 l=0.15
X5177 VGND sar9b_0.net36 a_14451_18356# VGND sky130_fd_pr__nfet_01v8 ad=0.0754 pd=0.81 as=0.1352 ps=1.56 w=0.52 l=0.15
X5178 VDPWR VGND VDPWR VDPWR sky130_fd_pr__pfet_01v8_hvt ad=0.2262 pd=2.26 as=0 ps=0 w=0.87 l=0.59
X5179 th_dif_sw_0.VCP single_9b_cdac_1.cdac_sw_9b_0.S[0] sky130_fd_pr__cap_mim_m3_1 l=2 w=2
X5180 th_dif_sw_0.VCP single_9b_cdac_1.cdac_sw_9b_0.S[0] sky130_fd_pr__cap_mim_m3_1 l=2 w=2
X5181 VGND sar9b_0.net3 a_12469_26338# VGND sky130_fd_pr__nfet_01v8 ad=0.1346 pd=1.15 as=0.0441 ps=0.63 w=0.42 l=0.15
X5182 VDPWR VGND VDPWR VDPWR sky130_fd_pr__pfet_01v8_hvt ad=0.2262 pd=2.26 as=0 ps=0 w=0.87 l=0.59
X5183 a_6581_25428# a_6537_25670# a_6415_25428# VGND sky130_fd_pr__nfet_01v8 ad=0.0441 pd=0.63 as=0.1401 ps=1.1 w=0.42 l=0.15
X5184 a_11567_23226# sar9b_0.net15 VDPWR VDPWR sky130_fd_pr__pfet_01v8_hvt ad=0.0567 pd=0.69 as=0.0819 ps=0.81 w=0.42 l=0.15
X5185 a_30717_15495# single_9b_cdac_1.cdac_sw_9b_0.cdac_sw_3_7.nooverlap_clk_0.x3.Y VGND VGND sky130_fd_pr__nfet_01v8_lvt ad=0.0888 pd=0.98 as=0.2109 ps=2.05 w=0.74 l=0.15
X5186 single_9b_cdac_0.cdac_sw_9b_0.cdac_sw_3_0.tg_sw_3_3.SWN single_9b_cdac_0.cdac_sw_9b_0.cdac_sw_3_0.nooverlap_clk_0.x10.A VDPWR VDPWR sky130_fd_pr__pfet_01v8 ad=0.168 pd=1.42 as=0.3864 ps=2.93 w=1.12 l=0.15
X5187 VGND single_9b_cdac_0.cdac_sw_9b_0.cdac_sw_3_2.nooverlap_clk_0.x1.A single_9b_cdac_0.cdac_sw_9b_0.cdac_sw_3_2.nooverlap_clk_0.sky130_fd_sc_hs__inv_8_0.A VGND sky130_fd_pr__nfet_01v8_lvt ad=0.1221 pd=1.07 as=0.1036 ps=1.02 w=0.74 l=0.15
X5188 VDPWR VGND VDPWR VDPWR sky130_fd_pr__pfet_01v8_hvt ad=0.2262 pd=2.26 as=0 ps=0 w=0.87 l=0.59
X5189 VGND a_7813_22316# sar9b_0._14_ VGND sky130_fd_pr__nfet_01v8 ad=0.10025 pd=0.985 as=0.169 ps=1.82 w=0.65 l=0.15
X5190 single_9b_cdac_0.cdac_sw_9b_0.S[7] single_9b_cdac_0.cdac_sw_9b_0.cdac_sw_3_7.tg_sw_3_3.SWN ua[0] VDPWR sky130_fd_pr__pfet_01v8 ad=0.435 pd=3.58 as=0.435 ps=3.58 w=1.5 l=0.5
X5191 single_9b_cdac_1.cdac_sw_9b_0.cdac_sw_3_8.nooverlap_clk_0.x10.A single_9b_cdac_1.cdac_sw_9b_0.cdac_sw_3_8.nooverlap_clk_0.x8.A VGND VGND sky130_fd_pr__nfet_01v8_lvt ad=0.1036 pd=1.02 as=0.1221 ps=1.07 w=0.74 l=0.15
X5192 th_dif_sw_0.VCP single_9b_cdac_1.cdac_sw_9b_0.S[1] sky130_fd_pr__cap_mim_m3_1 l=2 w=2
X5193 a_6169_26758# a_5951_26516# VDPWR VDPWR sky130_fd_pr__pfet_01v8_hvt ad=0.12915 pd=1.185 as=0.2184 ps=2.2 w=0.84 l=0.15
X5194 VGND single_9b_cdac_0.cdac_sw_9b_0.cdac_sw_3_7.nooverlap_clk_0.CLKB0 single_9b_cdac_0.cdac_sw_9b_0.cdac_sw_3_7.nooverlap_clk_0.CLK0 VGND sky130_fd_pr__nfet_01v8_lvt ad=0.2109 pd=2.05 as=0.1036 ps=1.02 w=0.74 l=0.15
X5195 single_9b_cdac_0.cdac_sw_9b_0.S[4] single_9b_cdac_0.cdac_sw_9b_0.cdac_sw_3_3.tg_sw_3_3.SWN ua[0] VDPWR sky130_fd_pr__pfet_01v8 ad=0.435 pd=3.58 as=0.435 ps=3.58 w=1.5 l=0.5
X5196 a_7817_23252# sar9b_0.net3 sar9b_0._11_ VGND sky130_fd_pr__nfet_01v8 ad=0.08775 pd=0.92 as=0.169 ps=1.82 w=0.65 l=0.15
X5197 single_9b_cdac_0.cdac_sw_9b_0.S[5] single_9b_cdac_0.cdac_sw_9b_0.cdac_sw_3_5.tg_sw_3_3.SWN single_9b_cdac_0.cdac_sw_9b_0.S[5] VGND sky130_fd_pr__nfet_01v8 ad=0.145 pd=1.58 as=0 ps=0 w=0.5 l=0.5
X5198 th_dif_sw_0.VCP single_9b_cdac_1.cdac_sw_9b_0.S[0] sky130_fd_pr__cap_mim_m3_1 l=2 w=2
X5199 VGND a_12211_24100# a_12145_24174# VGND sky130_fd_pr__nfet_01v8 ad=0.12495 pd=1.015 as=0.0669 ps=0.75 w=0.42 l=0.15
X5200 sar9b_0._15_ sar9b_0._06_ VDPWR VDPWR sky130_fd_pr__pfet_01v8_hvt ad=0.135 pd=1.27 as=0.26 ps=2.52 w=1 l=0.15
X5201 single_9b_cdac_0.cdac_sw_9b_0.cdac_sw_3_8.tg_sw_3_3.SWP single_9b_cdac_0.cdac_sw_9b_0.cdac_sw_3_8.tg_sw_3_3.SWN VGND VGND sky130_fd_pr__nfet_01v8_lvt ad=0.1036 pd=1.02 as=0.1554 ps=1.16 w=0.74 l=0.15
X5202 VGND VDPWR VGND VGND sky130_fd_pr__nfet_01v8 ad=0.143 pd=1.62 as=0 ps=0 w=0.55 l=0.59
X5203 a_9417_23074# a_9038_22708# a_9345_23074# VGND sky130_fd_pr__nfet_01v8 ad=0.1401 pd=1.1 as=0.0441 ps=0.63 w=0.42 l=0.15
X5204 th_dif_sw_0.VCP single_9b_cdac_1.cdac_sw_9b_0.S[2] sky130_fd_pr__cap_mim_m3_1 l=2 w=2
X5205 single_9b_cdac_1.cdac_sw_9b_0.cdac_sw_3_8.tg_sw_3_3.SWN single_9b_cdac_1.cdac_sw_9b_0.cdac_sw_3_8.nooverlap_clk_0.x10.A VGND VGND sky130_fd_pr__nfet_01v8_lvt ad=0.1036 pd=1.02 as=0.1295 ps=1.09 w=0.74 l=0.15
X5206 dw_12589_1395# a_10166_3438# sky130_fd_pr__cap_mim_m3_1 l=2 w=2
X5207 VDPWR single_9b_cdac_1.cdac_sw_9b_0.cdac_sw_3_8.tg_sw_3_3.SWN single_9b_cdac_1.cdac_sw_9b_0.cdac_sw_3_8.tg_sw_3_3.SWP VDPWR sky130_fd_pr__pfet_01v8 ad=0.196 pd=1.47 as=0.168 ps=1.42 w=1.12 l=0.15
X5208 single_9b_cdac_0.cdac_sw_9b_0.S[7] single_9b_cdac_0.cdac_sw_9b_0.cdac_sw_3_7.nooverlap_clk_0.CLKB0 a_29134_26999# VDPWR sky130_fd_pr__pfet_01v8 ad=0.435 pd=3.58 as=0.435 ps=3.58 w=1.5 l=0.5
X5209 single_9b_cdac_0.cdac_sw_9b_0.S[4] single_9b_cdac_0.cdac_sw_9b_0.cdac_sw_3_3.nooverlap_clk_0.CLKB0 a_43540_26999# VDPWR sky130_fd_pr__pfet_01v8 ad=0.435 pd=3.58 as=0.435 ps=3.58 w=1.5 l=0.5
X5210 a_9738_20240# a_10055_20130# a_10013_19988# VGND sky130_fd_pr__special_nfet_01v8 ad=0.0711 pd=0.755 as=0.0669 ps=0.75 w=0.36 l=0.15
X5211 single_9b_cdac_1.cdac_sw_9b_0.S[7] single_9b_cdac_1.cdac_sw_9b_0.cdac_sw_3_7.tg_sw_3_3.SWN ua[0] VDPWR sky130_fd_pr__pfet_01v8 ad=0.435 pd=3.58 as=0.435 ps=3.58 w=1.5 l=0.5
X5212 th_dif_sw_0.VCN single_9b_cdac_0.cdac_sw_9b_0.S[3] sky130_fd_pr__cap_mim_m3_1 l=2 w=2
X5213 VGND a_14143_25188# a_14077_25262# VGND sky130_fd_pr__nfet_01v8 ad=0.12495 pd=1.015 as=0.0669 ps=0.75 w=0.42 l=0.15
X5214 VDPWR a_14143_18874# a_14130_19266# VDPWR sky130_fd_pr__pfet_01v8_hvt ad=0.0819 pd=0.81 as=0.0567 ps=0.69 w=0.42 l=0.15
X5215 a_33936_16877# single_9b_cdac_1.SW[6] VDPWR VDPWR sky130_fd_pr__pfet_01v8 ad=0.435 pd=3.58 as=0.435 ps=3.58 w=1.5 l=0.5
X5216 dw_12589_1395# a_10166_3438# sky130_fd_pr__cap_mim_m3_1 l=2 w=2
X5217 th_dif_sw_0.VCP single_9b_cdac_1.cdac_sw_9b_0.S[0] sky130_fd_pr__cap_mim_m3_1 l=2 w=2
X5218 VGND VDPWR VGND VGND sky130_fd_pr__nfet_01v8 ad=0.143 pd=1.62 as=0 ps=0 w=0.55 l=0.59
X5219 dw_12589_1395# a_10166_3438# sky130_fd_pr__cap_mim_m3_1 l=2 w=2
X5220 th_dif_sw_0.VCN single_9b_cdac_0.cdac_sw_9b_0.S[0] sky130_fd_pr__cap_mim_m3_1 l=2 w=2
X5221 a_60565_29911# single_9b_cdac_0.cdac_sw_9b_0.cdac_sw_3_1.nooverlap_clk_0.x8.A VGND VGND sky130_fd_pr__nfet_01v8_lvt ad=0.0888 pd=0.98 as=0.2109 ps=2.05 w=0.74 l=0.15
X5222 single_9b_cdac_1.cdac_sw_9b_0.cdac_sw_3_8.tg_sw_3_3.SWP single_9b_cdac_1.cdac_sw_9b_0.cdac_sw_3_8.tg_sw_3_3.SWN VDPWR VDPWR sky130_fd_pr__pfet_01v8 ad=0.168 pd=1.42 as=0.3304 ps=2.83 w=1.12 l=0.15
X5223 th_dif_sw_0.VCN single_9b_cdac_0.cdac_sw_9b_0.S[0] sky130_fd_pr__cap_mim_m3_1 l=2 w=2
X5224 single_9b_cdac_0.cdac_sw_9b_0.cdac_sw_3_6.nooverlap_clk_0.CLKB0 single_9b_cdac_0.cdac_sw_9b_0.cdac_sw_3_6.nooverlap_clk_0.sky130_fd_sc_hs__inv_8_0.A VGND VGND sky130_fd_pr__nfet_01v8_lvt ad=0.1036 pd=1.02 as=0.1295 ps=1.09 w=0.74 l=0.15
X5225 VDPWR sar9b_0.clk_div_0.COUNT\[1\] a_6631_24590# VDPWR sky130_fd_pr__pfet_01v8_hvt ad=0.1475 pd=1.295 as=0.265 ps=2.53 w=1 l=0.15
X5226 VGND VDPWR VGND VGND sky130_fd_pr__nfet_01v8 ad=0.143 pd=1.62 as=0 ps=0 w=0.55 l=0.59
X5227 single_9b_cdac_1.cdac_sw_9b_0.S[2] single_9b_cdac_1.cdac_sw_9b_0.cdac_sw_3_0.tg_sw_3_3.SWP ua[0] VGND sky130_fd_pr__nfet_01v8 ad=0.145 pd=1.58 as=0.145 ps=1.58 w=0.5 l=0.5
X5228 th_dif_sw_0.VCP single_9b_cdac_1.cdac_sw_9b_0.S[0] sky130_fd_pr__cap_mim_m3_1 l=2 w=2
X5229 th_dif_sw_0.VCN single_9b_cdac_0.cdac_sw_9b_0.S[1] sky130_fd_pr__cap_mim_m3_1 l=2 w=2
X5230 single_9b_cdac_1.cdac_sw_9b_0.cdac_sw_3_1.nooverlap_clk_0.CLKB0 single_9b_cdac_1.cdac_sw_9b_0.cdac_sw_3_1.nooverlap_clk_0.sky130_fd_sc_hs__inv_8_0.A VDPWR VDPWR sky130_fd_pr__pfet_01v8 ad=0.168 pd=1.42 as=0.3304 ps=2.83 w=1.12 l=0.15
X5231 th_dif_sw_0.VCP single_9b_cdac_1.cdac_sw_9b_0.S[1] sky130_fd_pr__cap_mim_m3_1 l=2 w=2
X5232 a_10305_26516# a_9115_26516# a_10196_26516# VGND sky130_fd_pr__special_nfet_01v8 ad=0.0669 pd=0.75 as=0.0711 ps=0.755 w=0.36 l=0.15
X5233 VGND VDPWR VGND VGND sky130_fd_pr__nfet_01v8 ad=0.143 pd=1.62 as=0 ps=0 w=0.55 l=0.59
X5234 sar9b_0.clk_div_0.COUNT\[2\] a_7203_22682# VGND VGND sky130_fd_pr__nfet_01v8 ad=0.169 pd=1.82 as=0.08775 ps=0.92 w=0.65 l=0.15
X5235 a_12225_18362# a_12059_18362# VGND VGND sky130_fd_pr__nfet_01v8 ad=0.1092 pd=1.36 as=0.0567 ps=0.69 w=0.42 l=0.15
X5236 single_9b_cdac_1.cdac_sw_9b_0.cdac_sw_3_0.nooverlap_clk_0.x1.A single_9b_cdac_1.cdac_sw_9b_0.cdac_sw_3_0.nooverlap_clk_0.sky130_fd_sc_hs__inv_1_1.A VDPWR VDPWR sky130_fd_pr__pfet_01v8 ad=0.3304 pd=2.83 as=0.3864 ps=2.93 w=1.12 l=0.15
X5237 th_dif_sw_0.VCP single_9b_cdac_1.cdac_sw_9b_0.S[0] sky130_fd_pr__cap_mim_m3_1 l=2 w=2
X5238 single_9b_cdac_1.cdac_sw_9b_0.cdac_sw_3_8.nooverlap_clk_0.sky130_fd_sc_hs__inv_1_1.A single_9b_cdac_1.cdac_sw_9b_0.cdac_sw_3_8.nooverlap_clk_0.sky130_fd_sc_hs__nand2_1_0.Y VGND VGND sky130_fd_pr__nfet_01v8_lvt ad=0.2109 pd=2.05 as=0.2627 ps=2.19 w=0.74 l=0.15
X5239 VGND a_11935_25402# a_11869_25428# VGND sky130_fd_pr__nfet_01v8 ad=0.12495 pd=1.015 as=0.0669 ps=0.75 w=0.42 l=0.15
X5240 a_13968_25262# a_12887_24890# a_13621_24858# VDPWR sky130_fd_pr__pfet_01v8_hvt ad=0.0588 pd=0.7 as=0.12915 ps=1.185 w=0.42 l=0.15
X5241 VGND single_9b_cdac_1.cdac_sw_9b_0.cdac_sw_3_6.nooverlap_clk_0.CLKB0 single_9b_cdac_1.cdac_sw_9b_0.cdac_sw_3_6.nooverlap_clk_0.CLK0 VGND sky130_fd_pr__nfet_01v8_lvt ad=0.1036 pd=1.02 as=0.1036 ps=1.02 w=0.74 l=0.15
X5242 a_36555_15501# single_9b_cdac_1.CF[6] single_9b_cdac_1.cdac_sw_9b_0.cdac_sw_3_6.nooverlap_clk_0.sky130_fd_sc_hs__nand2_1_0.Y VGND sky130_fd_pr__nfet_01v8_lvt ad=0.0888 pd=0.98 as=0.2109 ps=2.05 w=0.74 l=0.15
X5243 th_dif_sw_0.VCP single_9b_cdac_1.cdac_sw_9b_0.S[0] sky130_fd_pr__cap_mim_m3_1 l=2 w=2
X5244 th_dif_sw_0.VCP single_9b_cdac_1.cdac_sw_9b_0.S[2] sky130_fd_pr__cap_mim_m3_1 l=2 w=2
X5245 single_9b_cdac_0.cdac_sw_9b_0.S[2] single_9b_cdac_0.cdac_sw_9b_0.cdac_sw_3_0.tg_sw_3_3.SWN ua[0] VDPWR sky130_fd_pr__pfet_01v8 ad=0.435 pd=3.58 as=0.435 ps=3.58 w=1.5 l=0.5
X5246 th_dif_sw_0.VCN single_9b_cdac_0.cdac_sw_9b_0.S[0] sky130_fd_pr__cap_mim_m3_1 l=2 w=2
X5247 ua[0] single_9b_cdac_0.cdac_sw_9b_0.cdac_sw_3_5.tg_sw_3_3.SWP ua[0] VDPWR sky130_fd_pr__pfet_01v8 ad=0.435 pd=3.58 as=0 ps=0 w=1.5 l=0.5
X5248 VDPWR a_13315_18660# a_13302_18356# VDPWR sky130_fd_pr__pfet_01v8_hvt ad=0.0819 pd=0.81 as=0.0567 ps=0.69 w=0.42 l=0.15
X5249 VDPWR single_9b_cdac_1.cdac_sw_9b_0.cdac_sw_3_4.nooverlap_clk_0.x8.A single_9b_cdac_1.cdac_sw_9b_0.cdac_sw_3_4.nooverlap_clk_0.sky130_fd_sc_hs__nand2_1_0.Y VDPWR sky130_fd_pr__pfet_01v8 ad=0.3192 pd=2.81 as=0.168 ps=1.42 w=1.12 l=0.15
X5250 VGND single_9b_cdac_0.cdac_sw_9b_0.cdac_sw_3_2.tg_sw_3_3.SWN single_9b_cdac_0.cdac_sw_9b_0.cdac_sw_3_2.tg_sw_3_3.SWP VGND sky130_fd_pr__nfet_01v8_lvt ad=0.1036 pd=1.02 as=0.1036 ps=1.02 w=0.74 l=0.15
X5251 a_6705_25978# a_6539_25978# VDPWR VDPWR sky130_fd_pr__pfet_01v8_hvt ad=0.1664 pd=1.8 as=0.0864 ps=0.91 w=0.64 l=0.15
X5252 VDPWR VGND VDPWR VDPWR sky130_fd_pr__pfet_01v8_hvt ad=0.2262 pd=2.26 as=0 ps=0 w=0.87 l=0.59
X5253 th_dif_sw_0.VCP single_9b_cdac_1.cdac_sw_9b_0.S[0] sky130_fd_pr__cap_mim_m3_1 l=2 w=2
X5254 VGND VDPWR VGND VGND sky130_fd_pr__nfet_01v8 ad=0.143 pd=1.62 as=0 ps=0 w=0.55 l=0.59
X5255 th_dif_sw_0.VCP single_9b_cdac_1.cdac_sw_9b_0.S[2] sky130_fd_pr__cap_mim_m3_1 l=2 w=2
X5256 th_dif_sw_0.VCP single_9b_cdac_1.cdac_sw_9b_0.S[0] sky130_fd_pr__cap_mim_m3_1 l=2 w=2
X5257 single_9b_cdac_1.cdac_sw_9b_0.S[0] single_9b_cdac_1.cdac_sw_9b_0.cdac_sw_3_2.tg_sw_3_3.SWP ua[0] VGND sky130_fd_pr__nfet_01v8 ad=0.145 pd=1.58 as=0.145 ps=1.58 w=0.5 l=0.5
X5258 a_30012_26990# single_9b_cdac_0.cdac_sw_9b_0.cdac_sw_3_7.nooverlap_clk_0.CLK0 single_9b_cdac_0.cdac_sw_9b_0.S[7] VGND sky130_fd_pr__nfet_01v8 ad=0.145 pd=1.58 as=0.145 ps=1.58 w=0.5 l=0.5
X5259 a_8991_26350# a_8545_25978# a_8895_26350# VGND sky130_fd_pr__special_nfet_01v8 ad=0.1401 pd=1.1 as=0.0594 ps=0.69 w=0.36 l=0.15
X5260 VGND single_9b_cdac_1.cdac_sw_9b_0.cdac_sw_3_6.nooverlap_clk_0.x8.A single_9b_cdac_1.cdac_sw_9b_0.cdac_sw_3_6.nooverlap_clk_0.x10.A VGND sky130_fd_pr__nfet_01v8_lvt ad=0.2109 pd=2.05 as=0.1036 ps=1.02 w=0.74 l=0.15
X5261 single_9b_cdac_1.cdac_sw_9b_0.cdac_sw_3_4.nooverlap_clk_0.sky130_fd_sc_hs__nand2_1_0.Y single_9b_cdac_1.CF[3] VDPWR VDPWR sky130_fd_pr__pfet_01v8 ad=0.168 pd=1.42 as=0.3192 ps=2.81 w=1.12 l=0.15
X5262 a_5725_27426# a_5690_27192# a_5487_27034# VGND sky130_fd_pr__nfet_01v8 ad=0.06405 pd=0.725 as=0.1092 ps=1.36 w=0.42 l=0.15
X5263 a_12211_26490# sar9b_0.net3 VDPWR VDPWR sky130_fd_pr__pfet_01v8_hvt ad=0.0567 pd=0.69 as=0.0819 ps=0.81 w=0.42 l=0.15
X5264 single_9b_cdac_0.cdac_sw_9b_0.cdac_sw_3_2.nooverlap_clk_0.sky130_fd_sc_hs__inv_8_0.A single_9b_cdac_0.cdac_sw_9b_0.cdac_sw_3_2.nooverlap_clk_0.x1.A VDPWR VDPWR sky130_fd_pr__pfet_01v8 ad=0.168 pd=1.42 as=0.168 ps=1.42 w=1.12 l=0.15
X5265 VDPWR sar9b_0.net33 a_13623_25972# VDPWR sky130_fd_pr__pfet_01v8_hvt ad=0.11455 pd=1.08 as=0.2054 ps=2.1 w=0.79 l=0.15
X5266 a_34814_17740# single_9b_cdac_1.cdac_sw_9b_0.cdac_sw_3_6.nooverlap_clk_0.CLK0 single_9b_cdac_1.cdac_sw_9b_0.S[6] VGND sky130_fd_pr__nfet_01v8 ad=0.145 pd=1.58 as=0.145 ps=1.58 w=0.5 l=0.5
X5267 single_9b_cdac_0.cdac_sw_9b_0.S[6] single_9b_cdac_0.cdac_sw_9b_0.cdac_sw_3_6.tg_sw_3_3.SWN ua[0] VDPWR sky130_fd_pr__pfet_01v8 ad=0.435 pd=3.58 as=0.435 ps=3.58 w=1.5 l=0.5
X5268 a_10935_23618# sar9b_0.net15 VDPWR VDPWR sky130_fd_pr__pfet_01v8_hvt ad=0.1092 pd=1.36 as=0.07035 ps=0.755 w=0.42 l=0.15
X5269 VDPWR single_9b_cdac_1.cdac_sw_9b_0.cdac_sw_3_5.nooverlap_clk_0.x10.A single_9b_cdac_1.cdac_sw_9b_0.cdac_sw_3_5.tg_sw_3_3.SWN VDPWR sky130_fd_pr__pfet_01v8 ad=0.196 pd=1.47 as=0.168 ps=1.42 w=1.12 l=0.15
X5270 th_dif_sw_0.VCP single_9b_cdac_1.cdac_sw_9b_0.S[2] sky130_fd_pr__cap_mim_m3_1 l=2 w=2
X5271 th_dif_sw_0.VCP single_9b_cdac_1.cdac_sw_9b_0.S[2] sky130_fd_pr__cap_mim_m3_1 l=2 w=2
X5272 single_9b_cdac_0.cdac_sw_9b_0.S[4] single_9b_cdac_0.cdac_sw_9b_0.cdac_sw_3_3.tg_sw_3_3.SWN single_9b_cdac_0.cdac_sw_9b_0.S[4] VGND sky130_fd_pr__nfet_01v8 ad=0.145 pd=1.58 as=0 ps=0 w=0.5 l=0.5
X5273 VDPWR VGND VDPWR VDPWR sky130_fd_pr__pfet_01v8_hvt ad=0.2262 pd=2.26 as=0 ps=0 w=0.87 l=0.59
X5274 a_14051_24100# a_13876_24174# a_14230_24162# VGND sky130_fd_pr__nfet_01v8 ad=0.1092 pd=1.36 as=0.06405 ps=0.725 w=0.42 l=0.15
X5275 th_dif_sw_0.VCN single_9b_cdac_0.cdac_sw_9b_0.S[1] sky130_fd_pr__cap_mim_m3_1 l=2 w=2
X5276 a_16185_13034# tdc_0.phase_detector_0.pd_out_0.B VDPWR VDPWR sky130_fd_pr__pfet_01v8 ad=0.196 pd=1.47 as=0.2352 ps=1.54 w=1.12 l=0.15
X5277 single_9b_cdac_1.cdac_sw_9b_0.S[0] single_9b_cdac_1.cdac_sw_9b_0.cdac_sw_3_2.tg_sw_3_3.SWN ua[0] VDPWR sky130_fd_pr__pfet_01v8 ad=0.435 pd=3.58 as=0.435 ps=3.58 w=1.5 l=0.5
X5278 VDPWR single_9b_cdac_0.cdac_sw_9b_0.cdac_sw_3_2.nooverlap_clk_0.x1.A single_9b_cdac_0.cdac_sw_9b_0.cdac_sw_3_2.nooverlap_clk_0.sky130_fd_sc_hs__inv_8_0.A VDPWR sky130_fd_pr__pfet_01v8 ad=0.168 pd=1.42 as=0.168 ps=1.42 w=1.12 l=0.15
X5279 a_8637_23252# a_8471_23252# VGND VGND sky130_fd_pr__nfet_01v8 ad=0.1092 pd=1.36 as=0.0567 ps=0.69 w=0.42 l=0.15
X5280 a_6337_22714# a_6171_22714# VGND VGND sky130_fd_pr__nfet_01v8 ad=0.1092 pd=1.36 as=0.0567 ps=0.69 w=0.42 l=0.15
X5281 VGND single_9b_cdac_1.cdac_sw_9b_0.cdac_sw_3_6.nooverlap_clk_0.x10.A single_9b_cdac_1.cdac_sw_9b_0.cdac_sw_3_6.tg_sw_3_3.SWN VGND sky130_fd_pr__nfet_01v8_lvt ad=0.1554 pd=1.16 as=0.1036 ps=1.02 w=0.74 l=0.15
X5282 dw_17224_1400# a_21368_4076# sky130_fd_pr__cap_mim_m3_1 l=2 w=2
X5283 th_dif_sw_0.th_sw_1.CK a_9132_7271# VGND VGND sky130_fd_pr__nfet_01v8_lvt ad=0.1036 pd=1.02 as=0.1036 ps=1.02 w=0.74 l=0.15
X5284 a_13308_26516# sar9b_0.net1 VGND VGND sky130_fd_pr__nfet_01v8 ad=0.066 pd=0.745 as=0.2205 ps=1.89 w=0.42 l=0.15
X5285 a_57946_26999# single_9b_cdac_0.SW[1] VDPWR VDPWR sky130_fd_pr__pfet_01v8 ad=0.435 pd=3.58 as=0.435 ps=3.58 w=1.5 l=0.5
X5286 single_9b_cdac_1.cdac_sw_9b_0.cdac_sw_3_5.nooverlap_clk_0.CLK0 single_9b_cdac_1.cdac_sw_9b_0.cdac_sw_3_5.nooverlap_clk_0.CLKB0 VGND VGND sky130_fd_pr__nfet_01v8_lvt ad=0.1036 pd=1.02 as=0.1554 ps=1.16 w=0.74 l=0.15
X5287 VGND single_9b_cdac_1.cdac_sw_9b_0.cdac_sw_3_2.nooverlap_clk_0.CLKB0 single_9b_cdac_1.cdac_sw_9b_0.cdac_sw_3_2.nooverlap_clk_0.CLK0 VGND sky130_fd_pr__nfet_01v8_lvt ad=0.1295 pd=1.09 as=0.1036 ps=1.02 w=0.74 l=0.15
X5288 single_9b_cdac_0.cdac_sw_9b_0.cdac_sw_3_1.tg_sw_3_3.SWP single_9b_cdac_0.cdac_sw_9b_0.cdac_sw_3_1.tg_sw_3_3.SWN VGND VGND sky130_fd_pr__nfet_01v8_lvt ad=0.1036 pd=1.02 as=0.2146 ps=2.06 w=0.74 l=0.15
X5289 a_10012_22164# a_9097_22164# a_9665_22406# VGND sky130_fd_pr__special_nfet_01v8 ad=0.0711 pd=0.755 as=0.0999 ps=0.985 w=0.36 l=0.15
X5290 single_9b_cdac_1.SW[3] a_13347_20532# VGND VGND sky130_fd_pr__nfet_01v8 ad=0.1352 pd=1.56 as=0.0754 ps=0.81 w=0.52 l=0.15
X5291 a_9530_19444# a_8453_19450# a_9368_19822# VDPWR sky130_fd_pr__pfet_01v8_hvt ad=0.0567 pd=0.69 as=0.0588 ps=0.7 w=0.42 l=0.15
X5292 single_9b_cdac_1.cdac_sw_9b_0.S[5] single_9b_cdac_1.cdac_sw_9b_0.cdac_sw_3_5.tg_sw_3_3.SWN single_9b_cdac_1.cdac_sw_9b_0.S[5] VGND sky130_fd_pr__nfet_01v8 ad=0.145 pd=1.58 as=0 ps=0 w=0.5 l=0.5
X5293 single_9b_cdac_1.cdac_sw_9b_0.cdac_sw_3_5.tg_sw_3_3.SWN single_9b_cdac_1.cdac_sw_9b_0.cdac_sw_3_5.nooverlap_clk_0.x10.A VDPWR VDPWR sky130_fd_pr__pfet_01v8 ad=0.168 pd=1.42 as=0.168 ps=1.42 w=1.12 l=0.15
X5294 th_dif_sw_0.VCN single_9b_cdac_0.cdac_sw_9b_0.S[3] sky130_fd_pr__cap_mim_m3_1 l=2 w=2
X5295 a_48343_26999# single_9b_cdac_0.SW[3] VDPWR VDPWR sky130_fd_pr__pfet_01v8 ad=0.435 pd=3.58 as=0.435 ps=3.58 w=1.5 l=0.5
X5296 single_9b_cdac_0.cdac_sw_9b_0.cdac_sw_3_2.nooverlap_clk_0.sky130_fd_sc_hs__inv_8_0.A single_9b_cdac_0.cdac_sw_9b_0.cdac_sw_3_2.nooverlap_clk_0.x1.A VDPWR VDPWR sky130_fd_pr__pfet_01v8 ad=0.168 pd=1.42 as=0.3304 ps=2.83 w=1.12 l=0.15
X5297 a_10827_25262# a_10477_24890# a_10732_25250# VDPWR sky130_fd_pr__pfet_01v8_hvt ad=0.07245 pd=0.765 as=0.0651 ps=0.73 w=0.42 l=0.15
X5298 a_14077_18900# a_12887_18900# a_13968_18900# VGND sky130_fd_pr__special_nfet_01v8 ad=0.0669 pd=0.75 as=0.0711 ps=0.755 w=0.36 l=0.15
X5299 single_9b_cdac_0.cdac_sw_9b_0.cdac_sw_3_8.nooverlap_clk_0.sky130_fd_sc_hs__inv_8_0.A single_9b_cdac_0.cdac_sw_9b_0.cdac_sw_3_8.nooverlap_clk_0.x1.A VGND VGND sky130_fd_pr__nfet_01v8_lvt ad=0.1036 pd=1.02 as=0.2109 ps=2.05 w=0.74 l=0.15
X5300 a_6058_23618# a_5619_23252# a_5973_23252# VGND sky130_fd_pr__special_nfet_01v8 ad=0.0621 pd=0.705 as=0.0813 ps=0.83 w=0.36 l=0.15
X5301 single_9b_cdac_1.cdac_sw_9b_0.S[6] single_9b_cdac_1.cdac_sw_9b_0.cdac_sw_3_6.tg_sw_3_3.SWN ua[0] VDPWR sky130_fd_pr__pfet_01v8 ad=0.435 pd=3.58 as=0.435 ps=3.58 w=1.5 l=0.5
X5302 single_9b_cdac_0.cdac_sw_9b_0.S[5] single_9b_cdac_0.cdac_sw_9b_0.cdac_sw_3_5.nooverlap_clk_0.CLKB0 a_38738_26999# VDPWR sky130_fd_pr__pfet_01v8 ad=0.435 pd=3.58 as=0.435 ps=3.58 w=1.5 l=0.5
X5303 VDPWR single_9b_cdac_1.cdac_sw_9b_0.cdac_sw_3_5.nooverlap_clk_0.x10.A single_9b_cdac_1.cdac_sw_9b_0.cdac_sw_3_5.tg_sw_3_3.SWN VDPWR sky130_fd_pr__pfet_01v8 ad=0.168 pd=1.42 as=0.168 ps=1.42 w=1.12 l=0.15
X5304 th_dif_sw_0.VCP single_9b_cdac_1.cdac_sw_9b_0.S[1] sky130_fd_pr__cap_mim_m3_1 l=2 w=2
X5305 VDPWR sar9b_0.net6 a_12059_18362# VDPWR sky130_fd_pr__pfet_01v8_hvt ad=0.0864 pd=0.91 as=0.1664 ps=1.8 w=0.64 l=0.15
X5306 th_dif_sw_0.VCP single_9b_cdac_1.cdac_sw_9b_0.S[0] sky130_fd_pr__cap_mim_m3_1 l=2 w=2
X5307 VGND VDPWR VGND VGND sky130_fd_pr__nfet_01v8 ad=0.143 pd=1.62 as=0 ps=0 w=0.55 l=0.59
X5308 a_14322_25428# sar9b_0.net15 VGND VGND sky130_fd_pr__nfet_01v8 ad=0.06405 pd=0.725 as=0.12495 ps=1.015 w=0.42 l=0.15
X5309 th_dif_sw_0.VCP single_9b_cdac_1.cdac_sw_9b_0.S[0] sky130_fd_pr__cap_mim_m3_1 l=2 w=2
X5310 th_dif_sw_0.VCN single_9b_cdac_0.cdac_sw_9b_0.S[0] sky130_fd_pr__cap_mim_m3_1 l=2 w=2
X5311 VGND single_9b_cdac_0.cdac_sw_9b_0.cdac_sw_3_7.nooverlap_clk_0.CLKB0 single_9b_cdac_0.cdac_sw_9b_0.cdac_sw_3_7.nooverlap_clk_0.CLK0 VGND sky130_fd_pr__nfet_01v8_lvt ad=0.1036 pd=1.02 as=0.1036 ps=1.02 w=0.74 l=0.15
X5312 a_13621_19418# a_13403_19822# VDPWR VDPWR sky130_fd_pr__pfet_01v8_hvt ad=0.12915 pd=1.185 as=0.2184 ps=2.2 w=0.84 l=0.15
X5313 single_9b_cdac_1.cdac_sw_9b_0.cdac_sw_3_5.tg_sw_3_3.SWN single_9b_cdac_1.cdac_sw_9b_0.cdac_sw_3_5.nooverlap_clk_0.x10.A VDPWR VDPWR sky130_fd_pr__pfet_01v8 ad=0.168 pd=1.42 as=0.196 ps=1.47 w=1.12 l=0.15
X5314 th_dif_sw_0.VCN single_9b_cdac_0.cdac_sw_9b_0.S[1] sky130_fd_pr__cap_mim_m3_1 l=2 w=2
X5315 VGND single_9b_cdac_0.cdac_sw_9b_0.cdac_sw_3_4.nooverlap_clk_0.sky130_fd_sc_hs__inv_1_1.A single_9b_cdac_0.cdac_sw_9b_0.cdac_sw_3_4.nooverlap_clk_0.x1.A VGND sky130_fd_pr__nfet_01v8_lvt ad=0.2627 pd=2.19 as=0.2109 ps=2.05 w=0.74 l=0.15
X5316 th_dif_sw_0.VCP single_9b_cdac_1.cdac_sw_9b_0.S[1] sky130_fd_pr__cap_mim_m3_1 l=2 w=2
X5317 VDPWR sar9b_0.net42 a_14451_20532# VDPWR sky130_fd_pr__pfet_01v8_hvt ad=0.11455 pd=1.08 as=0.2054 ps=2.1 w=0.79 l=0.15
X5318 ua[0] single_9b_cdac_1.cdac_sw_9b_0.cdac_sw_3_1.tg_sw_3_3.SWP ua[0] VDPWR sky130_fd_pr__pfet_01v8 ad=0.435 pd=3.58 as=0 ps=0 w=1.5 l=0.5
X5319 VDPWR a_6701_20506# sar9b_0.clknet_1_0__leaf_CLK VDPWR sky130_fd_pr__pfet_01v8_hvt ad=0.14 pd=1.28 as=0.14 ps=1.28 w=1 l=0.15
X5320 single_9b_cdac_1.cdac_sw_9b_0.cdac_sw_3_5.nooverlap_clk_0.x10.A single_9b_cdac_1.cdac_sw_9b_0.cdac_sw_3_5.nooverlap_clk_0.x8.A VGND VGND sky130_fd_pr__nfet_01v8_lvt ad=0.1036 pd=1.02 as=0.1221 ps=1.07 w=0.74 l=0.15
X5321 th_dif_sw_0.VCP single_9b_cdac_1.cdac_sw_9b_0.S[0] sky130_fd_pr__cap_mim_m3_1 l=2 w=2
X5322 th_dif_sw_0.VCP single_9b_cdac_1.cdac_sw_9b_0.S[1] sky130_fd_pr__cap_mim_m3_1 l=2 w=2
X5323 th_dif_sw_0.VCN single_9b_cdac_0.cdac_sw_9b_0.S[2] sky130_fd_pr__cap_mim_m3_1 l=2 w=2
X5324 VDPWR single_9b_cdac_0.cdac_sw_9b_0.cdac_sw_3_7.nooverlap_clk_0.sky130_fd_sc_hs__inv_8_0.A single_9b_cdac_0.cdac_sw_9b_0.cdac_sw_3_7.nooverlap_clk_0.CLKB0 VDPWR sky130_fd_pr__pfet_01v8 ad=0.3304 pd=2.83 as=0.168 ps=1.42 w=1.12 l=0.15
X5325 VDPWR single_9b_cdac_0.cdac_sw_9b_0.cdac_sw_3_6.tg_sw_3_3.SWN single_9b_cdac_0.cdac_sw_9b_0.cdac_sw_3_6.tg_sw_3_3.SWP VDPWR sky130_fd_pr__pfet_01v8 ad=0.3304 pd=2.83 as=0.168 ps=1.42 w=1.12 l=0.15
X5326 a_10923_23252# a_10477_23252# a_10827_23252# VGND sky130_fd_pr__special_nfet_01v8 ad=0.1401 pd=1.1 as=0.0594 ps=0.69 w=0.36 l=0.15
X5327 VGND sar9b_0.net15 a_9893_21076# VGND sky130_fd_pr__nfet_01v8 ad=0.1346 pd=1.15 as=0.0441 ps=0.63 w=0.42 l=0.15
X5328 VGND a_6907_19444# sar9b_0.clkload0.X VGND sky130_fd_pr__nfet_01v8 ad=0.0588 pd=0.7 as=0.0588 ps=0.7 w=0.42 l=0.15
X5329 sar9b_0.net42 a_11567_23226# VGND VGND sky130_fd_pr__nfet_01v8 ad=0.169 pd=1.82 as=0.2087 ps=2.02 w=0.65 l=0.15
X5330 a_13621_21318# a_13403_21076# VGND VGND sky130_fd_pr__nfet_01v8 ad=0.0999 pd=0.985 as=0.1346 ps=1.15 w=0.64 l=0.15
X5331 VDPWR VGND VDPWR VDPWR sky130_fd_pr__pfet_01v8_hvt ad=0.2262 pd=2.26 as=0 ps=0 w=0.87 l=0.59
X5332 ua[0] single_9b_cdac_0.cdac_sw_9b_0.cdac_sw_3_3.tg_sw_3_3.SWP ua[0] VDPWR sky130_fd_pr__pfet_01v8 ad=0.435 pd=3.58 as=0 ps=0 w=1.5 l=0.5
X5333 single_9b_cdac_0.cdac_sw_9b_0.cdac_sw_3_5.tg_sw_3_3.SWP single_9b_cdac_0.cdac_sw_9b_0.cdac_sw_3_5.tg_sw_3_3.SWN VGND VGND sky130_fd_pr__nfet_01v8_lvt ad=0.1036 pd=1.02 as=0.1554 ps=1.16 w=0.74 l=0.15
X5334 single_9b_cdac_1.cdac_sw_9b_0.cdac_sw_3_5.tg_sw_3_3.SWN single_9b_cdac_1.cdac_sw_9b_0.cdac_sw_3_5.nooverlap_clk_0.x10.A VGND VGND sky130_fd_pr__nfet_01v8_lvt ad=0.1036 pd=1.02 as=0.1295 ps=1.09 w=0.74 l=0.15
X5335 single_9b_cdac_0.cdac_sw_9b_0.cdac_sw_3_7.nooverlap_clk_0.CLKB0 single_9b_cdac_0.cdac_sw_9b_0.cdac_sw_3_7.nooverlap_clk_0.sky130_fd_sc_hs__inv_8_0.A VDPWR VDPWR sky130_fd_pr__pfet_01v8 ad=0.168 pd=1.42 as=0.196 ps=1.47 w=1.12 l=0.15
X5336 single_9b_cdac_0.cdac_sw_9b_0.cdac_sw_3_6.tg_sw_3_3.SWP single_9b_cdac_0.cdac_sw_9b_0.cdac_sw_3_6.tg_sw_3_3.SWN VDPWR VDPWR sky130_fd_pr__pfet_01v8 ad=0.168 pd=1.42 as=0.196 ps=1.47 w=1.12 l=0.15
X5337 a_7725_23028# sar9b_0.clk_div_0.COUNT\[2\] VGND VGND sky130_fd_pr__nfet_01v8 ad=0.08775 pd=0.92 as=0.169 ps=1.82 w=0.65 l=0.15
X5338 a_11397_20538# a_11231_20538# VGND VGND sky130_fd_pr__nfet_01v8 ad=0.1092 pd=1.36 as=0.0567 ps=0.69 w=0.42 l=0.15
X5339 single_9b_cdac_1.cdac_sw_9b_0.S[5] single_9b_cdac_1.cdac_sw_9b_0.cdac_sw_3_5.tg_sw_3_3.SWP single_9b_cdac_1.cdac_sw_9b_0.S[5] VDPWR sky130_fd_pr__pfet_01v8 ad=0.435 pd=3.58 as=0 ps=0 w=1.5 l=0.5
X5340 th_dif_sw_0.VCN single_9b_cdac_0.cdac_sw_9b_0.S[0] sky130_fd_pr__cap_mim_m3_1 l=2 w=2
X5341 th_dif_sw_0.VCP single_9b_cdac_1.cdac_sw_9b_0.S[0] sky130_fd_pr__cap_mim_m3_1 l=2 w=2
X5342 VGND VDPWR VGND VGND sky130_fd_pr__nfet_01v8 ad=0.143 pd=1.62 as=0 ps=0 w=0.55 l=0.59
X5343 dw_12589_1395# a_10166_3438# sky130_fd_pr__cap_mim_m3_1 l=2 w=2
X5344 VGND a_14143_25402# a_14077_25428# VGND sky130_fd_pr__nfet_01v8 ad=0.12495 pd=1.015 as=0.0669 ps=0.75 w=0.42 l=0.15
X5345 VGND single_9b_cdac_1.CF[1] single_9b_cdac_0.cdac_sw_9b_0.cdac_sw_3_1.nooverlap_clk_0.x3.Y VGND sky130_fd_pr__nfet_01v8_lvt ad=0.2627 pd=2.19 as=0.2109 ps=2.05 w=0.74 l=0.15
X5346 VGND sar9b_0.clk_div_0.COUNT\[1\] a_7448_23252# VGND sky130_fd_pr__nfet_01v8 ad=0.17225 pd=1.83 as=0.091 ps=0.93 w=0.65 l=0.15
X5347 VGND a_11567_25188# a_11501_25262# VGND sky130_fd_pr__nfet_01v8 ad=0.12495 pd=1.015 as=0.0669 ps=0.75 w=0.42 l=0.15
X5348 VDPWR VGND VDPWR VDPWR sky130_fd_pr__pfet_01v8_hvt ad=0.2262 pd=2.26 as=0 ps=0 w=0.87 l=0.59
X5349 single_9b_cdac_1.cdac_sw_9b_0.S[7] single_9b_cdac_1.cdac_sw_9b_0.cdac_sw_3_7.tg_sw_3_3.SWP ua[0] VGND sky130_fd_pr__nfet_01v8 ad=0.145 pd=1.58 as=0.145 ps=1.58 w=0.5 l=0.5
X5350 dw_12589_1395# a_10166_3438# sky130_fd_pr__cap_mim_m3_1 l=2 w=2
X5351 a_9175_27364# sar9b_0.net3 VDPWR VDPWR sky130_fd_pr__pfet_01v8_hvt ad=0.0567 pd=0.69 as=0.0819 ps=0.81 w=0.42 l=0.15
X5352 VDPWR a_11852_22164# a_12027_22138# VDPWR sky130_fd_pr__pfet_01v8_hvt ad=0.1134 pd=1.38 as=0.0567 ps=0.69 w=0.42 l=0.15
X5353 a_13308_19988# sar9b_0.net1 VGND VGND sky130_fd_pr__nfet_01v8 ad=0.066 pd=0.745 as=0.2205 ps=1.89 w=0.42 l=0.15
X5354 VGND single_9b_cdac_1.cdac_sw_9b_0.cdac_sw_3_8.nooverlap_clk_0.x10.A single_9b_cdac_1.cdac_sw_9b_0.cdac_sw_3_8.tg_sw_3_3.SWN VGND sky130_fd_pr__nfet_01v8_lvt ad=0.2146 pd=2.06 as=0.1036 ps=1.02 w=0.74 l=0.15
X5355 th_dif_sw_0.VCP single_9b_cdac_1.cdac_sw_9b_0.S[0] sky130_fd_pr__cap_mim_m3_1 l=2 w=2
X5356 single_9b_cdac_0.cdac_sw_9b_0.cdac_sw_3_7.nooverlap_clk_0.x10.A single_9b_cdac_0.cdac_sw_9b_0.cdac_sw_3_7.nooverlap_clk_0.x8.A VDPWR VDPWR sky130_fd_pr__pfet_01v8 ad=0.168 pd=1.42 as=0.168 ps=1.42 w=1.12 l=0.15
X5357 VGND single_9b_cdac_0.cdac_sw_9b_0.cdac_sw_3_6.nooverlap_clk_0.x1.A single_9b_cdac_0.cdac_sw_9b_0.cdac_sw_3_6.nooverlap_clk_0.sky130_fd_sc_hs__inv_8_0.A VGND sky130_fd_pr__nfet_01v8_lvt ad=0.1221 pd=1.07 as=0.1036 ps=1.02 w=0.74 l=0.15
X5358 single_9b_cdac_1.cdac_sw_9b_0.S[4] single_9b_cdac_1.cdac_sw_9b_0.cdac_sw_3_3.tg_sw_3_3.SWN single_9b_cdac_1.cdac_sw_9b_0.S[4] VGND sky130_fd_pr__nfet_01v8 ad=0.145 pd=1.58 as=0 ps=0 w=0.5 l=0.5
X5359 th_dif_sw_0.VCP single_9b_cdac_1.cdac_sw_9b_0.S[1] sky130_fd_pr__cap_mim_m3_1 l=2 w=2
X5360 VGND sar9b_0.net4 a_10955_18900# VGND sky130_fd_pr__nfet_01v8 ad=0.0567 pd=0.69 as=0.1092 ps=1.36 w=0.42 l=0.15
X5361 th_dif_sw_0.VCN single_9b_cdac_0.cdac_sw_9b_0.S[1] sky130_fd_pr__cap_mim_m3_1 l=2 w=2
X5362 th_dif_sw_0.VCP single_9b_cdac_1.cdac_sw_9b_0.S[0] sky130_fd_pr__cap_mim_m3_1 l=2 w=2
X5363 VDPWR single_9b_cdac_0.cdac_sw_9b_0.cdac_sw_3_7.nooverlap_clk_0.x8.A single_9b_cdac_0.cdac_sw_9b_0.cdac_sw_3_7.nooverlap_clk_0.x10.A VDPWR sky130_fd_pr__pfet_01v8 ad=0.168 pd=1.42 as=0.168 ps=1.42 w=1.12 l=0.15
X5364 single_9b_cdac_0.cdac_sw_9b_0.S[4] single_9b_cdac_0.cdac_sw_9b_0.cdac_sw_3_3.nooverlap_clk_0.CLKB0 a_43540_26999# VDPWR sky130_fd_pr__pfet_01v8 ad=0.435 pd=3.58 as=0.435 ps=3.58 w=1.5 l=0.5
X5365 single_9b_cdac_1.cdac_sw_9b_0.S[7] single_9b_cdac_1.cdac_sw_9b_0.cdac_sw_3_7.tg_sw_3_3.SWN ua[0] VDPWR sky130_fd_pr__pfet_01v8 ad=0.435 pd=3.58 as=0.435 ps=3.58 w=1.5 l=0.5
X5366 a_9739_26882# sar9b_0.net3 VDPWR VDPWR sky130_fd_pr__pfet_01v8_hvt ad=0.1092 pd=1.36 as=0.07035 ps=0.755 w=0.42 l=0.15
X5367 a_12793_18330# a_12575_18734# VGND VGND sky130_fd_pr__nfet_01v8 ad=0.0999 pd=0.985 as=0.1346 ps=1.15 w=0.64 l=0.15
X5368 a_38738_26999# single_9b_cdac_0.SW[5] VDPWR VDPWR sky130_fd_pr__pfet_01v8 ad=0.435 pd=3.58 as=0.435 ps=3.58 w=1.5 l=0.5
X5369 single_9b_cdac_0.SW[0] a_13623_24340# VGND VGND sky130_fd_pr__nfet_01v8 ad=0.1352 pd=1.56 as=0.0754 ps=0.81 w=0.52 l=0.15
X5370 a_11579_21442# sar9b_0.net15 VDPWR VDPWR sky130_fd_pr__pfet_01v8_hvt ad=0.1092 pd=1.36 as=0.07035 ps=0.755 w=0.42 l=0.15
X5371 VDPWR a_13621_21318# a_13511_21442# VDPWR sky130_fd_pr__pfet_01v8_hvt ad=0.07035 pd=0.755 as=0.1155 ps=0.97 w=0.42 l=0.15
X5372 sar9b_0.clknet_1_0__leaf_CLK a_6701_20506# VDPWR VDPWR sky130_fd_pr__pfet_01v8_hvt ad=0.14 pd=1.28 as=0.14 ps=1.28 w=1 l=0.15
X5373 a_11392_25262# a_10311_24890# a_11045_24858# VDPWR sky130_fd_pr__pfet_01v8_hvt ad=0.0588 pd=0.7 as=0.12915 ps=1.185 w=0.42 l=0.15
X5374 a_9635_24314# sar9b_0.net15 VDPWR VDPWR sky130_fd_pr__pfet_01v8_hvt ad=0.0567 pd=0.69 as=0.0819 ps=0.81 w=0.42 l=0.15
X5375 single_9b_cdac_1.cdac_sw_9b_0.S[2] single_9b_cdac_1.cdac_sw_9b_0.cdac_sw_3_0.tg_sw_3_3.SWN single_9b_cdac_1.cdac_sw_9b_0.S[2] VGND sky130_fd_pr__nfet_01v8 ad=0.145 pd=1.58 as=0 ps=0 w=0.5 l=0.5
X5376 single_9b_cdac_0.cdac_sw_9b_0.cdac_sw_3_7.nooverlap_clk_0.x10.A single_9b_cdac_0.cdac_sw_9b_0.cdac_sw_3_7.nooverlap_clk_0.x8.A VDPWR VDPWR sky130_fd_pr__pfet_01v8 ad=0.168 pd=1.42 as=0.3304 ps=2.83 w=1.12 l=0.15
X5377 VDPWR VGND VDPWR VDPWR sky130_fd_pr__pfet_01v8_hvt ad=0.2262 pd=2.26 as=0 ps=0 w=0.87 l=0.59
X5378 dw_17224_1400# a_21368_4076# sky130_fd_pr__cap_mim_m3_1 l=2 w=2
X5379 th_dif_sw_0.VCP single_9b_cdac_1.cdac_sw_9b_0.S[0] sky130_fd_pr__cap_mim_m3_1 l=2 w=2
X5380 single_9b_cdac_1.cdac_sw_9b_0.cdac_sw_3_8.nooverlap_clk_0.CLK0 single_9b_cdac_1.cdac_sw_9b_0.cdac_sw_3_8.nooverlap_clk_0.CLKB0 VGND VGND sky130_fd_pr__nfet_01v8_lvt ad=0.1036 pd=1.02 as=0.1036 ps=1.02 w=0.74 l=0.15
X5381 VDPWR VGND VDPWR VDPWR sky130_fd_pr__pfet_01v8_hvt ad=0.2262 pd=2.26 as=0 ps=0 w=0.87 l=0.59
X5382 a_31753_29911# single_9b_cdac_0.cdac_sw_9b_0.cdac_sw_3_7.nooverlap_clk_0.x8.A VGND VGND sky130_fd_pr__nfet_01v8_lvt ad=0.0888 pd=0.98 as=0.2109 ps=2.05 w=0.74 l=0.15
X5383 single_9b_cdac_1.cdac_sw_9b_0.cdac_sw_3_7.nooverlap_clk_0.CLKB0 single_9b_cdac_1.cdac_sw_9b_0.cdac_sw_3_7.nooverlap_clk_0.sky130_fd_sc_hs__inv_8_0.A VDPWR VDPWR sky130_fd_pr__pfet_01v8 ad=0.168 pd=1.42 as=0.3304 ps=2.83 w=1.12 l=0.15
X5384 VDPWR single_9b_cdac_1.cdac_sw_9b_0.cdac_sw_3_3.tg_sw_3_3.SWN single_9b_cdac_1.cdac_sw_9b_0.cdac_sw_3_3.tg_sw_3_3.SWP VDPWR sky130_fd_pr__pfet_01v8 ad=0.3864 pd=2.93 as=0.168 ps=1.42 w=1.12 l=0.15
X5385 single_9b_cdac_1.cdac_sw_9b_0.cdac_sw_3_3.tg_sw_3_3.SWP single_9b_cdac_1.cdac_sw_9b_0.cdac_sw_3_3.tg_sw_3_3.SWN VGND VGND sky130_fd_pr__nfet_01v8_lvt ad=0.1036 pd=1.02 as=0.1554 ps=1.16 w=0.74 l=0.15
X5386 a_5973_23252# sar9b_0._02_ VGND VGND sky130_fd_pr__nfet_01v8 ad=0.0813 pd=0.83 as=0.1092 ps=1.36 w=0.42 l=0.15
X5387 th_dif_sw_0.VCN single_9b_cdac_0.cdac_sw_9b_0.S[0] sky130_fd_pr__cap_mim_m3_1 l=2 w=2
X5388 VGND VDPWR VGND VGND sky130_fd_pr__nfet_01v8 ad=0.143 pd=1.62 as=0 ps=0 w=0.55 l=0.59
X5389 ua[0] single_9b_cdac_0.cdac_sw_9b_0.cdac_sw_3_5.tg_sw_3_3.SWP ua[0] VDPWR sky130_fd_pr__pfet_01v8 ad=0.435 pd=3.58 as=0 ps=0 w=1.5 l=0.5
X5390 a_14143_21050# a_13968_21076# a_14322_21076# VGND sky130_fd_pr__nfet_01v8 ad=0.1092 pd=1.36 as=0.06405 ps=0.725 w=0.42 l=0.15
X5391 single_9b_cdac_0.cdac_sw_9b_0.cdac_sw_3_4.tg_sw_3_3.SWP single_9b_cdac_0.cdac_sw_9b_0.cdac_sw_3_4.tg_sw_3_3.SWN VGND VGND sky130_fd_pr__nfet_01v8_lvt ad=0.1036 pd=1.02 as=0.1036 ps=1.02 w=0.74 l=0.15
X5392 a_13053_22164# a_12887_22164# VDPWR VDPWR sky130_fd_pr__pfet_01v8_hvt ad=0.1664 pd=1.8 as=0.0864 ps=0.91 w=0.64 l=0.15
X5393 single_9b_cdac_1.cdac_sw_9b_0.cdac_sw_3_3.tg_sw_3_3.SWP single_9b_cdac_1.cdac_sw_9b_0.cdac_sw_3_3.tg_sw_3_3.SWN VDPWR VDPWR sky130_fd_pr__pfet_01v8 ad=0.168 pd=1.42 as=0.196 ps=1.47 w=1.12 l=0.15
X5394 VDPWR single_9b_cdac_1.cdac_sw_9b_0.cdac_sw_3_3.nooverlap_clk_0.CLKB0 single_9b_cdac_1.cdac_sw_9b_0.cdac_sw_3_3.nooverlap_clk_0.CLK0 VDPWR sky130_fd_pr__pfet_01v8 ad=0.196 pd=1.47 as=0.168 ps=1.42 w=1.12 l=0.15
X5395 single_9b_cdac_1.cdac_sw_9b_0.S[4] single_9b_cdac_1.cdac_sw_9b_0.cdac_sw_3_3.tg_sw_3_3.SWP single_9b_cdac_1.cdac_sw_9b_0.S[4] VDPWR sky130_fd_pr__pfet_01v8 ad=0.435 pd=3.58 as=0 ps=0 w=1.5 l=0.5
X5396 VDPWR single_9b_cdac_0.cdac_sw_9b_0.cdac_sw_3_0.nooverlap_clk_0.CLKB0 single_9b_cdac_0.cdac_sw_9b_0.cdac_sw_3_0.nooverlap_clk_0.CLK0 VDPWR sky130_fd_pr__pfet_01v8 ad=0.3304 pd=2.83 as=0.168 ps=1.42 w=1.12 l=0.15
X5397 VGND VDPWR VGND VGND sky130_fd_pr__nfet_01v8 ad=0.143 pd=1.62 as=0 ps=0 w=0.55 l=0.59
X5398 a_11195_25428# a_10679_25428# a_11100_25428# VGND sky130_fd_pr__special_nfet_01v8 ad=0.0594 pd=0.69 as=0.066 ps=0.745 w=0.36 l=0.15
X5399 VDPWR a_9727_23226# a_9714_23618# VDPWR sky130_fd_pr__pfet_01v8_hvt ad=0.0819 pd=0.81 as=0.0567 ps=0.69 w=0.42 l=0.15
X5400 VDPWR VGND VDPWR VDPWR sky130_fd_pr__pfet_01v8_hvt ad=0.2262 pd=2.26 as=0 ps=0 w=0.87 l=0.59
X5401 ua[0] single_9b_cdac_1.cdac_sw_9b_0.cdac_sw_3_5.tg_sw_3_3.SWN ua[0] VGND sky130_fd_pr__nfet_01v8 ad=0.145 pd=1.58 as=0 ps=0 w=0.5 l=0.5
X5402 VDPWR VGND VDPWR VDPWR sky130_fd_pr__pfet_01v8_hvt ad=0.2262 pd=2.26 as=0 ps=0 w=0.87 l=0.59
X5403 a_10196_26516# a_9115_26516# a_9849_26758# VDPWR sky130_fd_pr__pfet_01v8_hvt ad=0.0588 pd=0.7 as=0.12915 ps=1.185 w=0.42 l=0.15
X5404 a_11287_22164# a_10771_22164# a_11192_22164# VGND sky130_fd_pr__special_nfet_01v8 ad=0.0594 pd=0.69 as=0.066 ps=0.745 w=0.36 l=0.15
X5405 single_9b_cdac_1.cdac_sw_9b_0.S[1] single_9b_cdac_1.cdac_sw_9b_0.cdac_sw_3_1.tg_sw_3_3.SWP ua[0] VGND sky130_fd_pr__nfet_01v8 ad=0.145 pd=1.58 as=0.145 ps=1.58 w=0.5 l=0.5
X5406 single_9b_cdac_0.cdac_sw_9b_0.cdac_sw_3_2.nooverlap_clk_0.sky130_fd_sc_hs__inv_8_0.A single_9b_cdac_0.cdac_sw_9b_0.cdac_sw_3_2.nooverlap_clk_0.x1.A VGND VGND sky130_fd_pr__nfet_01v8_lvt ad=0.1184 pd=1.06 as=0.1221 ps=1.07 w=0.74 l=0.15
X5407 a_13407_24174# a_12961_23802# a_13311_24174# VGND sky130_fd_pr__special_nfet_01v8 ad=0.1401 pd=1.1 as=0.0594 ps=0.69 w=0.36 l=0.15
X5408 sar9b_0.net15 a_6930_20241# VGND VGND sky130_fd_pr__nfet_01v8 ad=0.08775 pd=0.92 as=0.09262 ps=0.935 w=0.65 l=0.15
X5409 single_9b_cdac_1.cdac_sw_9b_0.cdac_sw_3_3.nooverlap_clk_0.CLK0 single_9b_cdac_1.cdac_sw_9b_0.cdac_sw_3_3.nooverlap_clk_0.CLKB0 VDPWR VDPWR sky130_fd_pr__pfet_01v8 ad=0.168 pd=1.42 as=0.3304 ps=2.83 w=1.12 l=0.15
X5410 a_53154_16877# single_9b_cdac_1.SW[2] VDPWR VDPWR sky130_fd_pr__pfet_01v8 ad=0.435 pd=3.58 as=0.435 ps=3.58 w=1.5 l=0.5
X5411 ua[0] single_9b_cdac_0.cdac_sw_9b_0.cdac_sw_3_5.tg_sw_3_3.SWN ua[0] VGND sky130_fd_pr__nfet_01v8 ad=0.145 pd=1.58 as=0 ps=0 w=0.5 l=0.5
X5412 single_9b_cdac_0.cdac_sw_9b_0.S[3] single_9b_cdac_0.cdac_sw_9b_0.cdac_sw_3_4.tg_sw_3_3.SWP single_9b_cdac_0.cdac_sw_9b_0.S[3] VDPWR sky130_fd_pr__pfet_01v8 ad=0.435 pd=3.58 as=0 ps=0 w=1.5 l=0.5
X5413 single_9b_cdac_0.cdac_sw_9b_0.cdac_sw_3_0.nooverlap_clk_0.CLK0 single_9b_cdac_0.cdac_sw_9b_0.cdac_sw_3_0.nooverlap_clk_0.CLKB0 VDPWR VDPWR sky130_fd_pr__pfet_01v8 ad=0.168 pd=1.42 as=0.196 ps=1.47 w=1.12 l=0.15
X5414 a_8358_23796# a_7919_23802# a_8273_23796# VGND sky130_fd_pr__special_nfet_01v8 ad=0.0621 pd=0.705 as=0.0813 ps=0.83 w=0.36 l=0.15
X5415 VDPWR sar9b_0.net13 a_12887_26516# VDPWR sky130_fd_pr__pfet_01v8_hvt ad=0.0864 pd=0.91 as=0.1664 ps=1.8 w=0.64 l=0.15
X5416 single_9b_cdac_0.cdac_sw_9b_0.cdac_sw_3_8.tg_sw_3_3.SWP single_9b_cdac_0.cdac_sw_9b_0.cdac_sw_3_8.tg_sw_3_3.SWN VGND VGND sky130_fd_pr__nfet_01v8_lvt ad=0.1036 pd=1.02 as=0.1295 ps=1.09 w=0.74 l=0.15
X5417 a_13053_22714# a_12887_22714# VGND VGND sky130_fd_pr__nfet_01v8 ad=0.1092 pd=1.36 as=0.0567 ps=0.69 w=0.42 l=0.15
X5418 a_13511_22530# a_12887_22164# a_13403_22164# VDPWR sky130_fd_pr__pfet_01v8_hvt ad=0.1155 pd=0.97 as=0.07245 ps=0.765 w=0.42 l=0.15
X5419 single_9b_cdac_1.cdac_sw_9b_0.S[6] single_9b_cdac_1.cdac_sw_9b_0.cdac_sw_3_6.tg_sw_3_3.SWP ua[0] VGND sky130_fd_pr__nfet_01v8 ad=0.145 pd=1.58 as=0.145 ps=1.58 w=0.5 l=0.5
X5420 VGND single_9b_cdac_0.cdac_sw_9b_0.cdac_sw_3_1.nooverlap_clk_0.CLKB0 single_9b_cdac_0.cdac_sw_9b_0.cdac_sw_3_1.nooverlap_clk_0.CLK0 VGND sky130_fd_pr__nfet_01v8_lvt ad=0.1554 pd=1.16 as=0.1036 ps=1.02 w=0.74 l=0.15
X5421 th_dif_sw_0.VCN single_9b_cdac_0.cdac_sw_9b_0.S[1] sky130_fd_pr__cap_mim_m3_1 l=2 w=2
X5422 sar9b_0.net34 a_14143_26490# VDPWR VDPWR sky130_fd_pr__pfet_01v8_hvt ad=0.26 pd=2.52 as=0.3012 ps=2.66 w=1 l=0.15
X5423 VDPWR a_9665_22406# a_9555_22530# VDPWR sky130_fd_pr__pfet_01v8_hvt ad=0.07035 pd=0.755 as=0.1155 ps=0.97 w=0.42 l=0.15
X5424 VGND a_6701_20506# sar9b_0.clknet_1_0__leaf_CLK VGND sky130_fd_pr__nfet_01v8 ad=0.0588 pd=0.7 as=0.0588 ps=0.7 w=0.42 l=0.15
X5425 a_13621_19142# a_13403_18900# VDPWR VDPWR sky130_fd_pr__pfet_01v8_hvt ad=0.12915 pd=1.185 as=0.2184 ps=2.2 w=0.84 l=0.15
X5426 VGND a_7059_25402# a_6993_25428# VGND sky130_fd_pr__nfet_01v8 ad=0.12495 pd=1.015 as=0.0669 ps=0.75 w=0.42 l=0.15
X5427 VGND single_9b_cdac_0.cdac_sw_9b_0.cdac_sw_3_1.nooverlap_clk_0.x3.Y a_59529_29917# VGND sky130_fd_pr__nfet_01v8_lvt ad=0.2109 pd=2.05 as=0.0888 ps=0.98 w=0.74 l=0.15
X5428 VGND sar9b_0.net3 a_6581_25428# VGND sky130_fd_pr__nfet_01v8 ad=0.1346 pd=1.15 as=0.0441 ps=0.63 w=0.42 l=0.15
X5429 th_dif_sw_0.VCP single_9b_cdac_1.cdac_sw_9b_0.S[1] sky130_fd_pr__cap_mim_m3_1 l=2 w=2
X5430 single_9b_cdac_0.cdac_sw_9b_0.cdac_sw_3_6.tg_sw_3_3.SWN single_9b_cdac_0.cdac_sw_9b_0.cdac_sw_3_6.nooverlap_clk_0.x10.A VGND VGND sky130_fd_pr__nfet_01v8_lvt ad=0.1036 pd=1.02 as=0.2146 ps=2.06 w=0.74 l=0.15
X5431 single_9b_cdac_0.cdac_sw_9b_0.S[5] single_9b_cdac_0.cdac_sw_9b_0.cdac_sw_3_5.tg_sw_3_3.SWN single_9b_cdac_0.cdac_sw_9b_0.S[5] VGND sky130_fd_pr__nfet_01v8 ad=0.145 pd=1.58 as=0 ps=0 w=0.5 l=0.5
X5432 VGND single_9b_cdac_0.cdac_sw_9b_0.cdac_sw_3_0.nooverlap_clk_0.x10.A single_9b_cdac_0.cdac_sw_9b_0.cdac_sw_3_0.tg_sw_3_3.SWN VGND sky130_fd_pr__nfet_01v8_lvt ad=0.1554 pd=1.16 as=0.1036 ps=1.02 w=0.74 l=0.15
X5433 th_dif_sw_0.VCN single_9b_cdac_0.cdac_sw_9b_0.S[0] sky130_fd_pr__cap_mim_m3_1 l=2 w=2
X5434 sar9b_0.clknet_1_1__leaf_CLK a_6149_23770# VDPWR VDPWR sky130_fd_pr__pfet_01v8_hvt ad=0.14 pd=1.28 as=0.14 ps=1.28 w=1 l=0.15
X5435 a_5785_23252# a_5619_23252# VDPWR VDPWR sky130_fd_pr__pfet_01v8_hvt ad=0.1664 pd=1.8 as=0.0864 ps=0.91 w=0.64 l=0.15
X5436 a_9670_22708# a_8912_22824# a_9107_22682# VDPWR sky130_fd_pr__pfet_01v8_hvt ad=0.0651 pd=0.73 as=0.07245 ps=0.765 w=0.42 l=0.15
X5437 th_dif_sw_0.VCP single_9b_cdac_1.cdac_sw_9b_0.S[1] sky130_fd_pr__cap_mim_m3_1 l=2 w=2
X5438 single_9b_cdac_1.cdac_sw_9b_0.S[6] single_9b_cdac_1.cdac_sw_9b_0.cdac_sw_3_6.tg_sw_3_3.SWN ua[0] VDPWR sky130_fd_pr__pfet_01v8 ad=0.435 pd=3.58 as=0.435 ps=3.58 w=1.5 l=0.5
X5439 th_dif_sw_0.VCP single_9b_cdac_1.cdac_sw_9b_0.S[2] sky130_fd_pr__cap_mim_m3_1 l=2 w=2
X5440 VGND single_9b_cdac_1.cdac_sw_9b_0.cdac_sw_3_1.nooverlap_clk_0.x1.A single_9b_cdac_1.cdac_sw_9b_0.cdac_sw_3_1.nooverlap_clk_0.sky130_fd_sc_hs__inv_8_0.A VGND sky130_fd_pr__nfet_01v8_lvt ad=0.1221 pd=1.07 as=0.1184 ps=1.06 w=0.74 l=0.15
X5441 single_9b_cdac_0.cdac_sw_9b_0.cdac_sw_3_8.nooverlap_clk_0.CLK0 single_9b_cdac_0.cdac_sw_9b_0.cdac_sw_3_8.nooverlap_clk_0.CLKB0 VDPWR VDPWR sky130_fd_pr__pfet_01v8 ad=0.168 pd=1.42 as=0.196 ps=1.47 w=1.12 l=0.15
X5442 VDPWR a_6930_20241# sar9b_0.net15 VDPWR sky130_fd_pr__pfet_01v8_hvt ad=0.1425 pd=1.285 as=0.135 ps=1.27 w=1 l=0.15
X5443 VGND single_9b_cdac_1.cdac_sw_9b_0.cdac_sw_3_6.nooverlap_clk_0.CLKB0 single_9b_cdac_1.cdac_sw_9b_0.cdac_sw_3_6.nooverlap_clk_0.CLK0 VGND sky130_fd_pr__nfet_01v8_lvt ad=0.1295 pd=1.09 as=0.1036 ps=1.02 w=0.74 l=0.15
X5444 a_10477_23252# a_10311_23252# VDPWR VDPWR sky130_fd_pr__pfet_01v8_hvt ad=0.1664 pd=1.8 as=0.0864 ps=0.91 w=0.64 l=0.15
X5445 a_13249_18734# a_12059_18362# a_13140_18734# VGND sky130_fd_pr__special_nfet_01v8 ad=0.0669 pd=0.75 as=0.0711 ps=0.755 w=0.36 l=0.15
X5446 dw_17224_1400# a_21368_4076# sky130_fd_pr__cap_mim_m3_1 l=2 w=2
X5447 th_dif_sw_0.VCP single_9b_cdac_1.cdac_sw_9b_0.S[0] sky130_fd_pr__cap_mim_m3_1 l=2 w=2
X5448 th_dif_sw_0.VCN single_9b_cdac_0.cdac_sw_9b_0.S[1] sky130_fd_pr__cap_mim_m3_1 l=2 w=2
X5449 VGND th_dif_sw_0.CKB a_21177_7457# VGND sky130_fd_pr__nfet_01v8_lvt ad=0.2109 pd=2.05 as=0.1295 ps=1.09 w=0.74 l=0.15
X5450 a_10196_26516# a_9281_26516# a_9849_26758# VGND sky130_fd_pr__special_nfet_01v8 ad=0.0711 pd=0.755 as=0.0999 ps=0.985 w=0.36 l=0.15
X5451 single_9b_cdac_1.cdac_sw_9b_0.cdac_sw_3_0.nooverlap_clk_0.x10.A single_9b_cdac_1.cdac_sw_9b_0.cdac_sw_3_0.nooverlap_clk_0.x8.A VGND VGND sky130_fd_pr__nfet_01v8_lvt ad=0.1184 pd=1.06 as=0.2331 ps=2.11 w=0.74 l=0.15
X5452 dw_12589_1395# a_10166_3438# sky130_fd_pr__cap_mim_m3_1 l=2 w=2
X5453 th_dif_sw_0.VCN single_9b_cdac_0.cdac_sw_9b_0.S[5] sky130_fd_pr__cap_mim_m3_1 l=2 w=2
X5454 a_14897_9355# clk a_14871_9671# VGND sky130_fd_pr__nfet_01v8 ad=0.145 pd=1.29 as=0.29 ps=2.58 w=1 l=1
X5455 single_9b_cdac_0.cdac_sw_9b_0.cdac_sw_3_5.nooverlap_clk_0.CLK0 single_9b_cdac_0.cdac_sw_9b_0.cdac_sw_3_5.nooverlap_clk_0.CLKB0 VGND VGND sky130_fd_pr__nfet_01v8_lvt ad=0.1036 pd=1.02 as=0.2146 ps=2.06 w=0.74 l=0.15
X5456 VGND sar9b_0.net42 a_14451_20532# VGND sky130_fd_pr__nfet_01v8 ad=0.0754 pd=0.81 as=0.1352 ps=1.56 w=0.52 l=0.15
X5457 VGND single_9b_cdac_1.cdac_sw_9b_0.cdac_sw_3_0.nooverlap_clk_0.x10.A single_9b_cdac_1.cdac_sw_9b_0.cdac_sw_3_0.tg_sw_3_3.SWN VGND sky130_fd_pr__nfet_01v8_lvt ad=0.1295 pd=1.09 as=0.1036 ps=1.02 w=0.74 l=0.15
X5458 single_9b_cdac_1.cdac_sw_9b_0.S[1] single_9b_cdac_1.cdac_sw_9b_0.cdac_sw_3_1.nooverlap_clk_0.CLKB0 a_57946_16877# VDPWR sky130_fd_pr__pfet_01v8 ad=0.435 pd=3.58 as=0.435 ps=3.58 w=1.5 l=0.5
X5459 single_9b_cdac_0.cdac_sw_9b_0.S[4] single_9b_cdac_0.cdac_sw_9b_0.cdac_sw_3_3.tg_sw_3_3.SWP ua[0] VGND sky130_fd_pr__nfet_01v8 ad=0.145 pd=1.58 as=0.145 ps=1.58 w=0.5 l=0.5
X5460 th_dif_sw_0.VCN single_9b_cdac_0.cdac_sw_9b_0.S[0] sky130_fd_pr__cap_mim_m3_1 l=2 w=2
X5461 single_9b_cdac_0.cdac_sw_9b_0.S[2] single_9b_cdac_0.cdac_sw_9b_0.cdac_sw_3_0.tg_sw_3_3.SWN ua[0] VDPWR sky130_fd_pr__pfet_01v8 ad=0.435 pd=3.58 as=0.435 ps=3.58 w=1.5 l=0.5
X5462 sar9b_0.net33 a_14143_25402# VGND VGND sky130_fd_pr__nfet_01v8 ad=0.169 pd=1.82 as=0.2087 ps=2.02 w=0.65 l=0.15
X5463 VGND a_8783_23796# a_8951_23770# VGND sky130_fd_pr__nfet_01v8 ad=0.08775 pd=0.92 as=0.169 ps=1.82 w=0.65 l=0.15
X5464 th_dif_sw_0.VCN single_9b_cdac_0.cdac_sw_9b_0.S[1] sky130_fd_pr__cap_mim_m3_1 l=2 w=2
X5465 sar9b_0.net9 a_10371_21050# VDPWR VDPWR sky130_fd_pr__pfet_01v8_hvt ad=0.26 pd=2.52 as=0.3012 ps=2.66 w=1 l=0.15
X5466 single_9b_cdac_1.cdac_sw_9b_0.cdac_sw_3_1.nooverlap_clk_0.CLKB0 single_9b_cdac_1.cdac_sw_9b_0.cdac_sw_3_1.nooverlap_clk_0.sky130_fd_sc_hs__inv_8_0.A VGND VGND sky130_fd_pr__nfet_01v8_lvt ad=0.1036 pd=1.02 as=0.1036 ps=1.02 w=0.74 l=0.15
X5467 VDPWR VGND VDPWR VDPWR sky130_fd_pr__pfet_01v8_hvt ad=0.2262 pd=2.26 as=0 ps=0 w=0.87 l=0.59
X5468 VGND single_9b_cdac_1.cdac_sw_9b_0.cdac_sw_3_5.nooverlap_clk_0.x10.A single_9b_cdac_1.cdac_sw_9b_0.cdac_sw_3_5.tg_sw_3_3.SWN VGND sky130_fd_pr__nfet_01v8_lvt ad=0.2146 pd=2.06 as=0.1036 ps=1.02 w=0.74 l=0.15
X5469 VDPWR a_10196_26516# a_10371_26490# VDPWR sky130_fd_pr__pfet_01v8_hvt ad=0.1134 pd=1.38 as=0.0567 ps=0.69 w=0.42 l=0.15
X5470 single_9b_cdac_0.cdac_sw_9b_0.S[8] single_9b_cdac_0.cdac_sw_9b_0.cdac_sw_3_8.tg_sw_3_3.SWN single_9b_cdac_0.cdac_sw_9b_0.S[8] VGND sky130_fd_pr__nfet_01v8 ad=0.145 pd=1.58 as=0 ps=0 w=0.5 l=0.5
X5471 a_8895_26350# a_8545_25978# a_8800_26338# VDPWR sky130_fd_pr__pfet_01v8_hvt ad=0.07245 pd=0.765 as=0.0651 ps=0.73 w=0.42 l=0.15
X5472 ua[0] single_9b_cdac_0.cdac_sw_9b_0.cdac_sw_3_7.tg_sw_3_3.SWP ua[0] VDPWR sky130_fd_pr__pfet_01v8 ad=0.435 pd=3.58 as=0 ps=0 w=1.5 l=0.5
X5473 ua[0] single_9b_cdac_0.cdac_sw_9b_0.cdac_sw_3_3.tg_sw_3_3.SWP ua[0] VDPWR sky130_fd_pr__pfet_01v8 ad=0.435 pd=3.58 as=0 ps=0 w=1.5 l=0.5
X5474 th_dif_sw_0.VCP single_9b_cdac_1.cdac_sw_9b_0.S[0] sky130_fd_pr__cap_mim_m3_1 l=2 w=2
X5475 th_dif_sw_0.VCN single_9b_cdac_0.cdac_sw_9b_0.S[4] sky130_fd_pr__cap_mim_m3_1 l=2 w=2
X5476 VGND single_9b_cdac_1.cdac_sw_9b_0.cdac_sw_3_4.nooverlap_clk_0.x1.A single_9b_cdac_1.cdac_sw_9b_0.cdac_sw_3_4.nooverlap_clk_0.sky130_fd_sc_hs__inv_8_0.A VGND sky130_fd_pr__nfet_01v8_lvt ad=0.2109 pd=2.05 as=0.1036 ps=1.02 w=0.74 l=0.15
X5477 ua[0] single_9b_cdac_1.cdac_sw_9b_0.cdac_sw_3_3.tg_sw_3_3.SWN ua[0] VGND sky130_fd_pr__nfet_01v8 ad=0.145 pd=1.58 as=0 ps=0 w=0.5 l=0.5
X5478 th_dif_sw_0.VCP single_9b_cdac_1.cdac_sw_9b_0.S[0] sky130_fd_pr__cap_mim_m3_1 l=2 w=2
X5479 VDPWR single_9b_cdac_1.cdac_sw_9b_0.cdac_sw_3_1.tg_sw_3_3.SWN single_9b_cdac_1.cdac_sw_9b_0.cdac_sw_3_1.tg_sw_3_3.SWP VDPWR sky130_fd_pr__pfet_01v8 ad=0.196 pd=1.47 as=0.168 ps=1.42 w=1.12 l=0.15
X5480 single_9b_cdac_0.cdac_sw_9b_0.S[2] single_9b_cdac_0.cdac_sw_9b_0.cdac_sw_3_0.nooverlap_clk_0.CLKB0 a_53154_26999# VDPWR sky130_fd_pr__pfet_01v8 ad=0.435 pd=3.58 as=0.435 ps=3.58 w=1.5 l=0.5
X5481 th_dif_sw_0.VCN single_9b_cdac_0.cdac_sw_9b_0.S[1] sky130_fd_pr__cap_mim_m3_1 l=2 w=2
X5482 VDPWR a_11045_24858# a_10935_24884# VDPWR sky130_fd_pr__pfet_01v8_hvt ad=0.07035 pd=0.755 as=0.1155 ps=0.97 w=0.42 l=0.15
X5483 th_dif_sw_0.VCP single_9b_cdac_1.cdac_sw_9b_0.S[3] sky130_fd_pr__cap_mim_m3_1 l=2 w=2
X5484 a_9175_27364# a_9000_27438# a_9354_27426# VGND sky130_fd_pr__nfet_01v8 ad=0.1092 pd=1.36 as=0.06405 ps=0.725 w=0.42 l=0.15
X5485 ua[0] single_9b_cdac_0.cdac_sw_9b_0.cdac_sw_3_3.tg_sw_3_3.SWN ua[0] VGND sky130_fd_pr__nfet_01v8 ad=0.145 pd=1.58 as=0 ps=0 w=0.5 l=0.5
X5486 th_dif_sw_0.VCN single_9b_cdac_0.cdac_sw_9b_0.S[0] sky130_fd_pr__cap_mim_m3_1 l=2 w=2
X5487 VGND single_9b_cdac_1.cdac_sw_9b_0.cdac_sw_3_2.nooverlap_clk_0.CLKB0 single_9b_cdac_1.cdac_sw_9b_0.cdac_sw_3_2.nooverlap_clk_0.CLK0 VGND sky130_fd_pr__nfet_01v8_lvt ad=0.1554 pd=1.16 as=0.1036 ps=1.02 w=0.74 l=0.15
X5488 a_7325_26681# sar9b_0.net18 VDPWR VDPWR sky130_fd_pr__pfet_01v8_hvt ad=0.2054 pd=2.1 as=0.11455 ps=1.08 w=0.79 l=0.15
X5489 VGND single_9b_cdac_1.cdac_sw_9b_0.cdac_sw_3_4.nooverlap_clk_0.sky130_fd_sc_hs__inv_8_0.A single_9b_cdac_1.cdac_sw_9b_0.cdac_sw_3_4.nooverlap_clk_0.CLKB0 VGND sky130_fd_pr__nfet_01v8_lvt ad=0.1554 pd=1.16 as=0.1036 ps=1.02 w=0.74 l=0.15
X5490 single_9b_cdac_1.cdac_sw_9b_0.cdac_sw_3_1.tg_sw_3_3.SWP single_9b_cdac_1.cdac_sw_9b_0.cdac_sw_3_1.tg_sw_3_3.SWN VDPWR VDPWR sky130_fd_pr__pfet_01v8 ad=0.168 pd=1.42 as=0.168 ps=1.42 w=1.12 l=0.15
X5491 VGND VDPWR VGND VGND sky130_fd_pr__nfet_01v8 ad=0.143 pd=1.62 as=0 ps=0 w=0.55 l=0.59
X5492 a_7059_21228# sar9b_0.net3 a_7233_21104# VGND sky130_fd_pr__nfet_01v8 ad=0.1176 pd=1.4 as=0.0567 ps=0.69 w=0.42 l=0.15
X5493 VGND VDPWR VGND VGND sky130_fd_pr__nfet_01v8 ad=0.143 pd=1.62 as=0 ps=0 w=0.55 l=0.59
X5494 single_9b_cdac_1.cdac_sw_9b_0.cdac_sw_3_0.nooverlap_clk_0.x3.Y single_9b_cdac_1.CF[2] VDPWR VDPWR sky130_fd_pr__pfet_01v8 ad=0.3304 pd=2.83 as=0.3864 ps=2.93 w=1.12 l=0.15
X5495 VDPWR a_11689_23770# a_11579_23796# VDPWR sky130_fd_pr__pfet_01v8_hvt ad=0.07035 pd=0.755 as=0.1155 ps=0.97 w=0.42 l=0.15
X5496 a_16555_12412# tdc_0.phase_detector_0.pd_out_0.A VGND VGND sky130_fd_pr__nfet_01v8_lvt ad=0.0888 pd=0.98 as=0.2109 ps=2.05 w=0.74 l=0.15
X5497 VGND single_9b_cdac_1.SW[1] a_58824_17740# VGND sky130_fd_pr__nfet_01v8 ad=0.145 pd=1.58 as=0.145 ps=1.58 w=0.5 l=0.5
X5498 VDPWR single_9b_cdac_1.cdac_sw_9b_0.cdac_sw_3_1.tg_sw_3_3.SWN single_9b_cdac_1.cdac_sw_9b_0.cdac_sw_3_1.tg_sw_3_3.SWP VDPWR sky130_fd_pr__pfet_01v8 ad=0.168 pd=1.42 as=0.168 ps=1.42 w=1.12 l=0.15
X5499 a_49221_26990# single_9b_cdac_0.cdac_sw_9b_0.cdac_sw_3_4.nooverlap_clk_0.CLK0 single_9b_cdac_0.cdac_sw_9b_0.S[3] VGND sky130_fd_pr__nfet_01v8 ad=0.145 pd=1.58 as=0.145 ps=1.58 w=0.5 l=0.5
X5500 VDPWR single_9b_cdac_0.cdac_sw_9b_0.cdac_sw_3_4.tg_sw_3_3.SWN single_9b_cdac_0.cdac_sw_9b_0.cdac_sw_3_4.tg_sw_3_3.SWP VDPWR sky130_fd_pr__pfet_01v8 ad=0.196 pd=1.47 as=0.168 ps=1.42 w=1.12 l=0.15
X5501 VDPWR single_9b_cdac_1.cdac_sw_9b_0.cdac_sw_3_0.nooverlap_clk_0.x10.A single_9b_cdac_1.cdac_sw_9b_0.cdac_sw_3_0.tg_sw_3_3.SWN VDPWR sky130_fd_pr__pfet_01v8 ad=0.3864 pd=2.93 as=0.168 ps=1.42 w=1.12 l=0.15
X5502 single_9b_cdac_0.cdac_sw_9b_0.cdac_sw_3_8.tg_sw_3_3.SWN single_9b_cdac_0.cdac_sw_9b_0.cdac_sw_3_8.nooverlap_clk_0.x10.A VGND VGND sky130_fd_pr__nfet_01v8_lvt ad=0.1036 pd=1.02 as=0.1554 ps=1.16 w=0.74 l=0.15
X5503 single_9b_cdac_0.cdac_sw_9b_0.S[4] single_9b_cdac_0.cdac_sw_9b_0.cdac_sw_3_3.tg_sw_3_3.SWN single_9b_cdac_0.cdac_sw_9b_0.S[4] VGND sky130_fd_pr__nfet_01v8 ad=0.145 pd=1.58 as=0 ps=0 w=0.5 l=0.5
X5504 VGND single_9b_cdac_1.SW[6] a_34814_17740# VGND sky130_fd_pr__nfet_01v8 ad=0.145 pd=1.58 as=0.145 ps=1.58 w=0.5 l=0.5
X5505 th_dif_sw_0.VCP single_9b_cdac_1.cdac_sw_9b_0.S[0] sky130_fd_pr__cap_mim_m3_1 l=2 w=2
X5506 th_dif_sw_0.VCN single_9b_cdac_0.cdac_sw_9b_0.S[0] sky130_fd_pr__cap_mim_m3_1 l=2 w=2
X5507 a_8273_23796# sar9b_0._03_ VDPWR VDPWR sky130_fd_pr__pfet_01v8_hvt ad=0.05775 pd=0.695 as=0.1092 ps=1.36 w=0.42 l=0.15
X5508 th_dif_sw_0.VCP single_9b_cdac_1.cdac_sw_9b_0.S[0] sky130_fd_pr__cap_mim_m3_1 l=2 w=2
X5509 single_9b_cdac_1.cdac_sw_9b_0.cdac_sw_3_1.tg_sw_3_3.SWP single_9b_cdac_1.cdac_sw_9b_0.cdac_sw_3_1.tg_sw_3_3.SWN VDPWR VDPWR sky130_fd_pr__pfet_01v8 ad=0.168 pd=1.42 as=0.196 ps=1.47 w=1.12 l=0.15
X5510 sar9b_0.net21 a_9175_27364# VDPWR VDPWR sky130_fd_pr__pfet_01v8_hvt ad=0.26 pd=2.52 as=0.3012 ps=2.66 w=1 l=0.15
X5511 single_9b_cdac_0.cdac_sw_9b_0.cdac_sw_3_4.tg_sw_3_3.SWP single_9b_cdac_0.cdac_sw_9b_0.cdac_sw_3_4.tg_sw_3_3.SWN VDPWR VDPWR sky130_fd_pr__pfet_01v8 ad=0.168 pd=1.42 as=0.168 ps=1.42 w=1.12 l=0.15
X5512 single_9b_cdac_1.cdac_sw_9b_0.cdac_sw_3_0.tg_sw_3_3.SWN single_9b_cdac_1.cdac_sw_9b_0.cdac_sw_3_0.nooverlap_clk_0.x10.A VDPWR VDPWR sky130_fd_pr__pfet_01v8 ad=0.168 pd=1.42 as=0.196 ps=1.47 w=1.12 l=0.15
X5513 a_38738_26999# single_9b_cdac_0.SW[5] VDPWR VDPWR sky130_fd_pr__pfet_01v8 ad=0.435 pd=3.58 as=0.435 ps=3.58 w=1.5 l=0.5
X5514 VGND a_8526_23770# a_8484_24174# VGND sky130_fd_pr__nfet_01v8 ad=0.12095 pd=1.085 as=0.0696 ps=0.765 w=0.42 l=0.15
X5515 a_14322_19810# sar9b_0.net15 VGND VGND sky130_fd_pr__nfet_01v8 ad=0.06405 pd=0.725 as=0.12495 ps=1.015 w=0.42 l=0.15
X5516 single_9b_cdac_1.cdac_sw_9b_0.S[2] single_9b_cdac_1.cdac_sw_9b_0.cdac_sw_3_0.tg_sw_3_3.SWP single_9b_cdac_1.cdac_sw_9b_0.S[2] VDPWR sky130_fd_pr__pfet_01v8 ad=0.435 pd=3.58 as=0 ps=0 w=1.5 l=0.5
X5517 VDPWR single_9b_cdac_1.cdac_sw_9b_0.cdac_sw_3_1.nooverlap_clk_0.CLKB0 single_9b_cdac_1.cdac_sw_9b_0.cdac_sw_3_1.nooverlap_clk_0.CLK0 VDPWR sky130_fd_pr__pfet_01v8 ad=0.196 pd=1.47 as=0.168 ps=1.42 w=1.12 l=0.15
X5518 a_9000_27438# a_8085_27066# a_8653_27034# VGND sky130_fd_pr__special_nfet_01v8 ad=0.0711 pd=0.755 as=0.0999 ps=0.985 w=0.36 l=0.15
X5519 uo_out[0] a_14175_27060# VDPWR VDPWR sky130_fd_pr__pfet_01v8_hvt ad=0.2054 pd=2.1 as=0.11455 ps=1.08 w=0.79 l=0.15
X5520 VDPWR single_9b_cdac_0.cdac_sw_9b_0.cdac_sw_3_4.tg_sw_3_3.SWN single_9b_cdac_0.cdac_sw_9b_0.cdac_sw_3_4.tg_sw_3_3.SWP VDPWR sky130_fd_pr__pfet_01v8 ad=0.168 pd=1.42 as=0.168 ps=1.42 w=1.12 l=0.15
X5521 th_dif_sw_0.VCN single_9b_cdac_0.cdac_sw_9b_0.S[3] sky130_fd_pr__cap_mim_m3_1 l=2 w=2
X5522 single_9b_cdac_1.cdac_sw_9b_0.cdac_sw_3_1.nooverlap_clk_0.CLK0 single_9b_cdac_1.cdac_sw_9b_0.cdac_sw_3_1.nooverlap_clk_0.CLKB0 VDPWR VDPWR sky130_fd_pr__pfet_01v8 ad=0.168 pd=1.42 as=0.3304 ps=2.83 w=1.12 l=0.15
X5523 single_9b_cdac_0.cdac_sw_9b_0.cdac_sw_3_5.tg_sw_3_3.SWP single_9b_cdac_0.cdac_sw_9b_0.cdac_sw_3_5.tg_sw_3_3.SWN VGND VGND sky130_fd_pr__nfet_01v8_lvt ad=0.1036 pd=1.02 as=0.1295 ps=1.09 w=0.74 l=0.15
X5524 VGND single_9b_cdac_0.cdac_sw_9b_0.cdac_sw_3_2.tg_sw_3_3.SWN single_9b_cdac_0.cdac_sw_9b_0.cdac_sw_3_2.tg_sw_3_3.SWP VGND sky130_fd_pr__nfet_01v8_lvt ad=0.1554 pd=1.16 as=0.1036 ps=1.02 w=0.74 l=0.15
X5525 VGND VDPWR VGND VGND sky130_fd_pr__nfet_01v8 ad=0.143 pd=1.62 as=0 ps=0 w=0.55 l=0.59
X5526 VDPWR VGND VDPWR VDPWR sky130_fd_pr__pfet_01v8_hvt ad=0.2262 pd=2.26 as=0 ps=0 w=0.87 l=0.59
X5527 single_9b_cdac_1.cdac_sw_9b_0.cdac_sw_3_4.nooverlap_clk_0.sky130_fd_sc_hs__inv_1_1.A single_9b_cdac_1.cdac_sw_9b_0.cdac_sw_3_4.nooverlap_clk_0.sky130_fd_sc_hs__nand2_1_0.Y VDPWR VDPWR sky130_fd_pr__pfet_01v8 ad=0.3304 pd=2.83 as=0.3864 ps=2.93 w=1.12 l=0.15
X5528 ua[0] single_9b_cdac_0.cdac_sw_9b_0.cdac_sw_3_7.tg_sw_3_3.SWP ua[0] VDPWR sky130_fd_pr__pfet_01v8 ad=0.435 pd=3.58 as=0 ps=0 w=1.5 l=0.5
X5529 a_13511_22708# a_12887_22714# a_13403_23086# VDPWR sky130_fd_pr__pfet_01v8_hvt ad=0.1155 pd=0.97 as=0.07245 ps=0.765 w=0.42 l=0.15
X5530 single_9b_cdac_1.cdac_sw_9b_0.S[5] single_9b_cdac_1.cdac_sw_9b_0.cdac_sw_3_5.nooverlap_clk_0.CLKB0 a_38738_16877# VDPWR sky130_fd_pr__pfet_01v8 ad=0.435 pd=3.58 as=0.435 ps=3.58 w=1.5 l=0.5
X5531 th_dif_sw_0.VCP single_9b_cdac_1.cdac_sw_9b_0.S[0] sky130_fd_pr__cap_mim_m3_1 l=2 w=2
X5532 sar9b_0._03_ sar9b_0._11_ a_6631_24590# VDPWR sky130_fd_pr__pfet_01v8_hvt ad=0.265 pd=2.53 as=0.14 ps=1.28 w=1 l=0.15
X5533 VDPWR single_9b_cdac_1.CF[3] single_9b_cdac_0.cdac_sw_9b_0.cdac_sw_3_4.nooverlap_clk_0.x3.Y VDPWR sky130_fd_pr__pfet_01v8 ad=0.3864 pd=2.93 as=0.3304 ps=2.83 w=1.12 l=0.15
X5534 single_9b_cdac_0.SW[3] a_14451_24340# VGND VGND sky130_fd_pr__nfet_01v8 ad=0.1352 pd=1.56 as=0.0754 ps=0.81 w=0.52 l=0.15
X5535 th_dif_sw_0.VCP single_9b_cdac_1.cdac_sw_9b_0.S[0] sky130_fd_pr__cap_mim_m3_1 l=2 w=2
X5536 th_dif_sw_0.VCN single_9b_cdac_0.cdac_sw_9b_0.S[3] sky130_fd_pr__cap_mim_m3_1 l=2 w=2
X5537 VGND single_9b_cdac_0.cdac_sw_9b_0.cdac_sw_3_1.nooverlap_clk_0.x6.A single_9b_cdac_0.cdac_sw_9b_0.cdac_sw_3_1.nooverlap_clk_0.x8.A VGND sky130_fd_pr__nfet_01v8_lvt ad=0.2627 pd=2.19 as=0.2109 ps=2.05 w=0.74 l=0.15
X5538 VDPWR single_9b_cdac_1.cdac_sw_9b_0.cdac_sw_3_8.nooverlap_clk_0.sky130_fd_sc_hs__inv_8_0.A single_9b_cdac_1.cdac_sw_9b_0.cdac_sw_3_8.nooverlap_clk_0.CLKB0 VDPWR sky130_fd_pr__pfet_01v8 ad=0.196 pd=1.47 as=0.168 ps=1.42 w=1.12 l=0.15
X5539 single_9b_cdac_1.cdac_sw_9b_0.cdac_sw_3_7.tg_sw_3_3.SWP single_9b_cdac_1.cdac_sw_9b_0.cdac_sw_3_7.tg_sw_3_3.SWN VGND VGND sky130_fd_pr__nfet_01v8_lvt ad=0.1036 pd=1.02 as=0.1295 ps=1.09 w=0.74 l=0.15
X5540 VGND single_9b_cdac_1.cdac_sw_9b_0.cdac_sw_3_2.nooverlap_clk_0.x8.A single_9b_cdac_1.cdac_sw_9b_0.cdac_sw_3_2.nooverlap_clk_0.x10.A VGND sky130_fd_pr__nfet_01v8_lvt ad=0.1221 pd=1.07 as=0.1184 ps=1.06 w=0.74 l=0.15
X5541 a_43540_26999# single_9b_cdac_0.SW[4] VDPWR VDPWR sky130_fd_pr__pfet_01v8 ad=0.435 pd=3.58 as=0.435 ps=3.58 w=1.5 l=0.5
X5542 VGND VDPWR VGND VGND sky130_fd_pr__nfet_01v8 ad=0.143 pd=1.62 as=0 ps=0 w=0.55 l=0.59
X5543 th_dif_sw_0.VCN single_9b_cdac_0.cdac_sw_9b_0.S[0] sky130_fd_pr__cap_mim_m3_1 l=2 w=2
X5544 VGND a_14143_19748# a_14077_19822# VGND sky130_fd_pr__nfet_01v8 ad=0.12495 pd=1.015 as=0.0669 ps=0.75 w=0.42 l=0.15
X5545 single_9b_cdac_1.cdac_sw_9b_0.cdac_sw_3_8.nooverlap_clk_0.CLKB0 single_9b_cdac_1.cdac_sw_9b_0.cdac_sw_3_8.nooverlap_clk_0.sky130_fd_sc_hs__inv_8_0.A VDPWR VDPWR sky130_fd_pr__pfet_01v8 ad=0.168 pd=1.42 as=0.168 ps=1.42 w=1.12 l=0.15
X5546 VGND single_9b_cdac_1.cdac_sw_9b_0.cdac_sw_3_0.nooverlap_clk_0.x10.A single_9b_cdac_1.cdac_sw_9b_0.cdac_sw_3_0.tg_sw_3_3.SWN VGND sky130_fd_pr__nfet_01v8_lvt ad=0.1036 pd=1.02 as=0.1036 ps=1.02 w=0.74 l=0.15
X5547 th_dif_sw_0.VCN single_9b_cdac_0.cdac_sw_9b_0.S[0] sky130_fd_pr__cap_mim_m3_1 l=2 w=2
X5548 single_9b_cdac_0.cdac_sw_9b_0.cdac_sw_3_3.tg_sw_3_3.SWP single_9b_cdac_0.cdac_sw_9b_0.cdac_sw_3_3.tg_sw_3_3.SWN VGND VGND sky130_fd_pr__nfet_01v8_lvt ad=0.1036 pd=1.02 as=0.2146 ps=2.06 w=0.74 l=0.15
X5549 ua[0] single_9b_cdac_1.cdac_sw_9b_0.cdac_sw_3_2.tg_sw_3_3.SWP ua[0] VDPWR sky130_fd_pr__pfet_01v8 ad=0.435 pd=3.58 as=0 ps=0 w=1.5 l=0.5
X5550 a_64331_29917# single_9b_cdac_0.cdac_sw_9b_0.cdac_sw_3_2.nooverlap_clk_0.x1.A single_9b_cdac_0.cdac_sw_9b_0.cdac_sw_3_2.nooverlap_clk_0.x4.A VGND sky130_fd_pr__nfet_01v8_lvt ad=0.0888 pd=0.98 as=0.2109 ps=2.05 w=0.74 l=0.15
X5551 VDPWR sar9b_0.net40 a_13899_20532# VDPWR sky130_fd_pr__pfet_01v8_hvt ad=0.11455 pd=1.08 as=0.2054 ps=2.1 w=0.79 l=0.15
X5552 VDPWR single_9b_cdac_1.cdac_sw_9b_0.cdac_sw_3_8.nooverlap_clk_0.sky130_fd_sc_hs__inv_8_0.A single_9b_cdac_1.cdac_sw_9b_0.cdac_sw_3_8.nooverlap_clk_0.CLKB0 VDPWR sky130_fd_pr__pfet_01v8 ad=0.168 pd=1.42 as=0.168 ps=1.42 w=1.12 l=0.15
X5553 th_dif_sw_0.VCN single_9b_cdac_0.cdac_sw_9b_0.S[3] sky130_fd_pr__cap_mim_m3_1 l=2 w=2
X5554 VGND single_9b_cdac_1.SW[0] a_63626_17740# VGND sky130_fd_pr__nfet_01v8 ad=0.145 pd=1.58 as=0.145 ps=1.58 w=0.5 l=0.5
X5555 a_63626_17740# single_9b_cdac_1.cdac_sw_9b_0.cdac_sw_3_2.nooverlap_clk_0.CLK0 single_9b_cdac_1.cdac_sw_9b_0.S[0] VGND sky130_fd_pr__nfet_01v8 ad=0.145 pd=1.58 as=0.145 ps=1.58 w=0.5 l=0.5
X5556 single_9b_cdac_0.cdac_sw_9b_0.cdac_sw_3_6.nooverlap_clk_0.sky130_fd_sc_hs__inv_8_0.A single_9b_cdac_0.cdac_sw_9b_0.cdac_sw_3_6.nooverlap_clk_0.x1.A VGND VGND sky130_fd_pr__nfet_01v8_lvt ad=0.1184 pd=1.06 as=0.1221 ps=1.07 w=0.74 l=0.15
X5557 VDPWR VGND VDPWR VDPWR sky130_fd_pr__pfet_01v8_hvt ad=0.2262 pd=2.26 as=0 ps=0 w=0.87 l=0.59
X5558 single_9b_cdac_1.cdac_sw_9b_0.cdac_sw_3_2.tg_sw_3_3.SWN single_9b_cdac_1.cdac_sw_9b_0.cdac_sw_3_2.nooverlap_clk_0.x10.A VGND VGND sky130_fd_pr__nfet_01v8_lvt ad=0.1036 pd=1.02 as=0.1036 ps=1.02 w=0.74 l=0.15
X5559 a_10121_22164# a_8931_22164# a_10012_22164# VGND sky130_fd_pr__special_nfet_01v8 ad=0.0669 pd=0.75 as=0.0711 ps=0.755 w=0.36 l=0.15
X5560 VDPWR VGND VDPWR VDPWR sky130_fd_pr__pfet_01v8_hvt ad=0.2262 pd=2.26 as=0 ps=0 w=0.87 l=0.59
X5561 single_9b_cdac_1.cdac_sw_9b_0.cdac_sw_3_8.nooverlap_clk_0.CLKB0 single_9b_cdac_1.cdac_sw_9b_0.cdac_sw_3_8.nooverlap_clk_0.sky130_fd_sc_hs__inv_8_0.A VDPWR VDPWR sky130_fd_pr__pfet_01v8 ad=0.168 pd=1.42 as=0.196 ps=1.47 w=1.12 l=0.15
X5562 VDPWR single_9b_cdac_1.cdac_sw_9b_0.cdac_sw_3_2.nooverlap_clk_0.CLKB0 single_9b_cdac_1.cdac_sw_9b_0.cdac_sw_3_2.nooverlap_clk_0.CLK0 VDPWR sky130_fd_pr__pfet_01v8 ad=0.3864 pd=2.93 as=0.168 ps=1.42 w=1.12 l=0.15
X5563 VGND single_9b_cdac_0.cdac_sw_9b_0.cdac_sw_3_7.nooverlap_clk_0.CLKB0 single_9b_cdac_0.cdac_sw_9b_0.cdac_sw_3_7.nooverlap_clk_0.CLK0 VGND sky130_fd_pr__nfet_01v8_lvt ad=0.1554 pd=1.16 as=0.1036 ps=1.02 w=0.74 l=0.15
X5564 th_dif_sw_0.VCN single_9b_cdac_0.cdac_sw_9b_0.S[0] sky130_fd_pr__cap_mim_m3_1 l=2 w=2
X5565 th_dif_sw_0.VCN single_9b_cdac_0.cdac_sw_9b_0.S[0] sky130_fd_pr__cap_mim_m3_1 l=2 w=2
X5566 th_dif_sw_0.th_sw_1.CK a_9132_7271# VGND VGND sky130_fd_pr__nfet_01v8_lvt ad=0.1036 pd=1.02 as=0.1036 ps=1.02 w=0.74 l=0.15
X5567 single_9b_cdac_1.cdac_sw_9b_0.cdac_sw_3_2.nooverlap_clk_0.CLK0 single_9b_cdac_1.cdac_sw_9b_0.cdac_sw_3_2.nooverlap_clk_0.CLKB0 VDPWR VDPWR sky130_fd_pr__pfet_01v8 ad=0.168 pd=1.42 as=0.196 ps=1.47 w=1.12 l=0.15
X5568 th_dif_sw_0.VCP single_9b_cdac_1.cdac_sw_9b_0.S[0] sky130_fd_pr__cap_mim_m3_1 l=2 w=2
X5569 th_dif_sw_0.VCP single_9b_cdac_1.cdac_sw_9b_0.S[0] sky130_fd_pr__cap_mim_m3_1 l=2 w=2
X5570 VDPWR single_9b_cdac_0.cdac_sw_9b_0.cdac_sw_3_6.nooverlap_clk_0.sky130_fd_sc_hs__inv_8_0.A single_9b_cdac_0.cdac_sw_9b_0.cdac_sw_3_6.nooverlap_clk_0.CLKB0 VDPWR sky130_fd_pr__pfet_01v8 ad=0.196 pd=1.47 as=0.168 ps=1.42 w=1.12 l=0.15
X5571 a_11045_24858# a_10827_25262# VGND VGND sky130_fd_pr__nfet_01v8 ad=0.0999 pd=0.985 as=0.1346 ps=1.15 w=0.64 l=0.15
X5572 a_9569_24340# a_8379_24340# a_9460_24340# VGND sky130_fd_pr__special_nfet_01v8 ad=0.0669 pd=0.75 as=0.0711 ps=0.755 w=0.36 l=0.15
X5573 th_dif_sw_0.VCN single_9b_cdac_0.cdac_sw_9b_0.S[2] sky130_fd_pr__cap_mim_m3_1 l=2 w=2
X5574 a_9132_7271# th_dif_sw_0.CK VGND VGND sky130_fd_pr__nfet_01v8_lvt ad=0.1295 pd=1.09 as=0.2109 ps=2.05 w=0.74 l=0.15
X5575 VGND single_9b_cdac_1.cdac_sw_9b_0.cdac_sw_3_7.nooverlap_clk_0.x1.A single_9b_cdac_1.cdac_sw_9b_0.cdac_sw_3_7.nooverlap_clk_0.sky130_fd_sc_hs__inv_8_0.A VGND sky130_fd_pr__nfet_01v8_lvt ad=0.1221 pd=1.07 as=0.1184 ps=1.06 w=0.74 l=0.15
X5576 single_9b_cdac_0.cdac_sw_9b_0.cdac_sw_3_6.nooverlap_clk_0.CLKB0 single_9b_cdac_0.cdac_sw_9b_0.cdac_sw_3_6.nooverlap_clk_0.sky130_fd_sc_hs__inv_8_0.A VDPWR VDPWR sky130_fd_pr__pfet_01v8 ad=0.168 pd=1.42 as=0.3864 ps=2.93 w=1.12 l=0.15
X5577 single_9b_cdac_0.cdac_sw_9b_0.S[5] single_9b_cdac_0.cdac_sw_9b_0.cdac_sw_3_5.tg_sw_3_3.SWP ua[0] VGND sky130_fd_pr__nfet_01v8 ad=0.145 pd=1.58 as=0.145 ps=1.58 w=0.5 l=0.5
X5578 a_13308_25428# sar9b_0.net1 VDPWR VDPWR sky130_fd_pr__pfet_01v8_hvt ad=0.0651 pd=0.73 as=0.1092 ps=1.36 w=0.42 l=0.15
X5579 th_dif_sw_0.VCP single_9b_cdac_1.cdac_sw_9b_0.S[0] sky130_fd_pr__cap_mim_m3_1 l=2 w=2
X5580 th_dif_sw_0.VCP single_9b_cdac_1.cdac_sw_9b_0.S[1] sky130_fd_pr__cap_mim_m3_1 l=2 w=2
X5581 th_dif_sw_0.VCP single_9b_cdac_1.cdac_sw_9b_0.S[1] sky130_fd_pr__cap_mim_m3_1 l=2 w=2
X5582 single_9b_cdac_1.cdac_sw_9b_0.cdac_sw_3_1.nooverlap_clk_0.x8.A single_9b_cdac_1.cdac_sw_9b_0.cdac_sw_3_1.nooverlap_clk_0.x6.A VDPWR VDPWR sky130_fd_pr__pfet_01v8 ad=0.3304 pd=2.83 as=0.3864 ps=2.93 w=1.12 l=0.15
X5583 a_11501_25262# a_10311_24890# a_11392_25262# VGND sky130_fd_pr__special_nfet_01v8 ad=0.0669 pd=0.75 as=0.0711 ps=0.755 w=0.36 l=0.15
X5584 single_9b_cdac_1.cdac_sw_9b_0.S[7] single_9b_cdac_1.cdac_sw_9b_0.cdac_sw_3_7.nooverlap_clk_0.CLKB0 a_29134_16877# VDPWR sky130_fd_pr__pfet_01v8 ad=0.435 pd=3.58 as=0.435 ps=3.58 w=1.5 l=0.5
X5585 th_dif_sw_0.VCN single_9b_cdac_0.cdac_sw_9b_0.S[1] sky130_fd_pr__cap_mim_m3_1 l=2 w=2
X5586 VDPWR a_9460_26350# a_9635_26276# VDPWR sky130_fd_pr__pfet_01v8_hvt ad=0.1134 pd=1.38 as=0.0567 ps=0.69 w=0.42 l=0.15
X5587 VDPWR VGND VDPWR VDPWR sky130_fd_pr__pfet_01v8_hvt ad=0.2262 pd=2.26 as=0 ps=0 w=0.87 l=0.59
X5588 single_9b_cdac_1.cdac_sw_9b_0.S[4] single_9b_cdac_1.cdac_sw_9b_0.cdac_sw_3_3.nooverlap_clk_0.CLKB0 a_43540_16877# VDPWR sky130_fd_pr__pfet_01v8 ad=0.435 pd=3.58 as=0.435 ps=3.58 w=1.5 l=0.5
X5589 VDPWR single_9b_cdac_0.cdac_sw_9b_0.cdac_sw_3_4.nooverlap_clk_0.x4.A single_9b_cdac_0.cdac_sw_9b_0.cdac_sw_3_4.nooverlap_clk_0.x6.A VDPWR sky130_fd_pr__pfet_01v8 ad=0.3864 pd=2.93 as=0.3304 ps=2.83 w=1.12 l=0.15
X5590 single_9b_cdac_0.cdac_sw_9b_0.cdac_sw_3_2.tg_sw_3_3.SWP single_9b_cdac_0.cdac_sw_9b_0.cdac_sw_3_2.tg_sw_3_3.SWN VDPWR VDPWR sky130_fd_pr__pfet_01v8 ad=0.168 pd=1.42 as=0.196 ps=1.47 w=1.12 l=0.15
X5591 VGND single_9b_cdac_1.CF[4] single_9b_cdac_0.cdac_sw_9b_0.cdac_sw_3_3.nooverlap_clk_0.x3.Y VGND sky130_fd_pr__nfet_01v8_lvt ad=0.2627 pd=2.19 as=0.2109 ps=2.05 w=0.74 l=0.15
X5592 single_9b_cdac_0.cdac_sw_9b_0.cdac_sw_3_5.tg_sw_3_3.SWN single_9b_cdac_0.cdac_sw_9b_0.cdac_sw_3_5.nooverlap_clk_0.x10.A VGND VGND sky130_fd_pr__nfet_01v8_lvt ad=0.1036 pd=1.02 as=0.1554 ps=1.16 w=0.74 l=0.15
X5593 VDPWR VGND VDPWR VDPWR sky130_fd_pr__pfet_01v8_hvt ad=0.2262 pd=2.26 as=0 ps=0 w=0.87 l=0.59
X5594 th_dif_sw_0.VCN single_9b_cdac_0.cdac_sw_9b_0.S[1] sky130_fd_pr__cap_mim_m3_1 l=2 w=2
X5595 single_9b_cdac_1.cdac_sw_9b_0.cdac_sw_3_6.nooverlap_clk_0.x3.Y single_9b_cdac_1.CF[6] VGND VGND sky130_fd_pr__nfet_01v8_lvt ad=0.2109 pd=2.05 as=0.2627 ps=2.19 w=0.74 l=0.15
X5596 VGND VDPWR VGND VGND sky130_fd_pr__nfet_01v8 ad=0.143 pd=1.62 as=0 ps=0 w=0.55 l=0.59
X5597 a_13053_22164# a_12887_22164# VGND VGND sky130_fd_pr__nfet_01v8 ad=0.1092 pd=1.36 as=0.0567 ps=0.69 w=0.42 l=0.15
X5598 a_10449_19988# sar9b_0.net15 VGND VGND sky130_fd_pr__nfet_01v8 ad=0.0441 pd=0.63 as=0.1346 ps=1.15 w=0.42 l=0.15
X5599 th_dif_sw_0.VCP single_9b_cdac_1.cdac_sw_9b_0.S[1] sky130_fd_pr__cap_mim_m3_1 l=2 w=2
X5600 VDPWR clk a_7345_21594# VDPWR sky130_fd_pr__pfet_01v8_hvt ad=0.14 pd=1.28 as=0.14 ps=1.28 w=1 l=0.15
X5601 VDPWR a_6701_20506# sar9b_0.clknet_1_0__leaf_CLK VDPWR sky130_fd_pr__pfet_01v8_hvt ad=0.14 pd=1.28 as=0.14 ps=1.28 w=1 l=0.15
X5602 single_9b_cdac_1.cdac_sw_9b_0.cdac_sw_3_7.nooverlap_clk_0.CLKB0 single_9b_cdac_1.cdac_sw_9b_0.cdac_sw_3_7.nooverlap_clk_0.sky130_fd_sc_hs__inv_8_0.A VGND VGND sky130_fd_pr__nfet_01v8_lvt ad=0.1036 pd=1.02 as=0.1036 ps=1.02 w=0.74 l=0.15
X5603 a_10254_2858# th_dif_sw_0.th_sw_1.th_sw_main_0.VGS a_10166_3438# VGND sky130_fd_pr__nfet_01v8 ad=1.16 pd=8.58 as=1.16 ps=8.58 w=4 l=0.15
X5604 single_9b_cdac_0.cdac_sw_9b_0.S[2] single_9b_cdac_0.cdac_sw_9b_0.cdac_sw_3_0.tg_sw_3_3.SWP ua[0] VGND sky130_fd_pr__nfet_01v8 ad=0.145 pd=1.58 as=0.145 ps=1.58 w=0.5 l=0.5
X5605 th_dif_sw_0.VCN single_9b_cdac_0.cdac_sw_9b_0.S[0] sky130_fd_pr__cap_mim_m3_1 l=2 w=2
X5606 th_dif_sw_0.VCN single_9b_cdac_0.cdac_sw_9b_0.S[0] sky130_fd_pr__cap_mim_m3_1 l=2 w=2
X5607 VDPWR a_11649_27279# uo_out[3] VDPWR sky130_fd_pr__pfet_01v8_hvt ad=0.11455 pd=1.08 as=0.2054 ps=2.1 w=0.79 l=0.15
X5608 VGND sar9b_0.net13 a_12887_26516# VGND sky130_fd_pr__nfet_01v8 ad=0.0567 pd=0.69 as=0.1092 ps=1.36 w=0.42 l=0.15
X5609 single_9b_cdac_0.cdac_sw_9b_0.cdac_sw_3_4.nooverlap_clk_0.CLKB0 single_9b_cdac_0.cdac_sw_9b_0.cdac_sw_3_4.nooverlap_clk_0.sky130_fd_sc_hs__inv_8_0.A VGND VGND sky130_fd_pr__nfet_01v8_lvt ad=0.1036 pd=1.02 as=0.2146 ps=2.06 w=0.74 l=0.15
X5610 single_9b_cdac_1.cdac_sw_9b_0.S[3] single_9b_cdac_1.cdac_sw_9b_0.cdac_sw_3_4.tg_sw_3_3.SWN single_9b_cdac_1.cdac_sw_9b_0.S[3] VGND sky130_fd_pr__nfet_01v8 ad=0.145 pd=1.58 as=0 ps=0 w=0.5 l=0.5
X5611 a_11649_27279# sar9b_0.net23 VDPWR VDPWR sky130_fd_pr__pfet_01v8_hvt ad=0.2054 pd=2.1 as=0.11455 ps=1.08 w=0.79 l=0.15
X5612 a_24332_26999# single_9b_cdac_0.SW[8] VDPWR VDPWR sky130_fd_pr__pfet_01v8 ad=0.435 pd=3.58 as=0.435 ps=3.58 w=1.5 l=0.5
X5613 ua[0] single_9b_cdac_0.cdac_sw_9b_0.cdac_sw_3_5.tg_sw_3_3.SWN ua[0] VGND sky130_fd_pr__nfet_01v8 ad=0.145 pd=1.58 as=0 ps=0 w=0.5 l=0.5
X5614 VDPWR sar9b_0.net35 a_6726_27060# VDPWR sky130_fd_pr__pfet_01v8_hvt ad=0.1092 pd=1.36 as=0.0651 ps=0.73 w=0.42 l=0.15
X5615 a_8697_27426# a_8653_27034# a_8531_27438# VGND sky130_fd_pr__nfet_01v8 ad=0.0441 pd=0.63 as=0.1401 ps=1.1 w=0.42 l=0.15
X5616 VGND single_9b_cdac_1.cdac_sw_9b_0.cdac_sw_3_6.nooverlap_clk_0.CLKB0 single_9b_cdac_1.cdac_sw_9b_0.cdac_sw_3_6.nooverlap_clk_0.CLK0 VGND sky130_fd_pr__nfet_01v8_lvt ad=0.1554 pd=1.16 as=0.1036 ps=1.02 w=0.74 l=0.15
X5617 th_dif_sw_0.VCP single_9b_cdac_1.cdac_sw_9b_0.S[1] sky130_fd_pr__cap_mim_m3_1 l=2 w=2
X5618 th_dif_sw_0.VCN single_9b_cdac_0.cdac_sw_9b_0.S[1] sky130_fd_pr__cap_mim_m3_1 l=2 w=2
X5619 VDPWR VGND VDPWR VDPWR sky130_fd_pr__pfet_01v8_hvt ad=0.2262 pd=2.26 as=0 ps=0 w=0.87 l=0.59
X5620 single_9b_cdac_0.cdac_sw_9b_0.cdac_sw_3_4.tg_sw_3_3.SWP single_9b_cdac_0.cdac_sw_9b_0.cdac_sw_3_4.tg_sw_3_3.SWN VDPWR VDPWR sky130_fd_pr__pfet_01v8 ad=0.168 pd=1.42 as=0.3864 ps=2.93 w=1.12 l=0.15
X5621 VGND single_9b_cdac_0.cdac_sw_9b_0.cdac_sw_3_0.tg_sw_3_3.SWN single_9b_cdac_0.cdac_sw_9b_0.cdac_sw_3_0.tg_sw_3_3.SWP VGND sky130_fd_pr__nfet_01v8_lvt ad=0.1295 pd=1.09 as=0.1036 ps=1.02 w=0.74 l=0.15
X5622 a_13529_23770# a_13311_24174# VDPWR VDPWR sky130_fd_pr__pfet_01v8_hvt ad=0.12915 pd=1.185 as=0.2184 ps=2.2 w=0.84 l=0.15
X5623 ua[2] th_dif_sw_0.th_sw_1.th_sw_main_0.VGS a_10166_3438# VGND sky130_fd_pr__nfet_01v8 ad=1.16 pd=8.58 as=1.16 ps=8.58 w=4 l=0.15
X5624 a_17125_9355# clk a_16331_9671# VGND sky130_fd_pr__nfet_01v8 ad=0.145 pd=1.29 as=0.29 ps=2.58 w=1 l=1
X5625 single_9b_cdac_1.cdac_sw_9b_0.cdac_sw_3_1.nooverlap_clk_0.sky130_fd_sc_hs__inv_8_0.A single_9b_cdac_1.cdac_sw_9b_0.cdac_sw_3_1.nooverlap_clk_0.x1.A VGND VGND sky130_fd_pr__nfet_01v8_lvt ad=0.1036 pd=1.02 as=0.1221 ps=1.07 w=0.74 l=0.15
X5626 VDPWR single_9b_cdac_0.cdac_sw_9b_0.cdac_sw_3_5.nooverlap_clk_0.x10.A single_9b_cdac_0.cdac_sw_9b_0.cdac_sw_3_5.tg_sw_3_3.SWN VDPWR sky130_fd_pr__pfet_01v8 ad=0.3304 pd=2.83 as=0.168 ps=1.42 w=1.12 l=0.15
X5627 single_9b_cdac_1.cdac_sw_9b_0.S[2] single_9b_cdac_1.cdac_sw_9b_0.cdac_sw_3_0.tg_sw_3_3.SWP single_9b_cdac_1.cdac_sw_9b_0.S[2] VDPWR sky130_fd_pr__pfet_01v8 ad=0.435 pd=3.58 as=0 ps=0 w=1.5 l=0.5
X5628 single_9b_cdac_0.cdac_sw_9b_0.cdac_sw_3_5.tg_sw_3_3.SWN single_9b_cdac_0.cdac_sw_9b_0.cdac_sw_3_5.nooverlap_clk_0.x10.A VDPWR VDPWR sky130_fd_pr__pfet_01v8 ad=0.168 pd=1.42 as=0.196 ps=1.47 w=1.12 l=0.15
X5629 VDPWR single_9b_cdac_0.cdac_sw_9b_0.cdac_sw_3_5.nooverlap_clk_0.sky130_fd_sc_hs__inv_8_0.A single_9b_cdac_0.cdac_sw_9b_0.cdac_sw_3_5.nooverlap_clk_0.CLKB0 VDPWR sky130_fd_pr__pfet_01v8 ad=0.196 pd=1.47 as=0.168 ps=1.42 w=1.12 l=0.15
X5630 single_9b_cdac_0.cdac_sw_9b_0.cdac_sw_3_1.nooverlap_clk_0.CLK0 single_9b_cdac_0.cdac_sw_9b_0.cdac_sw_3_1.nooverlap_clk_0.CLKB0 VGND VGND sky130_fd_pr__nfet_01v8_lvt ad=0.1036 pd=1.02 as=0.1554 ps=1.16 w=0.74 l=0.15
X5631 VDPWR single_9b_cdac_1.cdac_sw_9b_0.cdac_sw_3_7.tg_sw_3_3.SWN single_9b_cdac_1.cdac_sw_9b_0.cdac_sw_3_7.tg_sw_3_3.SWP VDPWR sky130_fd_pr__pfet_01v8 ad=0.3864 pd=2.93 as=0.168 ps=1.42 w=1.12 l=0.15
X5632 VDPWR clk a_16331_9671# VDPWR sky130_fd_pr__pfet_01v8 ad=0.435 pd=3.29 as=0.87 ps=6.58 w=3 l=1
X5633 th_dif_sw_0.VCP single_9b_cdac_1.cdac_sw_9b_0.S[1] sky130_fd_pr__cap_mim_m3_1 l=2 w=2
X5634 single_9b_cdac_1.cdac_sw_9b_0.cdac_sw_3_1.nooverlap_clk_0.CLKB0 single_9b_cdac_1.cdac_sw_9b_0.cdac_sw_3_1.nooverlap_clk_0.sky130_fd_sc_hs__inv_8_0.A VGND VGND sky130_fd_pr__nfet_01v8_lvt ad=0.1036 pd=1.02 as=0.1295 ps=1.09 w=0.74 l=0.15
X5635 a_12027_22138# sar9b_0.net15 VDPWR VDPWR sky130_fd_pr__pfet_01v8_hvt ad=0.0567 pd=0.69 as=0.0819 ps=0.81 w=0.42 l=0.15
X5636 a_57946_16877# single_9b_cdac_1.SW[1] VDPWR VDPWR sky130_fd_pr__pfet_01v8 ad=0.435 pd=3.58 as=0.435 ps=3.58 w=1.5 l=0.5
X5637 th_dif_sw_0.VCN single_9b_cdac_0.cdac_sw_9b_0.S[1] sky130_fd_pr__cap_mim_m3_1 l=2 w=2
X5638 a_8637_20538# a_8471_20538# VGND VGND sky130_fd_pr__nfet_01v8 ad=0.1092 pd=1.36 as=0.0567 ps=0.69 w=0.42 l=0.15
X5639 single_9b_cdac_1.cdac_sw_9b_0.cdac_sw_3_7.tg_sw_3_3.SWP single_9b_cdac_1.cdac_sw_9b_0.cdac_sw_3_7.tg_sw_3_3.SWN VDPWR VDPWR sky130_fd_pr__pfet_01v8 ad=0.168 pd=1.42 as=0.196 ps=1.47 w=1.12 l=0.15
X5640 single_9b_cdac_0.cdac_sw_9b_0.cdac_sw_3_5.nooverlap_clk_0.CLKB0 single_9b_cdac_0.cdac_sw_9b_0.cdac_sw_3_5.nooverlap_clk_0.sky130_fd_sc_hs__inv_8_0.A VDPWR VDPWR sky130_fd_pr__pfet_01v8 ad=0.168 pd=1.42 as=0.3864 ps=2.93 w=1.12 l=0.15
X5641 VDPWR VGND VDPWR VDPWR sky130_fd_pr__pfet_01v8_hvt ad=0.2262 pd=2.26 as=0 ps=0 w=0.87 l=0.59
X5642 a_8453_19450# a_8287_19450# VDPWR VDPWR sky130_fd_pr__pfet_01v8_hvt ad=0.1664 pd=1.8 as=0.0864 ps=0.91 w=0.64 l=0.15
X5643 VDPWR single_9b_cdac_1.cdac_sw_9b_0.cdac_sw_3_7.nooverlap_clk_0.CLKB0 single_9b_cdac_1.cdac_sw_9b_0.cdac_sw_3_7.nooverlap_clk_0.CLK0 VDPWR sky130_fd_pr__pfet_01v8 ad=0.196 pd=1.47 as=0.168 ps=1.42 w=1.12 l=0.15
X5644 VGND a_11567_19748# a_11501_19822# VGND sky130_fd_pr__nfet_01v8 ad=0.12495 pd=1.015 as=0.0669 ps=0.75 w=0.42 l=0.15
X5645 ua[0] single_9b_cdac_1.cdac_sw_9b_0.cdac_sw_3_7.tg_sw_3_3.SWP ua[0] VDPWR sky130_fd_pr__pfet_01v8 ad=0.435 pd=3.58 as=0 ps=0 w=1.5 l=0.5
X5646 a_48343_16877# single_9b_cdac_1.SW[3] VDPWR VDPWR sky130_fd_pr__pfet_01v8 ad=0.435 pd=3.58 as=0.435 ps=3.58 w=1.5 l=0.5
X5647 th_dif_sw_0.VCP single_9b_cdac_1.cdac_sw_9b_0.S[1] sky130_fd_pr__cap_mim_m3_1 l=2 w=2
X5648 a_7345_21594# clk VDPWR VDPWR sky130_fd_pr__pfet_01v8_hvt ad=0.14 pd=1.28 as=0.14 ps=1.28 w=1 l=0.15
X5649 single_9b_cdac_1.cdac_sw_9b_0.S[5] single_9b_cdac_1.cdac_sw_9b_0.cdac_sw_3_5.nooverlap_clk_0.CLKB0 a_38738_16877# VDPWR sky130_fd_pr__pfet_01v8 ad=0.435 pd=3.58 as=0.435 ps=3.58 w=1.5 l=0.5
X5650 th_dif_sw_0.VCN single_9b_cdac_0.cdac_sw_9b_0.S[0] sky130_fd_pr__cap_mim_m3_1 l=2 w=2
X5651 a_11376_18900# sar9b_0.net6 VGND VGND sky130_fd_pr__nfet_01v8 ad=0.066 pd=0.745 as=0.2205 ps=1.89 w=0.42 l=0.15
X5652 single_9b_cdac_1.cdac_sw_9b_0.cdac_sw_3_7.nooverlap_clk_0.CLK0 single_9b_cdac_1.cdac_sw_9b_0.cdac_sw_3_7.nooverlap_clk_0.CLKB0 VDPWR VDPWR sky130_fd_pr__pfet_01v8 ad=0.168 pd=1.42 as=0.3304 ps=2.83 w=1.12 l=0.15
X5653 VGND VDPWR VGND VGND sky130_fd_pr__nfet_01v8 ad=0.143 pd=1.62 as=0 ps=0 w=0.55 l=0.59
X5654 VDPWR a_12487_20836# a_12474_20532# VDPWR sky130_fd_pr__pfet_01v8_hvt ad=0.0819 pd=0.81 as=0.0567 ps=0.69 w=0.42 l=0.15
X5655 VGND VDPWR VGND VGND sky130_fd_pr__nfet_01v8 ad=0.143 pd=1.62 as=0 ps=0 w=0.55 l=0.59
X5656 single_9b_cdac_1.cdac_sw_9b_0.S[2] single_9b_cdac_1.cdac_sw_9b_0.cdac_sw_3_0.tg_sw_3_3.SWP ua[0] VGND sky130_fd_pr__nfet_01v8 ad=0.145 pd=1.58 as=0.145 ps=1.58 w=0.5 l=0.5
X5657 th_dif_sw_0.VCN single_9b_cdac_0.cdac_sw_9b_0.S[0] sky130_fd_pr__cap_mim_m3_1 l=2 w=2
X5658 VGND VDPWR VGND VGND sky130_fd_pr__nfet_01v8 ad=0.143 pd=1.62 as=0 ps=0 w=0.55 l=0.59
X5659 VDPWR VGND VDPWR VDPWR sky130_fd_pr__pfet_01v8_hvt ad=0.2262 pd=2.26 as=0 ps=0 w=0.87 l=0.59
X5660 VGND single_9b_cdac_0.cdac_sw_9b_0.cdac_sw_3_4.nooverlap_clk_0.x10.A single_9b_cdac_0.cdac_sw_9b_0.cdac_sw_3_4.tg_sw_3_3.SWN VGND sky130_fd_pr__nfet_01v8_lvt ad=0.1554 pd=1.16 as=0.1036 ps=1.02 w=0.74 l=0.15
X5661 VDPWR VGND VDPWR VDPWR sky130_fd_pr__pfet_01v8_hvt ad=0.2262 pd=2.26 as=0 ps=0 w=0.87 l=0.59
X5662 VGND single_9b_cdac_0.cdac_sw_9b_0.cdac_sw_3_3.nooverlap_clk_0.x3.Y a_45123_29917# VGND sky130_fd_pr__nfet_01v8_lvt ad=0.2109 pd=2.05 as=0.0888 ps=0.98 w=0.74 l=0.15
X5663 VGND sar9b_0.net40 a_13899_20532# VGND sky130_fd_pr__nfet_01v8 ad=0.0754 pd=0.81 as=0.1352 ps=1.56 w=0.52 l=0.15
X5664 ua[0] single_9b_cdac_1.cdac_sw_9b_0.cdac_sw_3_2.tg_sw_3_3.SWP ua[0] VDPWR sky130_fd_pr__pfet_01v8 ad=0.435 pd=3.58 as=0 ps=0 w=1.5 l=0.5
X5665 VGND sar9b_0.net6 a_12887_19988# VGND sky130_fd_pr__nfet_01v8 ad=0.0567 pd=0.69 as=0.1092 ps=1.36 w=0.42 l=0.15
X5666 VDPWR VGND VDPWR VDPWR sky130_fd_pr__pfet_01v8_hvt ad=0.2262 pd=2.26 as=0 ps=0 w=0.87 l=0.59
X5667 th_dif_sw_0.VCN single_9b_cdac_0.cdac_sw_9b_0.S[0] sky130_fd_pr__cap_mim_m3_1 l=2 w=2
X5668 VGND a_10371_26490# a_10305_26516# VGND sky130_fd_pr__nfet_01v8 ad=0.12495 pd=1.015 as=0.0669 ps=0.75 w=0.42 l=0.15
X5669 a_11567_26516# a_11121_26516# a_11471_26516# VGND sky130_fd_pr__special_nfet_01v8 ad=0.1401 pd=1.1 as=0.0594 ps=0.69 w=0.36 l=0.15
X5670 a_9661_23252# a_8471_23252# a_9552_23252# VGND sky130_fd_pr__special_nfet_01v8 ad=0.0669 pd=0.75 as=0.0711 ps=0.755 w=0.36 l=0.15
X5671 VGND sar9b_0._07_ a_6345_21940# VGND sky130_fd_pr__nfet_01v8 ad=0.169 pd=1.82 as=0.08775 ps=0.92 w=0.65 l=0.15
X5672 VDPWR sar9b_0.net9 a_10955_21076# VDPWR sky130_fd_pr__pfet_01v8_hvt ad=0.0864 pd=0.91 as=0.1664 ps=1.8 w=0.64 l=0.15
X5673 th_dif_sw_0.VCP single_9b_cdac_1.cdac_sw_9b_0.S[1] sky130_fd_pr__cap_mim_m3_1 l=2 w=2
X5674 th_dif_sw_0.VCN single_9b_cdac_0.cdac_sw_9b_0.S[1] sky130_fd_pr__cap_mim_m3_1 l=2 w=2
X5675 VGND a_9132_7271# th_dif_sw_0.th_sw_1.CK VGND sky130_fd_pr__nfet_01v8_lvt ad=0.1036 pd=1.02 as=0.1036 ps=1.02 w=0.74 l=0.15
X5676 VGND single_9b_cdac_0.cdac_sw_9b_0.cdac_sw_3_5.nooverlap_clk_0.sky130_fd_sc_hs__inv_1_1.A single_9b_cdac_0.cdac_sw_9b_0.cdac_sw_3_5.nooverlap_clk_0.x1.A VGND sky130_fd_pr__nfet_01v8_lvt ad=0.2627 pd=2.19 as=0.2109 ps=2.05 w=0.74 l=0.15
X5677 VGND single_9b_cdac_1.cdac_sw_9b_0.cdac_sw_3_1.nooverlap_clk_0.x8.A single_9b_cdac_1.cdac_sw_9b_0.cdac_sw_3_1.nooverlap_clk_0.x10.A VGND sky130_fd_pr__nfet_01v8_lvt ad=0.2109 pd=2.05 as=0.1036 ps=1.02 w=0.74 l=0.15
X5678 VGND sar9b_0.net14 a_14175_27060# VGND sky130_fd_pr__nfet_01v8 ad=0.0754 pd=0.81 as=0.1352 ps=1.56 w=0.52 l=0.15
X5679 ua[0] single_9b_cdac_0.cdac_sw_9b_0.cdac_sw_3_3.tg_sw_3_3.SWN ua[0] VGND sky130_fd_pr__nfet_01v8 ad=0.145 pd=1.58 as=0 ps=0 w=0.5 l=0.5
X5680 single_9b_cdac_1.cdac_sw_9b_0.cdac_sw_3_4.nooverlap_clk_0.x10.A single_9b_cdac_1.cdac_sw_9b_0.cdac_sw_3_4.nooverlap_clk_0.x8.A VGND VGND sky130_fd_pr__nfet_01v8_lvt ad=0.1184 pd=1.06 as=0.2331 ps=2.11 w=0.74 l=0.15
X5681 th_dif_sw_0.VCP single_9b_cdac_1.cdac_sw_9b_0.S[1] sky130_fd_pr__cap_mim_m3_1 l=2 w=2
X5682 a_13511_21442# sar9b_0.net15 VDPWR VDPWR sky130_fd_pr__pfet_01v8_hvt ad=0.1092 pd=1.36 as=0.07035 ps=0.755 w=0.42 l=0.15
X5683 a_14143_19962# sar9b_0.net15 VDPWR VDPWR sky130_fd_pr__pfet_01v8_hvt ad=0.0567 pd=0.69 as=0.0819 ps=0.81 w=0.42 l=0.15
X5684 VGND single_9b_cdac_1.cdac_sw_9b_0.cdac_sw_3_4.nooverlap_clk_0.x10.A single_9b_cdac_1.cdac_sw_9b_0.cdac_sw_3_4.tg_sw_3_3.SWN VGND sky130_fd_pr__nfet_01v8_lvt ad=0.1295 pd=1.09 as=0.1036 ps=1.02 w=0.74 l=0.15
X5685 th_dif_sw_0.VCP single_9b_cdac_1.cdac_sw_9b_0.S[0] sky130_fd_pr__cap_mim_m3_1 l=2 w=2
X5686 th_dif_sw_0.VCN single_9b_cdac_0.cdac_sw_9b_0.S[0] sky130_fd_pr__cap_mim_m3_1 l=2 w=2
X5687 a_58824_17740# single_9b_cdac_1.cdac_sw_9b_0.cdac_sw_3_1.nooverlap_clk_0.CLK0 single_9b_cdac_1.cdac_sw_9b_0.S[1] VGND sky130_fd_pr__nfet_01v8 ad=0.145 pd=1.58 as=0.145 ps=1.58 w=0.5 l=0.5
X5688 single_9b_cdac_0.cdac_sw_9b_0.S[1] single_9b_cdac_0.cdac_sw_9b_0.cdac_sw_3_1.tg_sw_3_3.SWN ua[0] VDPWR sky130_fd_pr__pfet_01v8 ad=0.435 pd=3.58 as=0.435 ps=3.58 w=1.5 l=0.5
X5689 VDPWR a_9167_18874# sar9b_0.net35 VDPWR sky130_fd_pr__pfet_01v8_hvt ad=0.3012 pd=2.66 as=0.26 ps=2.52 w=1 l=0.15
X5690 a_14322_18900# sar9b_0.net15 VGND VGND sky130_fd_pr__nfet_01v8 ad=0.06405 pd=0.725 as=0.12495 ps=1.015 w=0.42 l=0.15
X5691 VGND single_9b_cdac_1.cdac_sw_9b_0.cdac_sw_3_8.nooverlap_clk_0.CLKB0 single_9b_cdac_1.cdac_sw_9b_0.cdac_sw_3_8.nooverlap_clk_0.CLK0 VGND sky130_fd_pr__nfet_01v8_lvt ad=0.2146 pd=2.06 as=0.1036 ps=1.02 w=0.74 l=0.15
X5692 ua[0] single_9b_cdac_1.cdac_sw_9b_0.cdac_sw_3_6.tg_sw_3_3.SWP ua[0] VDPWR sky130_fd_pr__pfet_01v8 ad=0.435 pd=3.58 as=0 ps=0 w=1.5 l=0.5
X5693 VDPWR single_9b_cdac_1.cdac_sw_9b_0.cdac_sw_3_2.nooverlap_clk_0.x10.A single_9b_cdac_1.cdac_sw_9b_0.cdac_sw_3_2.tg_sw_3_3.SWN VDPWR sky130_fd_pr__pfet_01v8 ad=0.196 pd=1.47 as=0.168 ps=1.42 w=1.12 l=0.15
X5694 VDPWR sar9b_0.net15 a_9252_22708# VDPWR sky130_fd_pr__pfet_01v8_hvt ad=0.07035 pd=0.755 as=0.1092 ps=1.36 w=0.42 l=0.15
X5695 a_34814_17740# single_9b_cdac_1.cdac_sw_9b_0.cdac_sw_3_6.nooverlap_clk_0.CLK0 single_9b_cdac_1.cdac_sw_9b_0.S[6] VGND sky130_fd_pr__nfet_01v8 ad=0.145 pd=1.58 as=0.145 ps=1.58 w=0.5 l=0.5
X5696 single_9b_cdac_1.cdac_sw_9b_0.cdac_sw_3_5.tg_sw_3_3.SWN single_9b_cdac_1.cdac_sw_9b_0.cdac_sw_3_5.nooverlap_clk_0.x10.A VDPWR VDPWR sky130_fd_pr__pfet_01v8 ad=0.168 pd=1.42 as=0.3304 ps=2.83 w=1.12 l=0.15
X5697 VGND single_9b_cdac_1.cdac_sw_9b_0.cdac_sw_3_1.nooverlap_clk_0.x10.A single_9b_cdac_1.cdac_sw_9b_0.cdac_sw_3_1.tg_sw_3_3.SWN VGND sky130_fd_pr__nfet_01v8_lvt ad=0.1554 pd=1.16 as=0.1036 ps=1.02 w=0.74 l=0.15
X5698 single_9b_cdac_1.cdac_sw_9b_0.cdac_sw_3_2.nooverlap_clk_0.CLK0 single_9b_cdac_1.cdac_sw_9b_0.cdac_sw_3_2.nooverlap_clk_0.CLKB0 VGND VGND sky130_fd_pr__nfet_01v8_lvt ad=0.1036 pd=1.02 as=0.1554 ps=1.16 w=0.74 l=0.15
X5699 VGND a_6701_20506# sar9b_0.clknet_1_0__leaf_CLK VGND sky130_fd_pr__nfet_01v8 ad=0.0588 pd=0.7 as=0.0588 ps=0.7 w=0.42 l=0.15
X5700 th_dif_sw_0.VCP single_9b_cdac_1.cdac_sw_9b_0.S[4] sky130_fd_pr__cap_mim_m3_1 l=2 w=2
X5701 th_dif_sw_0.VCN single_9b_cdac_0.cdac_sw_9b_0.S[1] sky130_fd_pr__cap_mim_m3_1 l=2 w=2
X5702 single_9b_cdac_1.cdac_sw_9b_0.cdac_sw_3_2.tg_sw_3_3.SWN single_9b_cdac_1.cdac_sw_9b_0.cdac_sw_3_2.nooverlap_clk_0.x10.A VDPWR VDPWR sky130_fd_pr__pfet_01v8 ad=0.168 pd=1.42 as=0.168 ps=1.42 w=1.12 l=0.15
X5703 a_9814_26338# sar9b_0.net3 VGND VGND sky130_fd_pr__nfet_01v8 ad=0.06405 pd=0.725 as=0.12495 ps=1.015 w=0.42 l=0.15
X5704 VGND clk a_7345_21594# VGND sky130_fd_pr__nfet_01v8 ad=0.1113 pd=1.37 as=0.0588 ps=0.7 w=0.42 l=0.15
X5705 sar9b_0.clknet_1_1__leaf_CLK a_6149_23770# VDPWR VDPWR sky130_fd_pr__pfet_01v8_hvt ad=0.14 pd=1.28 as=0.14 ps=1.28 w=1 l=0.15
X5706 sar9b_0.net15 a_6930_20241# VDPWR VDPWR sky130_fd_pr__pfet_01v8_hvt ad=0.135 pd=1.27 as=0.1425 ps=1.285 w=1 l=0.15
X5707 single_9b_cdac_1.cdac_sw_9b_0.S[1] single_9b_cdac_1.cdac_sw_9b_0.cdac_sw_3_1.tg_sw_3_3.SWN ua[0] VDPWR sky130_fd_pr__pfet_01v8 ad=0.435 pd=3.58 as=0.435 ps=3.58 w=1.5 l=0.5
X5708 th_dif_sw_0.VCP single_9b_cdac_1.cdac_sw_9b_0.S[1] sky130_fd_pr__cap_mim_m3_1 l=2 w=2
X5709 th_dif_sw_0.VCP single_9b_cdac_1.cdac_sw_9b_0.S[4] sky130_fd_pr__cap_mim_m3_1 l=2 w=2
X5710 VDPWR single_9b_cdac_1.cdac_sw_9b_0.cdac_sw_3_2.nooverlap_clk_0.x10.A single_9b_cdac_1.cdac_sw_9b_0.cdac_sw_3_2.tg_sw_3_3.SWN VDPWR sky130_fd_pr__pfet_01v8 ad=0.168 pd=1.42 as=0.168 ps=1.42 w=1.12 l=0.15
X5711 sar9b_0.clknet_1_1__leaf_CLK a_6149_23770# VDPWR VDPWR sky130_fd_pr__pfet_01v8_hvt ad=0.14 pd=1.28 as=0.14 ps=1.28 w=1 l=0.15
X5712 VDPWR VGND VDPWR VDPWR sky130_fd_pr__pfet_01v8_hvt ad=0.2262 pd=2.26 as=0 ps=0 w=0.87 l=0.59
X5713 VGND single_9b_cdac_0.cdac_sw_9b_0.cdac_sw_3_8.nooverlap_clk_0.sky130_fd_sc_hs__nand2_1_0.Y single_9b_cdac_0.cdac_sw_9b_0.cdac_sw_3_8.nooverlap_clk_0.sky130_fd_sc_hs__inv_1_1.A VGND sky130_fd_pr__nfet_01v8_lvt ad=0.2627 pd=2.19 as=0.2109 ps=2.05 w=0.74 l=0.15
X5714 VDPWR single_9b_cdac_0.cdac_sw_9b_0.cdac_sw_3_4.nooverlap_clk_0.x6.A single_9b_cdac_0.cdac_sw_9b_0.cdac_sw_3_4.nooverlap_clk_0.x8.A VDPWR sky130_fd_pr__pfet_01v8 ad=0.3864 pd=2.93 as=0.3304 ps=2.83 w=1.12 l=0.15
X5715 VGND single_9b_cdac_0.cdac_sw_9b_0.cdac_sw_3_7.nooverlap_clk_0.x8.A single_9b_cdac_0.cdac_sw_9b_0.cdac_sw_3_7.nooverlap_clk_0.x10.A VGND sky130_fd_pr__nfet_01v8_lvt ad=0.2331 pd=2.11 as=0.1184 ps=1.06 w=0.74 l=0.15
X5716 a_6417_19822# a_5863_19662# a_6070_19721# VGND sky130_fd_pr__special_nfet_01v8 ad=0.0813 pd=0.83 as=0.0621 ps=0.705 w=0.36 l=0.15
X5717 single_9b_cdac_1.cdac_sw_9b_0.cdac_sw_3_0.nooverlap_clk_0.CLK0 single_9b_cdac_1.cdac_sw_9b_0.cdac_sw_3_0.nooverlap_clk_0.CLKB0 VGND VGND sky130_fd_pr__nfet_01v8_lvt ad=0.1036 pd=1.02 as=0.1295 ps=1.09 w=0.74 l=0.15
X5718 single_9b_cdac_1.cdac_sw_9b_0.cdac_sw_3_2.tg_sw_3_3.SWN single_9b_cdac_1.cdac_sw_9b_0.cdac_sw_3_2.nooverlap_clk_0.x10.A VDPWR VDPWR sky130_fd_pr__pfet_01v8 ad=0.168 pd=1.42 as=0.196 ps=1.47 w=1.12 l=0.15
X5719 single_9b_cdac_1.cdac_sw_9b_0.S[4] single_9b_cdac_1.cdac_sw_9b_0.cdac_sw_3_3.nooverlap_clk_0.CLKB0 a_43540_16877# VDPWR sky130_fd_pr__pfet_01v8 ad=0.435 pd=3.58 as=0.435 ps=3.58 w=1.5 l=0.5
X5720 VGND a_14143_18874# a_14077_18900# VGND sky130_fd_pr__nfet_01v8 ad=0.12495 pd=1.015 as=0.0669 ps=0.75 w=0.42 l=0.15
X5721 single_9b_cdac_1.cdac_sw_9b_0.cdac_sw_3_8.nooverlap_clk_0.x1.A single_9b_cdac_1.cdac_sw_9b_0.cdac_sw_3_8.nooverlap_clk_0.sky130_fd_sc_hs__inv_1_1.A VGND VGND sky130_fd_pr__nfet_01v8_lvt ad=0.2109 pd=2.05 as=0.2627 ps=2.19 w=0.74 l=0.15
X5722 th_dif_sw_0.VCN single_9b_cdac_0.cdac_sw_9b_0.S[0] sky130_fd_pr__cap_mim_m3_1 l=2 w=2
X5723 a_13968_25428# a_13053_25428# a_13621_25670# VGND sky130_fd_pr__special_nfet_01v8 ad=0.0711 pd=0.755 as=0.0999 ps=0.985 w=0.36 l=0.15
X5724 a_38738_16877# single_9b_cdac_1.SW[5] VDPWR VDPWR sky130_fd_pr__pfet_01v8 ad=0.435 pd=3.58 as=0.435 ps=3.58 w=1.5 l=0.5
X5725 single_9b_cdac_1.cdac_sw_9b_0.cdac_sw_3_2.nooverlap_clk_0.x10.A single_9b_cdac_1.cdac_sw_9b_0.cdac_sw_3_2.nooverlap_clk_0.x8.A VGND VGND sky130_fd_pr__nfet_01v8_lvt ad=0.1036 pd=1.02 as=0.1221 ps=1.07 w=0.74 l=0.15
X5726 th_dif_sw_0.VCN single_9b_cdac_0.cdac_sw_9b_0.S[0] sky130_fd_pr__cap_mim_m3_1 l=2 w=2
X5727 single_9b_cdac_0.cdac_sw_9b_0.S[8] single_9b_cdac_0.cdac_sw_9b_0.cdac_sw_3_8.tg_sw_3_3.SWP single_9b_cdac_0.cdac_sw_9b_0.S[8] VDPWR sky130_fd_pr__pfet_01v8 ad=0.435 pd=3.58 as=0 ps=0 w=1.5 l=0.5
X5728 VDPWR VGND VDPWR VDPWR sky130_fd_pr__pfet_01v8_hvt ad=0.2262 pd=2.26 as=0 ps=0 w=0.87 l=0.59
X5729 VDPWR single_9b_cdac_0.cdac_sw_9b_0.cdac_sw_3_1.tg_sw_3_3.SWN single_9b_cdac_0.cdac_sw_9b_0.cdac_sw_3_1.tg_sw_3_3.SWP VDPWR sky130_fd_pr__pfet_01v8 ad=0.3304 pd=2.83 as=0.168 ps=1.42 w=1.12 l=0.15
X5730 VGND VDPWR VGND VGND sky130_fd_pr__nfet_01v8 ad=0.143 pd=1.62 as=0 ps=0 w=0.55 l=0.59
X5731 single_9b_cdac_0.cdac_sw_9b_0.cdac_sw_3_2.tg_sw_3_3.SWP single_9b_cdac_0.cdac_sw_9b_0.cdac_sw_3_2.tg_sw_3_3.SWN VGND VGND sky130_fd_pr__nfet_01v8_lvt ad=0.1036 pd=1.02 as=0.1554 ps=1.16 w=0.74 l=0.15
X5732 th_dif_sw_0.VCN single_9b_cdac_0.cdac_sw_9b_0.S[7] sky130_fd_pr__cap_mim_m3_1 l=2 w=2
X5733 single_9b_cdac_0.cdac_sw_9b_0.cdac_sw_3_6.tg_sw_3_3.SWP single_9b_cdac_0.cdac_sw_9b_0.cdac_sw_3_6.tg_sw_3_3.SWN VDPWR VDPWR sky130_fd_pr__pfet_01v8 ad=0.168 pd=1.42 as=0.196 ps=1.47 w=1.12 l=0.15
X5734 VDPWR single_9b_cdac_0.cdac_sw_9b_0.cdac_sw_3_0.nooverlap_clk_0.x8.A single_9b_cdac_0.cdac_sw_9b_0.cdac_sw_3_0.nooverlap_clk_0.x10.A VDPWR sky130_fd_pr__pfet_01v8 ad=0.3304 pd=2.83 as=0.168 ps=1.42 w=1.12 l=0.15
X5735 VGND a_9635_26276# a_9569_26350# VGND sky130_fd_pr__nfet_01v8 ad=0.12495 pd=1.015 as=0.0669 ps=0.75 w=0.42 l=0.15
X5736 VDPWR VGND VDPWR VDPWR sky130_fd_pr__pfet_01v8_hvt ad=0.2262 pd=2.26 as=0 ps=0 w=0.87 l=0.59
X5737 single_9b_cdac_1.cdac_sw_9b_0.cdac_sw_3_2.tg_sw_3_3.SWN single_9b_cdac_1.cdac_sw_9b_0.cdac_sw_3_2.nooverlap_clk_0.x10.A VGND VGND sky130_fd_pr__nfet_01v8_lvt ad=0.1036 pd=1.02 as=0.1295 ps=1.09 w=0.74 l=0.15
X5738 single_9b_cdac_0.cdac_sw_9b_0.cdac_sw_3_1.tg_sw_3_3.SWP single_9b_cdac_0.cdac_sw_9b_0.cdac_sw_3_1.tg_sw_3_3.SWN VDPWR VDPWR sky130_fd_pr__pfet_01v8 ad=0.168 pd=1.42 as=0.196 ps=1.47 w=1.12 l=0.15
X5739 single_9b_cdac_1.cdac_sw_9b_0.S[8] single_9b_cdac_1.cdac_sw_9b_0.cdac_sw_3_8.tg_sw_3_3.SWN single_9b_cdac_1.cdac_sw_9b_0.S[8] VGND sky130_fd_pr__nfet_01v8 ad=0.145 pd=1.58 as=0 ps=0 w=0.5 l=0.5
X5740 th_dif_sw_0.VCP single_9b_cdac_1.cdac_sw_9b_0.S[0] sky130_fd_pr__cap_mim_m3_1 l=2 w=2
X5741 single_9b_cdac_1.cdac_sw_9b_0.cdac_sw_3_6.nooverlap_clk_0.x4.A single_9b_cdac_1.cdac_sw_9b_0.cdac_sw_3_6.nooverlap_clk_0.x1.A a_35519_15495# VGND sky130_fd_pr__nfet_01v8_lvt ad=0.2109 pd=2.05 as=0.0888 ps=0.98 w=0.74 l=0.15
X5742 th_dif_sw_0.VCP single_9b_cdac_1.cdac_sw_9b_0.S[1] sky130_fd_pr__cap_mim_m3_1 l=2 w=2
X5743 th_dif_sw_0.VCN single_9b_cdac_0.cdac_sw_9b_0.S[7] sky130_fd_pr__cap_mim_m3_1 l=2 w=2
X5744 VDPWR a_7035_22708# a_7203_22682# VDPWR sky130_fd_pr__pfet_01v8_hvt ad=0.135 pd=1.27 as=0.27 ps=2.54 w=1 l=0.15
X5745 single_9b_cdac_1.cdac_sw_9b_0.S[3] single_9b_cdac_1.cdac_sw_9b_0.cdac_sw_3_4.tg_sw_3_3.SWP single_9b_cdac_1.cdac_sw_9b_0.S[3] VDPWR sky130_fd_pr__pfet_01v8 ad=0.435 pd=3.58 as=0 ps=0 w=1.5 l=0.5
X5746 VGND VDPWR VGND VGND sky130_fd_pr__nfet_01v8 ad=0.143 pd=1.62 as=0 ps=0 w=0.55 l=0.59
X5747 a_24332_26999# single_9b_cdac_0.SW[8] VDPWR VDPWR sky130_fd_pr__pfet_01v8 ad=0.435 pd=3.58 as=0.435 ps=3.58 w=1.5 l=0.5
X5748 th_dif_sw_0.VCN single_9b_cdac_0.cdac_sw_9b_0.S[0] sky130_fd_pr__cap_mim_m3_1 l=2 w=2
X5749 VDPWR single_9b_cdac_0.cdac_sw_9b_0.cdac_sw_3_8.tg_sw_3_3.SWN single_9b_cdac_0.cdac_sw_9b_0.cdac_sw_3_8.tg_sw_3_3.SWP VDPWR sky130_fd_pr__pfet_01v8 ad=0.196 pd=1.47 as=0.168 ps=1.42 w=1.12 l=0.15
X5750 ua[0] single_9b_cdac_0.cdac_sw_9b_0.cdac_sw_3_0.tg_sw_3_3.SWN ua[0] VGND sky130_fd_pr__nfet_01v8 ad=0.145 pd=1.58 as=0 ps=0 w=0.5 l=0.5
X5751 th_dif_sw_0.VCN single_9b_cdac_0.cdac_sw_9b_0.S[2] sky130_fd_pr__cap_mim_m3_1 l=2 w=2
X5752 single_9b_cdac_0.cdac_sw_9b_0.cdac_sw_3_8.tg_sw_3_3.SWP single_9b_cdac_0.cdac_sw_9b_0.cdac_sw_3_8.tg_sw_3_3.SWN VDPWR VDPWR sky130_fd_pr__pfet_01v8 ad=0.168 pd=1.42 as=0.168 ps=1.42 w=1.12 l=0.15
X5753 VGND VDPWR VGND VGND sky130_fd_pr__nfet_01v8 ad=0.143 pd=1.62 as=0 ps=0 w=0.55 l=0.59
X5754 a_9555_22530# a_8931_22164# a_9447_22164# VDPWR sky130_fd_pr__pfet_01v8_hvt ad=0.1155 pd=0.97 as=0.07245 ps=0.765 w=0.42 l=0.15
X5755 VGND VDPWR VGND VGND sky130_fd_pr__nfet_01v8 ad=0.143 pd=1.62 as=0 ps=0 w=0.55 l=0.59
X5756 a_25915_15495# single_9b_cdac_1.cdac_sw_9b_0.cdac_sw_3_8.nooverlap_clk_0.x3.Y VGND VGND sky130_fd_pr__nfet_01v8_lvt ad=0.0888 pd=0.98 as=0.2109 ps=2.05 w=0.74 l=0.15
X5757 a_9893_26516# a_9849_26758# a_9727_26516# VGND sky130_fd_pr__nfet_01v8 ad=0.0441 pd=0.63 as=0.1401 ps=1.1 w=0.42 l=0.15
X5758 VDPWR VGND VDPWR VDPWR sky130_fd_pr__pfet_01v8_hvt ad=0.2262 pd=2.26 as=0 ps=0 w=0.87 l=0.59
X5759 VGND single_9b_cdac_1.cdac_sw_9b_0.cdac_sw_3_1.nooverlap_clk_0.sky130_fd_sc_hs__inv_8_0.A single_9b_cdac_1.cdac_sw_9b_0.cdac_sw_3_1.nooverlap_clk_0.CLKB0 VGND sky130_fd_pr__nfet_01v8_lvt ad=0.2146 pd=2.06 as=0.1036 ps=1.02 w=0.74 l=0.15
X5760 VGND single_9b_cdac_0.cdac_sw_9b_0.cdac_sw_3_8.nooverlap_clk_0.CLKB0 single_9b_cdac_0.cdac_sw_9b_0.cdac_sw_3_8.nooverlap_clk_0.CLK0 VGND sky130_fd_pr__nfet_01v8_lvt ad=0.2109 pd=2.05 as=0.1036 ps=1.02 w=0.74 l=0.15
X5761 single_9b_cdac_0.cdac_sw_9b_0.S[5] single_9b_cdac_0.cdac_sw_9b_0.cdac_sw_3_5.tg_sw_3_3.SWN ua[0] VDPWR sky130_fd_pr__pfet_01v8 ad=0.435 pd=3.58 as=0.435 ps=3.58 w=1.5 l=0.5
X5762 a_13308_25250# sar9b_0.net1 VDPWR VDPWR sky130_fd_pr__pfet_01v8_hvt ad=0.0651 pd=0.73 as=0.1092 ps=1.36 w=0.42 l=0.15
X5763 VGND VDPWR VGND VGND sky130_fd_pr__nfet_01v8 ad=0.143 pd=1.62 as=0 ps=0 w=0.55 l=0.59
X5764 a_49221_17740# single_9b_cdac_1.cdac_sw_9b_0.cdac_sw_3_4.nooverlap_clk_0.CLK0 single_9b_cdac_1.cdac_sw_9b_0.S[3] VGND sky130_fd_pr__nfet_01v8 ad=0.145 pd=1.58 as=0.145 ps=1.58 w=0.5 l=0.5
X5765 th_dif_sw_0.VCN single_9b_cdac_0.cdac_sw_9b_0.S[0] sky130_fd_pr__cap_mim_m3_1 l=2 w=2
X5766 VDPWR single_9b_cdac_0.cdac_sw_9b_0.cdac_sw_3_8.tg_sw_3_3.SWN single_9b_cdac_0.cdac_sw_9b_0.cdac_sw_3_8.tg_sw_3_3.SWP VDPWR sky130_fd_pr__pfet_01v8 ad=0.168 pd=1.42 as=0.168 ps=1.42 w=1.12 l=0.15
X5767 VDPWR VGND VDPWR VDPWR sky130_fd_pr__pfet_01v8_hvt ad=0.2262 pd=2.26 as=0 ps=0 w=0.87 l=0.59
X5768 a_10012_22164# a_8931_22164# a_9665_22406# VDPWR sky130_fd_pr__pfet_01v8_hvt ad=0.0588 pd=0.7 as=0.12915 ps=1.185 w=0.42 l=0.15
X5769 single_9b_cdac_1.cdac_sw_9b_0.cdac_sw_3_7.nooverlap_clk_0.sky130_fd_sc_hs__inv_8_0.A single_9b_cdac_1.cdac_sw_9b_0.cdac_sw_3_7.nooverlap_clk_0.x1.A VGND VGND sky130_fd_pr__nfet_01v8_lvt ad=0.1036 pd=1.02 as=0.1221 ps=1.07 w=0.74 l=0.15
X5770 single_9b_cdac_1.cdac_sw_9b_0.cdac_sw_3_3.nooverlap_clk_0.CLK0 single_9b_cdac_1.cdac_sw_9b_0.cdac_sw_3_3.nooverlap_clk_0.CLKB0 VGND VGND sky130_fd_pr__nfet_01v8_lvt ad=0.1036 pd=1.02 as=0.1295 ps=1.09 w=0.74 l=0.15
X5771 single_9b_cdac_0.cdac_sw_9b_0.S[5] single_9b_cdac_0.cdac_sw_9b_0.cdac_sw_3_5.tg_sw_3_3.SWP single_9b_cdac_0.cdac_sw_9b_0.S[5] VDPWR sky130_fd_pr__pfet_01v8 ad=0.435 pd=3.58 as=0 ps=0 w=1.5 l=0.5
X5772 a_11392_25262# a_10477_24890# a_11045_24858# VGND sky130_fd_pr__special_nfet_01v8 ad=0.0711 pd=0.755 as=0.0999 ps=0.985 w=0.36 l=0.15
X5773 th_dif_sw_0.VCP single_9b_cdac_1.cdac_sw_9b_0.S[0] sky130_fd_pr__cap_mim_m3_1 l=2 w=2
X5774 th_dif_sw_0.VCN single_9b_cdac_0.cdac_sw_9b_0.S[0] sky130_fd_pr__cap_mim_m3_1 l=2 w=2
X5775 th_dif_sw_0.VCN single_9b_cdac_0.cdac_sw_9b_0.S[2] sky130_fd_pr__cap_mim_m3_1 l=2 w=2
X5776 VGND single_9b_cdac_0.cdac_sw_9b_0.cdac_sw_3_3.nooverlap_clk_0.x6.A single_9b_cdac_0.cdac_sw_9b_0.cdac_sw_3_3.nooverlap_clk_0.x8.A VGND sky130_fd_pr__nfet_01v8_lvt ad=0.2627 pd=2.19 as=0.2109 ps=2.05 w=0.74 l=0.15
X5777 VDPWR tdc_0.phase_detector_0.pd_out_0.A tdc_0.phase_detector_0.pd_out_0.B VDPWR sky130_fd_pr__pfet_01v8 ad=0.87 pd=6.58 as=0.435 ps=3.29 w=3 l=0.15
X5778 single_9b_cdac_0.cdac_sw_9b_0.cdac_sw_3_7.nooverlap_clk_0.CLK0 single_9b_cdac_0.cdac_sw_9b_0.cdac_sw_3_7.nooverlap_clk_0.CLKB0 VGND VGND sky130_fd_pr__nfet_01v8_lvt ad=0.1036 pd=1.02 as=0.1554 ps=1.16 w=0.74 l=0.15
X5779 a_5999_19822# a_5863_19662# a_5579_19676# VDPWR sky130_fd_pr__pfet_01v8_hvt ad=0.1095 pd=1.075 as=0.0567 ps=0.69 w=0.42 l=0.15
X5780 VGND VDPWR VGND VGND sky130_fd_pr__nfet_01v8 ad=0.143 pd=1.62 as=0 ps=0 w=0.55 l=0.59
X5781 VDPWR VGND VDPWR VDPWR sky130_fd_pr__pfet_01v8_hvt ad=0.2262 pd=2.26 as=0 ps=0 w=0.87 l=0.59
X5782 VGND single_9b_cdac_1.cdac_sw_9b_0.cdac_sw_3_4.nooverlap_clk_0.x10.A single_9b_cdac_1.cdac_sw_9b_0.cdac_sw_3_4.tg_sw_3_3.SWN VGND sky130_fd_pr__nfet_01v8_lvt ad=0.1036 pd=1.02 as=0.1036 ps=1.02 w=0.74 l=0.15
X5783 single_9b_cdac_1.cdac_sw_9b_0.cdac_sw_3_7.nooverlap_clk_0.CLKB0 single_9b_cdac_1.cdac_sw_9b_0.cdac_sw_3_7.nooverlap_clk_0.sky130_fd_sc_hs__inv_8_0.A VGND VGND sky130_fd_pr__nfet_01v8_lvt ad=0.1036 pd=1.02 as=0.1295 ps=1.09 w=0.74 l=0.15
X5784 th_dif_sw_0.VCP single_9b_cdac_1.cdac_sw_9b_0.S[3] sky130_fd_pr__cap_mim_m3_1 l=2 w=2
X5785 single_9b_cdac_1.cdac_sw_9b_0.S[2] single_9b_cdac_1.cdac_sw_9b_0.cdac_sw_3_0.tg_sw_3_3.SWN single_9b_cdac_1.cdac_sw_9b_0.S[2] VGND sky130_fd_pr__nfet_01v8 ad=0.145 pd=1.58 as=0 ps=0 w=0.5 l=0.5
X5786 a_13621_22682# a_13403_23086# VDPWR VDPWR sky130_fd_pr__pfet_01v8_hvt ad=0.12915 pd=1.185 as=0.2184 ps=2.2 w=0.84 l=0.15
X5787 VDPWR VGND VDPWR VDPWR sky130_fd_pr__pfet_01v8_hvt ad=0.2262 pd=2.26 as=0 ps=0 w=0.87 l=0.59
X5788 VDPWR single_9b_cdac_1.CF[8] single_9b_cdac_0.cdac_sw_9b_0.cdac_sw_3_8.nooverlap_clk_0.x3.Y VDPWR sky130_fd_pr__pfet_01v8 ad=0.3864 pd=2.93 as=0.3304 ps=2.83 w=1.12 l=0.15
X5789 VDPWR a_13621_25670# a_13511_25794# VDPWR sky130_fd_pr__pfet_01v8_hvt ad=0.07035 pd=0.755 as=0.1155 ps=0.97 w=0.42 l=0.15
X5790 a_7035_22708# a_6171_22714# a_6778_22682# VDPWR sky130_fd_pr__pfet_01v8_hvt ad=0.0567 pd=0.69 as=0.1095 ps=1.075 w=0.42 l=0.15
X5791 VDPWR a_14143_21050# a_14130_21442# VDPWR sky130_fd_pr__pfet_01v8_hvt ad=0.0819 pd=0.81 as=0.0567 ps=0.69 w=0.42 l=0.15
X5792 sar9b_0.net19 a_7059_25402# VDPWR VDPWR sky130_fd_pr__pfet_01v8_hvt ad=0.26 pd=2.52 as=0.3012 ps=2.66 w=1 l=0.15
X5793 VGND VDPWR VGND VGND sky130_fd_pr__nfet_01v8 ad=0.143 pd=1.62 as=0 ps=0 w=0.55 l=0.59
X5794 th_dif_sw_0.VCP single_9b_cdac_1.cdac_sw_9b_0.S[0] sky130_fd_pr__cap_mim_m3_1 l=2 w=2
X5795 a_11746_23252# sar9b_0.net15 VGND VGND sky130_fd_pr__nfet_01v8 ad=0.06405 pd=0.725 as=0.12495 ps=1.015 w=0.42 l=0.15
X5796 a_6814_22414# sar9b_0.clk_div_0.COUNT\[0\] VDPWR VDPWR sky130_fd_pr__pfet_01v8_hvt ad=0.05985 pd=0.705 as=0.14825 ps=1.34 w=0.42 l=0.15
X5797 th_dif_sw_0.VCP single_9b_cdac_1.cdac_sw_9b_0.S[0] sky130_fd_pr__cap_mim_m3_1 l=2 w=2
X5798 th_dif_sw_0.VCN single_9b_cdac_0.cdac_sw_9b_0.S[4] sky130_fd_pr__cap_mim_m3_1 l=2 w=2
X5799 VGND a_5343_25972# sar9b_0.net3 VGND sky130_fd_pr__nfet_01v8 ad=0.0588 pd=0.7 as=0.0588 ps=0.7 w=0.42 l=0.15
X5800 a_11457_25428# a_11413_25670# a_11291_25428# VGND sky130_fd_pr__nfet_01v8 ad=0.0441 pd=0.63 as=0.1401 ps=1.1 w=0.42 l=0.15
X5801 a_11549_22164# a_11505_22406# a_11383_22164# VGND sky130_fd_pr__nfet_01v8 ad=0.0441 pd=0.63 as=0.1401 ps=1.1 w=0.42 l=0.15
X5802 a_14077_21076# a_12887_21076# a_13968_21076# VGND sky130_fd_pr__special_nfet_01v8 ad=0.0669 pd=0.75 as=0.0711 ps=0.755 w=0.36 l=0.15
X5803 VDPWR VGND VDPWR VDPWR sky130_fd_pr__pfet_01v8_hvt ad=0.2262 pd=2.26 as=0 ps=0 w=0.87 l=0.59
X5804 tdc_0.delay_gate_ori_0.sky130_fd_sc_hs__and2_1_0.A a_14871_9671# a_15265_9613# VDPWR sky130_fd_pr__pfet_01v8 ad=0.87 pd=6.58 as=0.435 ps=3.29 w=3 l=1
X5805 VDPWR single_9b_cdac_1.cdac_sw_9b_0.cdac_sw_3_0.nooverlap_clk_0.x1.A single_9b_cdac_1.cdac_sw_9b_0.cdac_sw_3_0.nooverlap_clk_0.x4.A VDPWR sky130_fd_pr__pfet_01v8 ad=0.3192 pd=2.81 as=0.168 ps=1.42 w=1.12 l=0.15
X5806 single_9b_cdac_0.cdac_sw_9b_0.cdac_sw_3_0.nooverlap_clk_0.CLK0 single_9b_cdac_0.cdac_sw_9b_0.cdac_sw_3_0.nooverlap_clk_0.CLKB0 VDPWR VDPWR sky130_fd_pr__pfet_01v8 ad=0.168 pd=1.42 as=0.196 ps=1.47 w=1.12 l=0.15
X5807 VGND a_9078_20506# a_9036_20910# VGND sky130_fd_pr__nfet_01v8 ad=0.12095 pd=1.085 as=0.0696 ps=0.765 w=0.42 l=0.15
X5808 VGND a_12947_26276# a_12881_26350# VGND sky130_fd_pr__nfet_01v8 ad=0.12495 pd=1.015 as=0.0669 ps=0.75 w=0.42 l=0.15
X5809 VDPWR sar9b_0.net2 a_10406_19266# VDPWR sky130_fd_pr__pfet_01v8_hvt ad=0.1092 pd=1.36 as=0.0651 ps=0.73 w=0.42 l=0.15
X5810 ua[0] single_9b_cdac_1.cdac_sw_9b_0.cdac_sw_3_5.tg_sw_3_3.SWN ua[0] VGND sky130_fd_pr__nfet_01v8 ad=0.145 pd=1.58 as=0 ps=0 w=0.5 l=0.5
X5811 a_6674_21050# sar9b_0._08_ VGND VGND sky130_fd_pr__nfet_01v8 ad=0.1113 pd=1.37 as=0.1359 ps=1.1 w=0.42 l=0.15
X5812 ua[0] single_9b_cdac_1.cdac_sw_9b_0.cdac_sw_3_6.tg_sw_3_3.SWP ua[0] VDPWR sky130_fd_pr__pfet_01v8 ad=0.435 pd=3.58 as=0 ps=0 w=1.5 l=0.5
X5813 single_9b_cdac_1.cdac_sw_9b_0.cdac_sw_3_0.nooverlap_clk_0.x4.A single_9b_cdac_1.cdac_sw_9b_0.cdac_sw_3_0.nooverlap_clk_0.x3.Y VDPWR VDPWR sky130_fd_pr__pfet_01v8 ad=0.168 pd=1.42 as=0.3192 ps=2.81 w=1.12 l=0.15
X5814 single_9b_cdac_0.cdac_sw_9b_0.cdac_sw_3_1.nooverlap_clk_0.CLK0 single_9b_cdac_0.cdac_sw_9b_0.cdac_sw_3_1.nooverlap_clk_0.CLKB0 VGND VGND sky130_fd_pr__nfet_01v8_lvt ad=0.1036 pd=1.02 as=0.1295 ps=1.09 w=0.74 l=0.15
X5815 VDPWR sar9b_0.clknet_0_CLK a_6701_20506# VDPWR sky130_fd_pr__pfet_01v8_hvt ad=0.265 pd=2.53 as=0.14 ps=1.28 w=1 l=0.15
X5816 single_9b_cdac_1.cdac_sw_9b_0.S[2] single_9b_cdac_1.cdac_sw_9b_0.cdac_sw_3_0.nooverlap_clk_0.CLKB0 a_53154_16877# VDPWR sky130_fd_pr__pfet_01v8 ad=0.435 pd=3.58 as=0.435 ps=3.58 w=1.5 l=0.5
X5817 th_dif_sw_0.VCN single_9b_cdac_0.cdac_sw_9b_0.S[3] sky130_fd_pr__cap_mim_m3_1 l=2 w=2
X5818 th_dif_sw_0.VCN single_9b_cdac_0.cdac_sw_9b_0.S[5] sky130_fd_pr__cap_mim_m3_1 l=2 w=2
X5819 single_9b_cdac_1.cdac_sw_9b_0.S[1] single_9b_cdac_1.cdac_sw_9b_0.cdac_sw_3_1.tg_sw_3_3.SWP ua[0] VGND sky130_fd_pr__nfet_01v8 ad=0.145 pd=1.58 as=0.145 ps=1.58 w=0.5 l=0.5
X5820 VGND single_9b_cdac_0.cdac_sw_9b_0.cdac_sw_3_6.nooverlap_clk_0.x10.A single_9b_cdac_0.cdac_sw_9b_0.cdac_sw_3_6.tg_sw_3_3.SWN VGND sky130_fd_pr__nfet_01v8_lvt ad=0.1295 pd=1.09 as=0.1036 ps=1.02 w=0.74 l=0.15
X5821 ua[0] single_9b_cdac_0.cdac_sw_9b_0.cdac_sw_3_5.tg_sw_3_3.SWN ua[0] VGND sky130_fd_pr__nfet_01v8 ad=0.145 pd=1.58 as=0 ps=0 w=0.5 l=0.5
X5822 VGND a_5483_19676# sar9b_0.net16 VGND sky130_fd_pr__nfet_01v8 ad=0.08775 pd=0.92 as=0.169 ps=1.82 w=0.65 l=0.15
X5823 th_dif_sw_0.VCN single_9b_cdac_0.cdac_sw_9b_0.S[0] sky130_fd_pr__cap_mim_m3_1 l=2 w=2
X5824 a_11579_23796# a_10955_23802# a_11471_24174# VDPWR sky130_fd_pr__pfet_01v8_hvt ad=0.1155 pd=0.97 as=0.07245 ps=0.765 w=0.42 l=0.15
X5825 a_30012_17740# single_9b_cdac_1.cdac_sw_9b_0.cdac_sw_3_7.nooverlap_clk_0.CLK0 single_9b_cdac_1.cdac_sw_9b_0.S[7] VGND sky130_fd_pr__nfet_01v8 ad=0.145 pd=1.58 as=0.145 ps=1.58 w=0.5 l=0.5
X5826 VGND single_9b_cdac_1.cdac_sw_9b_0.cdac_sw_3_5.nooverlap_clk_0.x1.A single_9b_cdac_1.cdac_sw_9b_0.cdac_sw_3_5.nooverlap_clk_0.sky130_fd_sc_hs__inv_8_0.A VGND sky130_fd_pr__nfet_01v8_lvt ad=0.2109 pd=2.05 as=0.1036 ps=1.02 w=0.74 l=0.15
X5827 a_13511_26882# a_12887_26516# a_13403_26516# VDPWR sky130_fd_pr__pfet_01v8_hvt ad=0.1155 pd=0.97 as=0.07245 ps=0.765 w=0.42 l=0.15
X5828 single_9b_cdac_0.cdac_sw_9b_0.cdac_sw_3_1.tg_sw_3_3.SWN single_9b_cdac_0.cdac_sw_9b_0.cdac_sw_3_1.nooverlap_clk_0.x10.A VGND VGND sky130_fd_pr__nfet_01v8_lvt ad=0.1036 pd=1.02 as=0.2146 ps=2.06 w=0.74 l=0.15
X5829 VGND a_11935_25402# sar9b_0.FINAL VGND sky130_fd_pr__nfet_01v8 ad=0.169 pd=1.82 as=0.08775 ps=0.92 w=0.65 l=0.15
X5830 sar9b_0.net37 a_14143_18874# VGND VGND sky130_fd_pr__nfet_01v8 ad=0.169 pd=1.82 as=0.2087 ps=2.02 w=0.65 l=0.15
X5831 th_dif_sw_0.VCP single_9b_cdac_1.cdac_sw_9b_0.S[0] sky130_fd_pr__cap_mim_m3_1 l=2 w=2
C0 ua[0] single_9b_cdac_0.cdac_sw_9b_0.cdac_sw_3_3.tg_sw_3_3.SWN 3.10217f
C1 a_13308_19988# sar9b_0.net1 0.15828f
C2 a_10477_19450# sar9b_0.net15 0.07008f
C3 uio_out[1] VDPWR 1.00719f
C4 a_6516_26516# sar9b_0.net35 0.01821f
C5 a_7795_26276# sar9b_0.net38 0.07515f
C6 a_7620_26350# a_6539_25978# 0.10232f
C7 sar9b_0._10_ sar9b_0.net36 0.65197f
C8 a_10935_23618# VDPWR 0.1435f
C9 single_9b_cdac_1.SW[0] single_9b_cdac_1.SW[5] 0.02184f
C10 a_8895_24340# sar9b_0.net35 0.01137f
C11 single_9b_cdac_1.SW[0] single_9b_cdac_1.SW[3] 0.02237f
C12 VDPWR single_9b_cdac_1.cdac_sw_9b_0.cdac_sw_3_8.nooverlap_clk_0.sky130_fd_sc_hs__inv_1_1.A 0.38716f
C13 a_16185_13034# tdc_0.phase_detector_0.pd_out_0.A 0.02054f
C14 a_9167_18874# sar9b_0.net35 0.07179f
C15 single_9b_cdac_1.cdac_sw_9b_0.cdac_sw_3_1.tg_sw_3_3.SWP a_57946_16877# 0.04592f
C16 single_9b_cdac_0.cdac_sw_9b_0.cdac_sw_3_2.nooverlap_clk_0.x10.A single_9b_cdac_0.cdac_sw_9b_0.cdac_sw_3_2.nooverlap_clk_0.sky130_fd_sc_hs__inv_8_0.A 0.05105f
C17 a_11691_25978# sar9b_0.FINAL 0.33573f
C18 sar9b_0.net15 a_10955_18900# 0.32626f
C19 sar9b_0.net15 a_9670_22708# 0.02136f
C20 VDPWR single_9b_cdac_0.cdac_sw_9b_0.cdac_sw_3_4.nooverlap_clk_0.x3.Y 0.3196f
C21 a_14143_21050# a_14451_20532# 0.01246f
C22 VDPWR a_21177_7457# 1.54446f
C23 VDPWR a_8358_23796# 0.25292f
C24 a_10955_23802# sar9b_0.net13 0.49075f
C25 sar9b_0.net11 sar9b_0.net31 0.02275f
C26 clk a_15265_9613# 0.01191f
C27 single_9b_cdac_0.SW[5] single_9b_cdac_0.SW[7] 0.09374f
C28 single_9b_cdac_0.SW[0] single_9b_cdac_1.CF[6] 0.78994f
C29 sar9b_0.net41 sar9b_0.net5 0.02001f
C30 a_12887_21076# a_13899_20532# 0.01008f
C31 a_40321_29917# single_9b_cdac_0.cdac_sw_9b_0.cdac_sw_3_5.nooverlap_clk_0.x4.A 0.01076f
C32 single_9b_cdac_0.cdac_sw_9b_0.cdac_sw_3_0.tg_sw_3_3.SWN single_9b_cdac_0.cdac_sw_9b_0.cdac_sw_3_4.nooverlap_clk_0.CLKB0 0.01134f
C33 sar9b_0.net3 sar9b_0.FINAL 1.30377f
C34 sar9b_0.clk_div_0.COUNT\[2\] a_7203_22682# 0.17333f
C35 ui_in[0] ui_in[1] 0.03102f
C36 a_6691_26490# a_6516_26516# 0.23366f
C37 single_9b_cdac_0.SW[2] single_9b_cdac_0.SW[1] 16.494f
C38 a_12887_21076# sar9b_0.net8 0.03632f
C39 sar9b_0.net7 a_12036_18900# 0.02545f
C40 a_11045_24858# sar9b_0.net15 0.16916f
C41 a_11121_18900# a_12036_18900# 0.12532f
C42 a_13621_26758# a_13968_26516# 0.05116f
C43 sar9b_0._07_ sar9b_0._08_ 0.22298f
C44 a_12425_25946# a_12772_26350# 0.05116f
C45 a_8545_24340# a_9635_24314# 0.04242f
C46 a_9113_24582# a_8895_24340# 0.20964f
C47 sar9b_0.FINAL sar9b_0.net19 0.09962f
C48 a_11689_21318# a_12036_21076# 0.05116f
C49 a_11121_21076# a_11376_21076# 0.06418f
C50 sar9b_0.net28 single_9b_cdac_1.CF[2] 0.14485f
C51 a_6701_20506# sar9b_0.net15 0.0575f
C52 single_9b_cdac_0.cdac_sw_9b_0.cdac_sw_3_3.nooverlap_clk_0.x8.A single_9b_cdac_0.cdac_sw_9b_0.cdac_sw_3_3.nooverlap_clk_0.sky130_fd_sc_hs__inv_1_1.A 0.08121f
C53 sar9b_0.net26 sar9b_0.net30 0.61255f
C54 sar9b_0.net37 sar9b_0._07_ 0.21744f
C55 uo_out[7] uio_out[0] 2.91263f
C56 a_6171_22714# sar9b_0._04_ 0.13548f
C57 a_6651_23520# a_5785_23252# 0.03405f
C58 a_10482_3438# th_dif_sw_0.th_sw_1.th_sw_main_0.VGS 1.63339f
C59 single_9b_cdac_1.cdac_sw_9b_0.cdac_sw_3_0.tg_sw_3_3.SWP single_9b_cdac_1.CF[3] 0.18989f
C60 a_9535_19962# a_9738_20240# 0.23366f
C61 VDPWR single_9b_cdac_1.cdac_sw_9b_0.cdac_sw_3_0.nooverlap_clk_0.x3.Y 0.3196f
C62 tdc_0.OUTP tdc_0.phase_detector_0.pd_out_0.B 0.36961f
C63 a_10771_22164# a_10937_22164# 0.60618f
C64 sar9b_0.net41 sar9b_0.net38 0.28951f
C65 single_9b_cdac_1.cdac_sw_9b_0.cdac_sw_3_5.nooverlap_clk_0.x1.A single_9b_cdac_1.cdac_sw_9b_0.cdac_sw_3_5.nooverlap_clk_0.x6.A 0.03729f
C66 ua[0] single_9b_cdac_1.cdac_sw_9b_0.cdac_sw_3_0.nooverlap_clk_0.CLKB0 0.12378f
C67 single_9b_cdac_0.SW[0] single_9b_cdac_1.CF[7] 1.15425f
C68 a_13511_22708# a_13053_22714# 0.03462f
C69 a_10827_23252# sar9b_0.net2 0.06401f
C70 uo_out[0] th_dif_sw_0.VCN 0.10947f
C71 single_9b_cdac_1.cdac_sw_9b_0.cdac_sw_3_3.tg_sw_3_3.SWP single_9b_cdac_1.CF[5] 0.19147f
C72 a_13308_21076# VDPWR 0.07761f
C73 a_11567_25188# sar9b_0.net11 0.05369f
C74 a_11965_20506# sar9b_0.net7 0.06216f
C75 single_9b_cdac_0.cdac_sw_9b_0.cdac_sw_3_5.nooverlap_clk_0.sky130_fd_sc_hs__inv_1_1.A VDPWR 0.38716f
C76 single_9b_cdac_0.cdac_sw_9b_0.cdac_sw_3_5.tg_sw_3_3.SWP VDPWR 3.27795f
C77 sar9b_0.net15 a_13621_22682# 0.17823f
C78 a_8431_22682# a_8634_22840# 0.23366f
C79 sar9b_0.net37 sar9b_0.net7 0.02676f
C80 a_12795_23802# a_12961_23802# 0.85445f
C81 a_12887_21076# VDPWR 0.45936f
C82 sar9b_0.net4 a_11121_18900# 0.0128f
C83 a_10845_25428# sar9b_0.net13 0.73904f
C84 a_9115_26516# sar9b_0.FINAL 0.4974f
C85 a_10055_20130# a_10774_20354# 0.08594f
C86 a_10211_20225# a_10356_20354# 0.05722f
C87 sar9b_0.net15 single_9b_cdac_1.SW[4] 0.05722f
C88 a_10016_20256# sar9b_0.net2 0.21722f
C89 single_9b_cdac_1.cdac_sw_9b_0.S[8] VDPWR 4.16512f
C90 a_7919_23802# a_8526_23770# 0.14145f
C91 single_9b_cdac_0.cdac_sw_9b_0.cdac_sw_3_8.tg_sw_3_3.SWP single_9b_cdac_0.cdac_sw_9b_0.cdac_sw_3_8.nooverlap_clk_0.CLKB0 1.71649f
C92 sar9b_0.net15 single_9b_cdac_1.SW[2] 0.17671f
C93 a_6930_20241# sar9b_0.clknet_1_0__leaf_CLK 0.09586f
C94 single_9b_cdac_0.cdac_sw_9b_0.cdac_sw_3_1.nooverlap_clk_0.x8.A VDPWR 0.84061f
C95 a_13053_18900# a_13403_18900# 0.22382f
C96 a_12887_18900# a_14143_18874# 0.04357f
C97 a_12225_18362# sar9b_0.net35 0.55416f
C98 a_11689_23770# a_11579_23796# 0.09774f
C99 single_9b_cdac_1.cdac_sw_9b_0.cdac_sw_3_4.nooverlap_clk_0.x10.A single_9b_cdac_1.cdac_sw_9b_0.cdac_sw_3_4.nooverlap_clk_0.sky130_fd_sc_hs__inv_8_0.A 0.05105f
C100 a_11395_22530# a_11505_22406# 0.09774f
C101 single_9b_cdac_1.SW[8] a_25210_17740# 0.18991f
C102 single_9b_cdac_0.SW[8] a_24332_26999# 0.28324f
C103 single_9b_cdac_1.CF[4] single_9b_cdac_1.cdac_sw_9b_0.cdac_sw_3_3.nooverlap_clk_0.x3.Y 0.12898f
C104 a_6674_21050# sar9b_0._09_ 0.09633f
C105 a_11691_25978# VDPWR 0.50561f
C106 sar9b_0.net40 a_13623_21620# 0.03306f
C107 a_8543_27060# a_8653_27034# 0.09774f
C108 sar9b_0.net5 a_13347_21620# 0.18925f
C109 single_9b_cdac_1.cdac_sw_9b_0.cdac_sw_3_3.tg_sw_3_3.SWN single_9b_cdac_1.CF[5] 0.03484f
C110 single_9b_cdac_1.cdac_sw_9b_0.cdac_sw_3_6.tg_sw_3_3.SWN single_9b_cdac_1.cdac_sw_9b_0.cdac_sw_3_7.nooverlap_clk_0.CLKB0 0.01175f
C111 sar9b_0.net42 sar9b_0.net10 0.02492f
C112 a_9543_19748# sar9b_0.net5 0.06101f
C113 a_11287_22164# sar9b_0.net9 0.03367f
C114 a_7055_26350# VDPWR 0.20487f
C115 single_9b_cdac_0.cdac_sw_9b_0.cdac_sw_3_0.nooverlap_clk_0.sky130_fd_sc_hs__inv_8_0.A single_9b_cdac_0.cdac_sw_9b_0.cdac_sw_3_0.nooverlap_clk_0.x10.A 0.05105f
C116 single_9b_cdac_1.cdac_sw_9b_0.cdac_sw_3_4.nooverlap_clk_0.sky130_fd_sc_hs__nand2_1_0.Y single_9b_cdac_1.CF[3] 0.17948f
C117 single_9b_cdac_1.cdac_sw_9b_0.cdac_sw_3_2.nooverlap_clk_0.CLK0 single_9b_cdac_1.CF[0] 0.42014f
C118 sar9b_0.net15 sar9b_0.FINAL 0.44411f
C119 single_9b_cdac_1.CF[8] sar9b_0.net30 0.14153f
C120 a_12887_19988# sar9b_0.net5 0.03327f
C121 VDPWR a_7273_25946# 0.20793f
C122 single_9b_cdac_1.cdac_sw_9b_0.cdac_sw_3_7.nooverlap_clk_0.x8.A single_9b_cdac_1.cdac_sw_9b_0.cdac_sw_3_7.nooverlap_clk_0.sky130_fd_sc_hs__inv_8_0.A 0.04988f
C123 a_7363_23502# sar9b_0.clk_div_0.COUNT\[1\] 0.05117f
C124 sar9b_0.net3 VDPWR 6.11396f
C125 a_6308_27060# a_5968_27176# 0.02958f
C126 sar9b_0.net41 a_13623_20532# 0.0319f
C127 single_9b_cdac_1.cdac_sw_9b_0.cdac_sw_3_7.nooverlap_clk_0.sky130_fd_sc_hs__nand2_1_0.Y a_31753_15501# 0.01076f
C128 ua[0] single_9b_cdac_1.cdac_sw_9b_0.cdac_sw_3_1.nooverlap_clk_0.CLKB0 0.1236f
C129 ua[1] th_dif_sw_0.th_sw_1.CKB 0.08416f
C130 sar9b_0.net15 a_9038_22708# 0.16666f
C131 a_13053_24890# a_13511_24884# 0.02761f
C132 sar9b_0.net37 a_6224_25428# 0.17266f
C133 uio_out[1] sar9b_0.net36 0.12107f
C134 VDPWR sar9b_0.net19 0.57113f
C135 single_9b_cdac_0.SW[6] single_9b_cdac_0.SW[8] 0.24974f
C136 a_6059_26882# a_5601_26516# 0.03462f
C137 single_9b_cdac_1.cdac_sw_9b_0.cdac_sw_3_6.nooverlap_clk_0.x1.A single_9b_cdac_1.cdac_sw_9b_0.cdac_sw_3_6.nooverlap_clk_0.sky130_fd_sc_hs__inv_8_0.A 0.45521f
C138 uio_out[0] uio_out[1] 2.96207f
C139 single_9b_cdac_1.cdac_sw_9b_0.S[0] single_9b_cdac_1.cdac_sw_9b_0.cdac_sw_3_2.tg_sw_3_3.SWN 0.84426f
C140 a_9849_26758# a_10196_26516# 0.05116f
C141 single_9b_cdac_0.cdac_sw_9b_0.S[8] single_9b_cdac_0.cdac_sw_9b_0.S[7] 16.5515f
C142 dw_17224_1400# th_dif_sw_0.CKB 0.01764f
C143 VDPWR single_9b_cdac_0.cdac_sw_9b_0.cdac_sw_3_7.nooverlap_clk_0.x1.A 0.75853f
C144 single_9b_cdac_0.SW[4] single_9b_cdac_0.SW[8] 0.04309f
C145 single_9b_cdac_1.cdac_sw_9b_0.cdac_sw_3_2.nooverlap_clk_0.x1.A single_9b_cdac_1.cdac_sw_9b_0.cdac_sw_3_2.nooverlap_clk_0.x3.Y 0.07579f
C146 a_9543_19748# sar9b_0.net38 0.05198f
C147 single_9b_cdac_0.SW[5] single_9b_cdac_1.CF[5] 1.8421f
C148 sar9b_0.net15 sar9b_0.net8 0.94241f
C149 sar9b_0.net11 sar9b_0.net43 0.03103f
C150 single_9b_cdac_1.cdac_sw_9b_0.cdac_sw_3_6.nooverlap_clk_0.x8.A single_9b_cdac_1.cdac_sw_9b_0.cdac_sw_3_6.nooverlap_clk_0.sky130_fd_sc_hs__inv_1_1.A 0.08121f
C151 single_9b_cdac_1.CF[6] single_9b_cdac_0.cdac_sw_9b_0.cdac_sw_3_6.tg_sw_3_3.SWP 0.10499f
C152 a_12887_19988# sar9b_0.net38 0.0208f
C153 VDPWR a_6778_22682# 0.17693f
C154 single_9b_cdac_1.cdac_sw_9b_0.cdac_sw_3_2.nooverlap_clk_0.x10.A single_9b_cdac_1.cdac_sw_9b_0.cdac_sw_3_2.nooverlap_clk_0.x8.A 0.42509f
C155 single_9b_cdac_1.CF[4] single_9b_cdac_1.cdac_sw_9b_0.cdac_sw_3_4.tg_sw_3_3.SWP 0.19129f
C156 sar9b_0.net15 a_9003_24706# 0.0122f
C157 sar9b_0.net30 single_9b_cdac_1.CF[6] 0.0362f
C158 single_9b_cdac_1.cdac_sw_9b_0.cdac_sw_3_0.nooverlap_clk_0.x8.A single_9b_cdac_1.cdac_sw_9b_0.cdac_sw_3_0.nooverlap_clk_0.x6.A 0.11216f
C159 single_9b_cdac_0.cdac_sw_9b_0.cdac_sw_3_2.tg_sw_3_3.SWP single_9b_cdac_1.CF[1] 0.19143f
C160 single_9b_cdac_1.cdac_sw_9b_0.cdac_sw_3_6.nooverlap_clk_0.x10.A VDPWR 0.95338f
C161 single_9b_cdac_0.cdac_sw_9b_0.cdac_sw_3_0.tg_sw_3_3.SWN single_9b_cdac_1.CF[3] 0.03436f
C162 a_10311_17812# sar9b_0.net1 0.16669f
C163 sar9b_0.net35 a_7345_21594# 0.0378f
C164 VDPWR a_9115_26516# 0.48513f
C165 a_8637_23252# a_9727_23226# 0.04242f
C166 a_8471_23252# a_9552_23252# 0.10236f
C167 a_9205_23494# a_8987_23252# 0.20964f
C168 sar9b_0.net28 single_9b_cdac_1.CF[0] 0.04632f
C169 single_9b_cdac_1.cdac_sw_9b_0.S[5] single_9b_cdac_1.cdac_sw_9b_0.S[7] 1.05598f
C170 ua[0] single_9b_cdac_1.cdac_sw_9b_0.cdac_sw_3_1.nooverlap_clk_0.CLK0 0.12077f
C171 sar9b_0.clk_div_0.COUNT\[0\] sar9b_0.clknet_1_1__leaf_CLK 0.31279f
C172 a_8471_20538# sar9b_0.net35 0.04269f
C173 VDPWR a_12027_22138# 0.3914f
C174 a_9739_21442# VDPWR 0.14223f
C175 a_9648_19168# a_9687_19042# 0.89706f
C176 single_9b_cdac_1.cdac_sw_9b_0.cdac_sw_3_4.nooverlap_clk_0.x8.A single_9b_cdac_1.cdac_sw_9b_0.cdac_sw_3_4.nooverlap_clk_0.sky130_fd_sc_hs__inv_1_1.A 0.08121f
C177 single_9b_cdac_1.cdac_sw_9b_0.cdac_sw_3_6.nooverlap_clk_0.x8.A VDPWR 0.84061f
C178 single_9b_cdac_1.SW[6] clk 0.08297f
C179 a_13968_25428# sar9b_0.net33 0.05539f
C180 single_9b_cdac_0.cdac_sw_9b_0.cdac_sw_3_6.nooverlap_clk_0.CLK0 single_9b_cdac_0.cdac_sw_9b_0.cdac_sw_3_7.nooverlap_clk_0.CLK0 0.02632f
C181 single_9b_cdac_1.CF[2] single_9b_cdac_1.cdac_sw_9b_0.cdac_sw_3_0.nooverlap_clk_0.x8.A 0.31534f
C182 sar9b_0._04_ sar9b_0._12_ 0.03488f
C183 sar9b_0.net4 sar9b_0.net9 0.27266f
C184 a_13347_20532# sar9b_0.net6 0.01489f
C185 a_13857_27279# sar9b_0.net25 0.22635f
C186 a_13623_23252# single_9b_cdac_1.CF[5] 0.11082f
C187 sar9b_0.net15 VDPWR 12.2828f
C188 single_9b_cdac_1.CF[7] single_9b_cdac_0.cdac_sw_9b_0.cdac_sw_3_6.tg_sw_3_3.SWP 0.19143f
C189 a_13403_25428# sar9b_0.FINAL 0.03536f
C190 VDPWR single_9b_cdac_0.cdac_sw_9b_0.cdac_sw_3_0.tg_sw_3_3.SWP 3.27788f
C191 a_5870_19566# a_6417_19822# 0.10164f
C192 single_9b_cdac_1.CF[7] sar9b_0.net30 0.03153f
C193 single_9b_cdac_0.cdac_sw_9b_0.cdac_sw_3_6.nooverlap_clk_0.CLK0 single_9b_cdac_0.cdac_sw_9b_0.cdac_sw_3_5.nooverlap_clk_0.CLK0 0.02632f
C194 single_9b_cdac_1.cdac_sw_9b_0.cdac_sw_3_2.nooverlap_clk_0.CLKB0 single_9b_cdac_1.cdac_sw_9b_0.cdac_sw_3_1.nooverlap_clk_0.CLKB0 0.02632f
C195 a_13621_21318# a_12887_21076# 0.07009f
C196 a_8085_27066# a_9000_27438# 0.12532f
C197 clk rst_n 0.03102f
C198 a_7145_23226# sar9b_0.clk_div_0.COUNT\[0\] 0.112f
C199 VDPWR single_9b_cdac_1.cdac_sw_9b_0.cdac_sw_3_2.nooverlap_clk_0.x1.A 0.74663f
C200 a_13403_25262# sar9b_0.net15 0.16891f
C201 a_11747_20910# sar9b_0.net8 0.03568f
C202 single_9b_cdac_1.cdac_sw_9b_0.cdac_sw_3_2.nooverlap_clk_0.CLK0 a_63626_17740# 0.14695f
C203 a_11392_19822# sar9b_0.net15 0.24757f
C204 sar9b_0.net39 a_12947_26276# 0.02144f
C205 single_9b_cdac_0.cdac_sw_9b_0.cdac_sw_3_4.tg_sw_3_3.SWN single_9b_cdac_0.cdac_sw_9b_0.cdac_sw_3_3.nooverlap_clk_0.CLKB0 0.0115f
C206 single_9b_cdac_1.cdac_sw_9b_0.cdac_sw_3_0.tg_sw_3_3.SWN single_9b_cdac_1.CF[3] 0.03433f
C207 sar9b_0.net2 a_9727_23226# 0.08295f
C208 single_9b_cdac_0.cdac_sw_9b_0.cdac_sw_3_7.nooverlap_clk_0.x4.A single_9b_cdac_0.cdac_sw_9b_0.cdac_sw_3_7.nooverlap_clk_0.x6.A 0.12431f
C209 single_9b_cdac_0.cdac_sw_9b_0.cdac_sw_3_4.nooverlap_clk_0.x1.A single_9b_cdac_0.cdac_sw_9b_0.cdac_sw_3_4.nooverlap_clk_0.x3.Y 0.07579f
C210 sar9b_0._06_ sar9b_0._14_ 0.0139f
C211 a_10955_23802# a_11471_24174# 0.11053f
C212 a_8931_22164# sar9b_0.net35 0.01443f
C213 a_21368_4076# a_21684_3438# 0.61926f
C214 a_12059_18362# a_12225_18362# 0.63478f
C215 VDPWR single_9b_cdac_0.cdac_sw_9b_0.cdac_sw_3_5.nooverlap_clk_0.x1.A 0.75853f
C216 single_9b_cdac_1.cdac_sw_9b_0.cdac_sw_3_0.nooverlap_clk_0.x10.A single_9b_cdac_1.cdac_sw_9b_0.cdac_sw_3_0.nooverlap_clk_0.x1.A 0.05472f
C217 single_9b_cdac_0.SW[0] VDPWR 2.35302f
C218 a_5968_27176# sar9b_0.FINAL 0.39233f
C219 sar9b_0.net4 a_10935_19444# 0.02436f
C220 sar9b_0.clk_div_0.COUNT\[2\] sar9b_0.clknet_0_CLK 0.11171f
C221 a_12961_23802# sar9b_0.net39 0.03441f
C222 a_9003_25972# sar9b_0.net3 0.0122f
C223 single_9b_cdac_1.cdac_sw_9b_0.cdac_sw_3_2.nooverlap_clk_0.x8.A single_9b_cdac_1.cdac_sw_9b_0.cdac_sw_3_2.nooverlap_clk_0.x4.A 0.0303f
C224 single_9b_cdac_0.cdac_sw_9b_0.cdac_sw_3_0.nooverlap_clk_0.x6.A single_9b_cdac_0.cdac_sw_9b_0.cdac_sw_3_0.nooverlap_clk_0.x4.A 0.12431f
C225 single_9b_cdac_1.cdac_sw_9b_0.cdac_sw_3_8.nooverlap_clk_0.x6.A single_9b_cdac_1.cdac_sw_9b_0.cdac_sw_3_8.nooverlap_clk_0.x4.A 0.12431f
C226 single_9b_cdac_1.CF[3] a_14143_22138# 0.03403f
C227 a_10142_20354# sar9b_0.net41 0.03705f
C228 sar9b_0.net35 a_8951_22950# 0.01918f
C229 a_12793_18330# sar9b_0.net2 0.05614f
C230 a_6337_22714# a_6610_22708# 0.07855f
C231 single_9b_cdac_1.cdac_sw_9b_0.cdac_sw_3_8.nooverlap_clk_0.x1.A single_9b_cdac_1.cdac_sw_9b_0.cdac_sw_3_8.nooverlap_clk_0.x4.A 0.28523f
C232 single_9b_cdac_0.cdac_sw_9b_0.S[4] single_9b_cdac_0.cdac_sw_9b_0.S[8] 1.41363f
C233 VDPWR a_13968_18900# 0.29f
C234 sar9b_0.net3 sar9b_0.net36 0.03958f
C235 single_9b_cdac_0.cdac_sw_9b_0.cdac_sw_3_8.nooverlap_clk_0.x4.A single_9b_cdac_0.cdac_sw_9b_0.cdac_sw_3_8.nooverlap_clk_0.sky130_fd_sc_hs__nand2_1_0.Y 0.01751f
C236 single_9b_cdac_1.SW[7] single_9b_cdac_1.cdac_sw_9b_0.S[7] 0.22983f
C237 uio_out[0] sar9b_0.net3 0.10718f
C238 a_13621_22682# a_13621_22406# 0.01249f
C239 a_14175_18356# sar9b_0.net35 0.19125f
C240 single_9b_cdac_1.cdac_sw_9b_0.cdac_sw_3_5.nooverlap_clk_0.CLKB0 single_9b_cdac_1.cdac_sw_9b_0.cdac_sw_3_6.nooverlap_clk_0.CLKB0 0.02632f
C241 a_8803_19822# VDPWR 0.21634f
C242 single_9b_cdac_1.cdac_sw_9b_0.cdac_sw_3_1.nooverlap_clk_0.x10.A VDPWR 0.95338f
C243 a_11471_26516# a_11376_26516# 0.04983f
C244 single_9b_cdac_1.CF[4] single_9b_cdac_0.SW[3] 0.05403f
C245 a_12211_26490# a_12036_26516# 0.23366f
C246 a_11689_26758# a_11579_26882# 0.09774f
C247 single_9b_cdac_0.SW[7] a_30012_26990# 0.18991f
C248 a_11747_20910# VDPWR 0.21521f
C249 single_9b_cdac_0.cdac_sw_9b_0.cdac_sw_3_5.tg_sw_3_3.SWN single_9b_cdac_0.cdac_sw_9b_0.cdac_sw_3_5.tg_sw_3_3.SWP 3.10626f
C250 single_9b_cdac_1.CF[5] single_9b_cdac_1.SW[5] 1.95851f
C251 ua[0] single_9b_cdac_1.cdac_sw_9b_0.cdac_sw_3_7.nooverlap_clk_0.CLKB0 0.1236f
C252 a_13621_19418# a_13621_19142# 0.01249f
C253 a_9113_25946# sar9b_0.net3 0.15943f
C254 single_9b_cdac_1.CF[5] single_9b_cdac_1.SW[3] 0.0149f
C255 single_9b_cdac_1.cdac_sw_9b_0.S[7] single_9b_cdac_1.cdac_sw_9b_0.S[0] 0.2766f
C256 a_54737_29917# single_9b_cdac_0.cdac_sw_9b_0.cdac_sw_3_0.nooverlap_clk_0.x4.A 0.01076f
C257 a_5601_26516# sar9b_0.FINAL 0.47521f
C258 ua[0] single_9b_cdac_1.cdac_sw_9b_0.cdac_sw_3_3.tg_sw_3_3.SWP 1.1512f
C259 single_9b_cdac_0.cdac_sw_9b_0.cdac_sw_3_5.tg_sw_3_3.SWP single_9b_cdac_0.cdac_sw_9b_0.S[5] 1.56015f
C260 a_14175_21620# single_9b_cdac_1.CF[2] 0.11339f
C261 single_9b_cdac_1.cdac_sw_9b_0.S[6] single_9b_cdac_1.cdac_sw_9b_0.S[8] 1.18098f
C262 clk single_9b_cdac_0.SW[3] 0.0837f
C263 single_9b_cdac_0.cdac_sw_9b_0.cdac_sw_3_3.nooverlap_clk_0.x1.A single_9b_cdac_0.cdac_sw_9b_0.cdac_sw_3_3.nooverlap_clk_0.sky130_fd_sc_hs__inv_1_1.A 0.10429f
C264 a_5977_22708# VDPWR 0.01166f
C265 sar9b_0._13_ a_7039_22138# 0.02207f
C266 a_13403_25428# VDPWR 0.19334f
C267 a_14143_25402# single_9b_cdac_0.SW[5] 0.03389f
C268 single_9b_cdac_0.cdac_sw_9b_0.cdac_sw_3_2.tg_sw_3_3.SWN single_9b_cdac_1.CF[0] 0.12358f
C269 single_9b_cdac_1.CF[4] a_14451_21620# 0.11122f
C270 a_13308_19988# sar9b_0.net6 0.0142f
C271 sar9b_0.net40 single_9b_cdac_1.CF[0] 0.05028f
C272 sar9b_0.net41 single_9b_cdac_1.SW[5] 0.06691f
C273 VDPWR single_9b_cdac_0.cdac_sw_9b_0.cdac_sw_3_3.nooverlap_clk_0.x3.Y 0.3196f
C274 a_10311_24890# a_11392_25262# 0.10236f
C275 sar9b_0.net8 a_11652_20898# 0.02486f
C276 sar9b_0.net42 a_14451_20532# 0.20536f
C277 sar9b_0.net41 single_9b_cdac_1.SW[3] 0.02402f
C278 ua[0] single_9b_cdac_1.cdac_sw_9b_0.cdac_sw_3_4.tg_sw_3_3.SWN 3.10207f
C279 a_13053_22164# sar9b_0.net9 0.16487f
C280 a_13621_20230# a_13968_19988# 0.05116f
C281 a_13053_19988# a_13308_19988# 0.05639f
C282 a_13403_25428# a_13403_25262# 0.01481f
C283 ua[0] single_9b_cdac_1.cdac_sw_9b_0.cdac_sw_3_3.tg_sw_3_3.SWN 3.10214f
C284 single_9b_cdac_1.CF[1] single_9b_cdac_1.cdac_sw_9b_0.cdac_sw_3_1.tg_sw_3_3.SWP 0.10499f
C285 single_9b_cdac_0.cdac_sw_9b_0.cdac_sw_3_3.nooverlap_clk_0.x8.A single_9b_cdac_0.cdac_sw_9b_0.cdac_sw_3_3.nooverlap_clk_0.x4.A 0.0303f
C286 VDPWR a_9809_27279# 0.22404f
C287 a_13623_21620# sar9b_0.net39 0.01101f
C288 single_9b_cdac_1.CF[7] single_9b_cdac_1.cdac_sw_9b_0.cdac_sw_3_7.nooverlap_clk_0.x4.A 0.0313f
C289 single_9b_cdac_1.SW[6] a_33936_16877# 0.28324f
C290 sar9b_0.net11 a_8085_23802# 0.05015f
C291 a_10732_23252# sar9b_0.net12 0.01476f
C292 single_9b_cdac_0.cdac_sw_9b_0.cdac_sw_3_0.nooverlap_clk_0.x10.A single_9b_cdac_0.cdac_sw_9b_0.cdac_sw_3_0.nooverlap_clk_0.x1.A 0.05472f
C293 a_13968_19822# single_9b_cdac_1.SW[2] 0.02093f
C294 a_9843_19137# a_9988_19266# 0.05722f
C295 a_9687_19042# a_10406_19266# 0.08561f
C296 single_9b_cdac_1.CF[7] single_9b_cdac_0.cdac_sw_9b_0.cdac_sw_3_7.nooverlap_clk_0.x4.A 0.0313f
C297 uo_out[6] sar9b_0.FINAL 0.146f
C298 a_10311_24890# sar9b_0.net12 0.17346f
C299 sar9b_0.net38 a_8471_23252# 0.02959f
C300 a_11471_21076# a_10955_21076# 0.10748f
C301 sar9b_0.FINAL sar9b_0.net1 0.04367f
C302 sar9b_0.net28 single_9b_cdac_1.CF[3] 0.12942f
C303 VDPWR a_5968_27176# 0.39814f
C304 a_13308_25428# a_13053_25428# 0.05562f
C305 a_13968_25428# a_13621_25670# 0.05116f
C306 a_13621_21318# sar9b_0.net15 0.18299f
C307 single_9b_cdac_1.cdac_sw_9b_0.cdac_sw_3_8.tg_sw_3_3.SWN single_9b_cdac_1.cdac_sw_9b_0.cdac_sw_3_8.nooverlap_clk_0.x10.A 0.69086f
C308 single_9b_cdac_0.cdac_sw_9b_0.cdac_sw_3_1.nooverlap_clk_0.x8.A single_9b_cdac_0.cdac_sw_9b_0.cdac_sw_3_1.nooverlap_clk_0.sky130_fd_sc_hs__inv_1_1.A 0.08121f
C309 single_9b_cdac_0.cdac_sw_9b_0.S[1] single_9b_cdac_0.cdac_sw_9b_0.S[7] 0.25258f
C310 single_9b_cdac_0.cdac_sw_9b_0.cdac_sw_3_5.tg_sw_3_3.SWP single_9b_cdac_0.SW[4] 0.01837f
C311 a_7039_22138# sar9b_0._09_ 0.01019f
C312 a_11045_23494# a_10827_23252# 0.20964f
C313 a_10477_23252# a_11567_23226# 0.04242f
C314 a_10311_23252# a_11392_23252# 0.10232f
C315 sar9b_0.net15 sar9b_0.net36 0.55219f
C316 single_9b_cdac_0.cdac_sw_9b_0.cdac_sw_3_3.nooverlap_clk_0.sky130_fd_sc_hs__inv_1_1.A single_9b_cdac_0.cdac_sw_9b_0.cdac_sw_3_3.nooverlap_clk_0.sky130_fd_sc_hs__nand2_1_0.Y 0.12223f
C317 sar9b_0.net29 single_9b_cdac_1.CF[3] 0.09215f
C318 single_9b_cdac_0.cdac_sw_9b_0.cdac_sw_3_4.nooverlap_clk_0.CLK0 VDPWR 2.71729f
C319 single_9b_cdac_0.cdac_sw_9b_0.cdac_sw_3_6.nooverlap_clk_0.CLK0 single_9b_cdac_0.cdac_sw_9b_0.S[6] 0.26427f
C320 single_9b_cdac_0.SW[2] single_9b_cdac_0.cdac_sw_9b_0.S[2] 0.22543f
C321 VDPWR a_11652_20898# 0.07893f
C322 ua[0] single_9b_cdac_0.SW[5] 0.1911f
C323 single_9b_cdac_1.CF[8] single_9b_cdac_1.cdac_sw_9b_0.cdac_sw_3_8.nooverlap_clk_0.x10.A 0.02149f
C324 sar9b_0.clk_div_0.COUNT\[3\] sar9b_0.net3 0.02987f
C325 single_9b_cdac_1.CF[4] single_9b_cdac_1.CF[2] 0.05938f
C326 a_12887_25428# sar9b_0.net39 0.0314f
C327 a_9687_19042# sar9b_0.net5 0.25955f
C328 VDPWR single_9b_cdac_0.cdac_sw_9b_0.cdac_sw_3_2.nooverlap_clk_0.x1.A 0.74663f
C329 single_9b_cdac_0.cdac_sw_9b_0.cdac_sw_3_4.nooverlap_clk_0.x10.A single_9b_cdac_0.cdac_sw_9b_0.cdac_sw_3_4.nooverlap_clk_0.sky130_fd_sc_hs__inv_8_0.A 0.05105f
C330 single_9b_cdac_0.cdac_sw_9b_0.cdac_sw_3_4.nooverlap_clk_0.x8.A single_9b_cdac_0.cdac_sw_9b_0.cdac_sw_3_4.nooverlap_clk_0.sky130_fd_sc_hs__inv_1_1.A 0.08121f
C331 single_9b_cdac_0.cdac_sw_9b_0.cdac_sw_3_0.nooverlap_clk_0.x10.A VDPWR 0.95338f
C332 VDPWR a_5601_26516# 0.55386f
C333 single_9b_cdac_0.cdac_sw_9b_0.cdac_sw_3_4.nooverlap_clk_0.sky130_fd_sc_hs__nand2_1_0.Y VDPWR 0.62538f
C334 sar9b_0.net8 sar9b_0.net1 0.65606f
C335 single_9b_cdac_0.SW[7] single_9b_cdac_0.cdac_sw_9b_0.S[7] 0.22983f
C336 VDPWR single_9b_cdac_0.cdac_sw_9b_0.cdac_sw_3_6.tg_sw_3_3.SWP 3.27795f
C337 clk single_9b_cdac_1.CF[2] 0.08196f
C338 single_9b_cdac_1.cdac_sw_9b_0.cdac_sw_3_5.tg_sw_3_3.SWN single_9b_cdac_1.CF[6] 0.03484f
C339 sar9b_0.net30 VDPWR 0.74761f
C340 a_6343_20354# VDPWR 0.24548f
C341 sar9b_0.net21 a_9175_27364# 0.06871f
C342 VDPWR a_13621_22406# 0.20426f
C343 single_9b_cdac_0.cdac_sw_9b_0.cdac_sw_3_5.nooverlap_clk_0.CLKB0 single_9b_cdac_1.CF[5] 0.26707f
C344 single_9b_cdac_0.cdac_sw_9b_0.S[4] a_44418_26990# 0.22513f
C345 a_9021_19418# a_8911_19444# 0.09774f
C346 a_6061_19988# sar9b_0._00_ 0.04101f
C347 single_9b_cdac_0.SW[3] a_48343_26999# 0.28324f
C348 a_9097_22164# sar9b_0.net2 0.28914f
C349 a_13379_27398# sar9b_0.FINAL 0.15967f
C350 single_9b_cdac_1.cdac_sw_9b_0.cdac_sw_3_3.nooverlap_clk_0.x4.A a_45123_15495# 0.01076f
C351 a_6943_22316# sar9b_0.clk_div_0.COUNT\[1\] 0.11634f
C352 sar9b_0.net10 a_12027_22138# 0.14869f
C353 a_12887_19988# single_9b_cdac_1.SW[3] 0.03315f
C354 a_8911_19444# sar9b_0.net4 0.03332f
C355 tdc_0.OUTN a_10311_17812# 0.24244f
C356 single_9b_cdac_1.cdac_sw_9b_0.cdac_sw_3_4.nooverlap_clk_0.x10.A VDPWR 0.95338f
C357 a_13403_19822# a_13308_19810# 0.04983f
C358 a_5483_19676# a_5579_19676# 0.31086f
C359 sar9b_0.net28 a_14175_24340# 0.21323f
C360 a_6701_20506# sar9b_0._09_ 0.01025f
C361 sar9b_0.net15 a_10187_22138# 0.32633f
C362 a_11413_25670# a_11760_25428# 0.05116f
C363 a_11195_25428# a_11303_25794# 0.05722f
C364 a_5969_25428# a_6537_25670# 0.18639f
C365 a_6483_23618# sar9b_0.clknet_1_1__leaf_CLK 0.07212f
C366 a_9281_26516# a_9631_26516# 0.2194f
C367 sar9b_0.net15 sar9b_0.net10 1.18909f
C368 uo_out[6] VDPWR 1.00511f
C369 single_9b_cdac_0.cdac_sw_9b_0.cdac_sw_3_3.tg_sw_3_3.SWP single_9b_cdac_0.SW[3] 0.01382f
C370 a_14175_24340# sar9b_0.net29 0.03121f
C371 VDPWR sar9b_0.net1 4.43692f
C372 dw_17224_1400# a_18214_3039# 1.98311f
C373 sar9b_0.net40 a_13071_21620# 0.0299f
C374 th_dif_sw_0.th_sw_0.th_sw_main_0.VGS a_18214_3039# 1.33121f
C375 a_9849_21318# sar9b_0.net41 0.01335f
C376 single_9b_cdac_1.cdac_sw_9b_0.cdac_sw_3_4.nooverlap_clk_0.x8.A single_9b_cdac_1.CF[3] 0.31534f
C377 sar9b_0.net29 a_14451_24340# 0.19436f
C378 a_13968_19822# VDPWR 0.29079f
C379 single_9b_cdac_1.cdac_sw_9b_0.cdac_sw_3_8.nooverlap_clk_0.CLKB0 single_9b_cdac_1.cdac_sw_9b_0.cdac_sw_3_7.tg_sw_3_3.SWN 0.01175f
C380 single_9b_cdac_1.cdac_sw_9b_0.cdac_sw_3_5.nooverlap_clk_0.sky130_fd_sc_hs__nand2_1_0.Y single_9b_cdac_1.CF[5] 0.17948f
C381 single_9b_cdac_1.cdac_sw_9b_0.cdac_sw_3_7.nooverlap_clk_0.sky130_fd_sc_hs__inv_1_1.A single_9b_cdac_1.cdac_sw_9b_0.cdac_sw_3_7.nooverlap_clk_0.sky130_fd_sc_hs__nand2_1_0.Y 0.12223f
C382 a_9631_21076# a_9739_21442# 0.05722f
C383 a_6427_25794# sar9b_0.net3 0.01468f
C384 a_7055_26350# a_7163_25972# 0.05722f
C385 a_12315_25972# sar9b_0.net3 0.01228f
C386 single_9b_cdac_1.cdac_sw_9b_0.cdac_sw_3_6.nooverlap_clk_0.x1.A single_9b_cdac_1.CF[6] 0.06503f
C387 single_9b_cdac_1.cdac_sw_9b_0.cdac_sw_3_5.nooverlap_clk_0.x8.A single_9b_cdac_1.CF[5] 0.31534f
C388 sar9b_0.net15 single_9b_cdac_0.SW[6] 0.02162f
C389 single_9b_cdac_0.SW[2] single_9b_cdac_0.SW[3] 14.3476f
C390 a_7163_25972# a_7273_25946# 0.09774f
C391 sar9b_0.net15 sar9b_0.net31 0.02705f
C392 sar9b_0.net15 a_9631_21076# 0.15336f
C393 sar9b_0._04_ sar9b_0.clknet_1_1__leaf_CLK 0.17343f
C394 sar9b_0.net3 a_7163_25972# 0.01632f
C395 a_12887_19450# a_14143_19748# 0.04357f
C396 a_13053_19450# a_13403_19822# 0.2298f
C397 sar9b_0.clk_div_0.COUNT\[2\] sar9b_0.clk_div_0.COUNT\[1\] 0.10233f
C398 single_9b_cdac_0.cdac_sw_9b_0.cdac_sw_3_6.nooverlap_clk_0.x6.A VDPWR 0.38397f
C399 a_9535_19962# a_10055_20130# 0.04357f
C400 a_6343_20354# a_6249_19988# 0.03564f
C401 single_9b_cdac_0.cdac_sw_9b_0.S[4] single_9b_cdac_0.cdac_sw_9b_0.S[1] 0.31852f
C402 a_9738_20240# a_10016_20256# 0.11876f
C403 sar9b_0.net7 sar9b_0.net41 0.10949f
C404 sar9b_0._00_ a_5884_21326# 0.11f
C405 sar9b_0._02_ VDPWR 0.42323f
C406 sar9b_0.net18 sar9b_0.net35 0.18237f
C407 sar9b_0.net15 single_9b_cdac_0.SW[4] 0.01013f
C408 single_9b_cdac_1.cdac_sw_9b_0.cdac_sw_3_3.nooverlap_clk_0.CLK0 a_44418_17740# 0.14695f
C409 a_8379_25978# sar9b_0.net38 0.38835f
C410 single_9b_cdac_0.cdac_sw_9b_0.S[8] single_9b_cdac_0.cdac_sw_9b_0.cdac_sw_3_8.nooverlap_clk_0.CLKB0 0.3601f
C411 single_9b_cdac_1.cdac_sw_9b_0.cdac_sw_3_5.nooverlap_clk_0.CLK0 a_39616_17740# 0.14695f
C412 uio_out[0] a_5968_27176# 0.03521f
C413 single_9b_cdac_0.cdac_sw_9b_0.cdac_sw_3_2.nooverlap_clk_0.CLKB0 VDPWR 2.81139f
C414 single_9b_cdac_1.CF[4] th_dif_sw_0.VCN 0.09453f
C415 uo_out[4] uo_out[3] 3.00068f
C416 a_5343_25972# a_5945_26191# 0.01965f
C417 a_11649_27279# sar9b_0.net39 0.0248f
C418 ua[0] single_9b_cdac_1.SW[5] 0.13353f
C419 a_13379_27398# VDPWR 0.20244f
C420 single_9b_cdac_0.cdac_sw_9b_0.cdac_sw_3_7.nooverlap_clk_0.sky130_fd_sc_hs__inv_8_0.A single_9b_cdac_0.cdac_sw_9b_0.cdac_sw_3_7.nooverlap_clk_0.x8.A 0.04988f
C421 a_11691_25978# sar9b_0.net43 0.45167f
C422 a_49221_17740# single_9b_cdac_1.SW[3] 0.18991f
C423 ua[0] single_9b_cdac_1.SW[3] 0.14032f
C424 sar9b_0.net15 a_11689_19142# 0.1782f
C425 single_9b_cdac_1.cdac_sw_9b_0.cdac_sw_3_7.nooverlap_clk_0.CLK0 single_9b_cdac_1.cdac_sw_9b_0.cdac_sw_3_7.nooverlap_clk_0.CLKB0 2.7611f
C426 uio_in[2] uio_in[1] 0.03102f
C427 single_9b_cdac_0.SW[0] sar9b_0.net31 0.0182f
C428 sar9b_0.net3 a_8653_27034# 0.18157f
C429 single_9b_cdac_1.cdac_sw_9b_0.cdac_sw_3_7.nooverlap_clk_0.x4.A VDPWR 0.62443f
C430 a_10356_20354# VDPWR 0.13285f
C431 VDPWR a_8783_23796# 0.19267f
C432 a_5785_23252# sar9b_0.clknet_1_1__leaf_CLK 0.47366f
C433 clk th_dif_sw_0.VCN 2.07356f
C434 sar9b_0.net3 sar9b_0.net43 0.02479f
C435 a_13403_23086# single_9b_cdac_1.CF[5] 0.0109f
C436 single_9b_cdac_1.CF[4] single_9b_cdac_1.CF[0] 0.03691f
C437 single_9b_cdac_0.cdac_sw_9b_0.cdac_sw_3_0.nooverlap_clk_0.CLKB0 single_9b_cdac_0.cdac_sw_9b_0.cdac_sw_3_1.nooverlap_clk_0.CLKB0 0.02778f
C438 VDPWR single_9b_cdac_0.cdac_sw_9b_0.cdac_sw_3_7.nooverlap_clk_0.x4.A 0.62443f
C439 single_9b_cdac_0.cdac_sw_9b_0.cdac_sw_3_8.nooverlap_clk_0.CLK0 single_9b_cdac_0.cdac_sw_9b_0.cdac_sw_3_8.nooverlap_clk_0.CLKB0 2.7611f
C440 a_6691_26490# sar9b_0.net18 0.06295f
C441 a_11567_25188# sar9b_0.net15 0.3316f
C442 a_5435_26516# a_6169_26758# 0.05811f
C443 sar9b_0.net36 a_5601_26516# 0.22454f
C444 single_9b_cdac_0.SW[2] a_53154_26999# 0.28324f
C445 a_14143_26490# a_13968_26516# 0.23366f
C446 tdc_0.OUTN th_dif_sw_0.CK 0.07473f
C447 a_12947_26276# a_12772_26350# 0.23366f
C448 sar9b_0._15_ sar9b_0._05_ 0.26004f
C449 single_9b_cdac_0.cdac_sw_9b_0.cdac_sw_3_4.nooverlap_clk_0.CLK0 single_9b_cdac_0.cdac_sw_9b_0.S[3] 0.28575f
C450 uio_out[0] a_5601_26516# 0.12712f
C451 a_9113_24582# a_9460_24340# 0.05116f
C452 single_9b_cdac_1.CF[0] sar9b_0.net39 0.10586f
C453 a_11689_21318# a_11579_21442# 0.09774f
C454 a_11471_21076# a_11376_21076# 0.04983f
C455 a_12211_21050# a_12036_21076# 0.23366f
C456 single_9b_cdac_1.cdac_sw_9b_0.cdac_sw_3_8.tg_sw_3_3.SWP single_9b_cdac_1.cdac_sw_9b_0.cdac_sw_3_8.nooverlap_clk_0.CLKB0 1.71649f
C457 clk single_9b_cdac_1.CF[0] 0.08208f
C458 sar9b_0.net15 a_13053_18900# 0.34106f
C459 a_14871_9671# clk 0.36908f
C460 sar9b_0.FINAL a_13053_26516# 0.02524f
C461 sar9b_0.net34 VDPWR 0.49746f
C462 sar9b_0.FINAL a_11857_25978# 0.33133f
C463 single_9b_cdac_1.cdac_sw_9b_0.cdac_sw_3_1.nooverlap_clk_0.sky130_fd_sc_hs__inv_1_1.A single_9b_cdac_1.cdac_sw_9b_0.cdac_sw_3_1.nooverlap_clk_0.x8.A 0.08121f
C464 sar9b_0._13_ VDPWR 0.22933f
C465 a_6483_23618# a_6226_23364# 0.03684f
C466 sar9b_0.clk_div_0.COUNT\[1\] a_8273_23796# 0.02316f
C467 single_9b_cdac_1.cdac_sw_9b_0.cdac_sw_3_2.nooverlap_clk_0.CLKB0 single_9b_cdac_1.cdac_sw_9b_0.cdac_sw_3_2.nooverlap_clk_0.sky130_fd_sc_hs__inv_8_0.A 0.6919f
C468 a_9167_18874# a_9370_19152# 0.23366f
C469 single_9b_cdac_1.cdac_sw_9b_0.S[4] single_9b_cdac_1.cdac_sw_9b_0.cdac_sw_3_3.tg_sw_3_3.SWP 1.55982f
C470 sar9b_0.net28 single_9b_cdac_1.CF[1] 0.03695f
C471 a_10937_22164# a_11505_22406# 0.17467f
C472 a_6219_22316# sar9b_0._12_ 0.0925f
C473 single_9b_cdac_0.cdac_sw_9b_0.cdac_sw_3_0.nooverlap_clk_0.sky130_fd_sc_hs__inv_1_1.A single_9b_cdac_0.cdac_sw_9b_0.cdac_sw_3_0.nooverlap_clk_0.sky130_fd_sc_hs__nand2_1_0.Y 0.12223f
C474 a_10637_27279# uo_out[4] 0.1107f
C475 single_9b_cdac_1.CF[4] single_9b_cdac_1.cdac_sw_9b_0.cdac_sw_3_3.nooverlap_clk_0.x8.A 0.31534f
C476 single_9b_cdac_1.cdac_sw_9b_0.cdac_sw_3_7.tg_sw_3_3.SWP single_9b_cdac_1.cdac_sw_9b_0.cdac_sw_3_7.nooverlap_clk_0.CLKB0 1.71649f
C477 sar9b_0.net7 a_13347_21620# 0.02702f
C478 single_9b_cdac_0.SW[2] single_9b_cdac_1.CF[2] 2.01677f
C479 a_10955_18900# sar9b_0.net6 0.6263f
C480 sar9b_0.clkload0.X sar9b_0.clknet_1_0__leaf_CLK 0.04399f
C481 single_9b_cdac_1.cdac_sw_9b_0.cdac_sw_3_8.nooverlap_clk_0.x10.A single_9b_cdac_1.cdac_sw_9b_0.cdac_sw_3_8.nooverlap_clk_0.sky130_fd_sc_hs__inv_8_0.A 0.05105f
C482 single_9b_cdac_0.cdac_sw_9b_0.cdac_sw_3_0.nooverlap_clk_0.x4.A single_9b_cdac_1.CF[2] 0.0313f
C483 single_9b_cdac_1.cdac_sw_9b_0.cdac_sw_3_0.tg_sw_3_3.SWP single_9b_cdac_1.SW[2] 0.17199f
C484 a_12487_20836# sar9b_0.net7 0.01668f
C485 single_9b_cdac_1.SW[6] single_9b_cdac_1.SW[1] 0.21749f
C486 single_9b_cdac_1.SW[7] single_9b_cdac_1.SW[0] 0.02168f
C487 sar9b_0.net15 a_14143_23012# 0.27822f
C488 a_8431_22682# a_8912_22824# 0.04242f
C489 a_8634_22840# a_8951_22950# 0.10236f
C490 single_9b_cdac_1.cdac_sw_9b_0.cdac_sw_3_0.nooverlap_clk_0.x4.A single_9b_cdac_1.cdac_sw_9b_0.cdac_sw_3_0.nooverlap_clk_0.sky130_fd_sc_hs__nand2_1_0.Y 0.01751f
C491 single_9b_cdac_0.cdac_sw_9b_0.cdac_sw_3_3.nooverlap_clk_0.x1.A single_9b_cdac_0.cdac_sw_9b_0.cdac_sw_3_3.nooverlap_clk_0.x4.A 0.28523f
C492 single_9b_cdac_1.cdac_sw_9b_0.cdac_sw_3_4.tg_sw_3_3.SWN single_9b_cdac_1.cdac_sw_9b_0.S[3] 0.84426f
C493 a_12961_23802# a_13529_23770# 0.18639f
C494 a_12795_23802# a_13311_24174# 0.10748f
C495 a_10679_25428# VDPWR 0.45995f
C496 a_11195_25428# sar9b_0.net13 0.03454f
C497 uo_out[2] sar9b_0.net39 0.04547f
C498 sar9b_0.net36 sar9b_0.net1 0.02081f
C499 single_9b_cdac_1.cdac_sw_9b_0.cdac_sw_3_3.tg_sw_3_3.SWN single_9b_cdac_1.cdac_sw_9b_0.S[4] 0.84426f
C500 uo_out[2] clk 0.0457f
C501 a_11100_25428# sar9b_0.net13 0.1701f
C502 a_7919_23802# a_8951_23770# 0.04875f
C503 a_8085_23802# a_8358_23796# 0.0802f
C504 a_14175_21620# single_9b_cdac_1.CF[3] 0.11079f
C505 single_9b_cdac_0.cdac_sw_9b_0.cdac_sw_3_6.nooverlap_clk_0.CLK0 a_34814_26990# 0.14695f
C506 single_9b_cdac_0.cdac_sw_9b_0.cdac_sw_3_2.tg_sw_3_3.SWP VDPWR 3.27795f
C507 sar9b_0._09_ VDPWR 0.641f
C508 a_12887_18900# a_13308_18900# 0.09313f
C509 a_13053_18900# a_13968_18900# 0.12532f
C510 single_9b_cdac_1.SW[0] single_9b_cdac_1.cdac_sw_9b_0.S[0] 0.22983f
C511 a_12575_18734# sar9b_0.net35 0.03002f
C512 single_9b_cdac_1.SW[6] single_9b_cdac_1.SW[8] 0.07172f
C513 a_12961_23802# a_13876_24174# 0.12532f
C514 a_16357_9613# th_dif_sw_0.VCN 0.10892f
C515 a_7735_21076# sar9b_0._09_ 0.16948f
C516 a_6943_22316# sar9b_0._12_ 0.05931f
C517 sar9b_0.net27 sar9b_0.net11 0.50008f
C518 a_11852_22164# sar9b_0.net9 0.05775f
C519 a_7145_23226# a_7363_23502# 0.08213f
C520 a_7620_26350# VDPWR 0.29294f
C521 a_8340_27426# sar9b_0.net39 0.17011f
C522 single_9b_cdac_1.cdac_sw_9b_0.cdac_sw_3_3.nooverlap_clk_0.sky130_fd_sc_hs__nand2_1_0.Y a_46159_15501# 0.01076f
C523 sar9b_0.net15 sar9b_0.net43 0.24949f
C524 sar9b_0.net22 sar9b_0.FINAL 0.04022f
C525 single_9b_cdac_0.SW[7] a_13623_25972# 0.11086f
C526 a_8379_24340# sar9b_0.net35 0.03026f
C527 a_8287_19450# a_9021_19418# 0.05348f
C528 single_9b_cdac_0.cdac_sw_9b_0.cdac_sw_3_4.nooverlap_clk_0.sky130_fd_sc_hs__nand2_1_0.Y single_9b_cdac_0.cdac_sw_9b_0.cdac_sw_3_4.nooverlap_clk_0.x1.A 0.01003f
C529 single_9b_cdac_0.cdac_sw_9b_0.cdac_sw_3_0.nooverlap_clk_0.CLKB0 single_9b_cdac_0.cdac_sw_9b_0.S[2] 0.36013f
C530 a_13511_24884# VDPWR 0.13232f
C531 a_6587_21852# sar9b_0._08_ 0.1084f
C532 sar9b_0.net14 sar9b_0.net15 0.03964f
C533 single_9b_cdac_1.cdac_sw_9b_0.cdac_sw_3_7.nooverlap_clk_0.x1.A single_9b_cdac_1.cdac_sw_9b_0.cdac_sw_3_7.nooverlap_clk_0.sky130_fd_sc_hs__inv_8_0.A 0.45521f
C534 a_6308_27060# a_6094_27060# 0.09774f
C535 a_6679_22316# sar9b_0.clk_div_0.COUNT\[0\] 0.20689f
C536 ua[0] single_9b_cdac_0.cdac_sw_9b_0.cdac_sw_3_5.nooverlap_clk_0.CLKB0 0.1236f
C537 sar9b_0.net41 a_14175_20532# 0.19691f
C538 a_11231_20538# a_11965_20506# 0.05338f
C539 sar9b_0.net17 a_5343_25972# 0.02323f
C540 single_9b_cdac_0.cdac_sw_9b_0.cdac_sw_3_7.tg_sw_3_3.SWN single_9b_cdac_0.cdac_sw_9b_0.S[7] 0.84427f
C541 th_dif_sw_0.CKB th_dif_sw_0.VCN 0.12032f
C542 sar9b_0.net40 a_10732_25250# 0.01291f
C543 a_8287_19450# sar9b_0.net4 0.28752f
C544 single_9b_cdac_1.cdac_sw_9b_0.cdac_sw_3_5.tg_sw_3_3.SWN VDPWR 2.82172f
C545 single_9b_cdac_0.cdac_sw_9b_0.cdac_sw_3_2.nooverlap_clk_0.sky130_fd_sc_hs__nand2_1_0.Y single_9b_cdac_1.CF[0] 0.17948f
C546 a_13403_25262# a_13511_24884# 0.05722f
C547 sar9b_0.net26 sar9b_0.net28 0.16636f
C548 a_5785_23252# a_6226_23364# 0.11071f
C549 a_11231_20538# sar9b_0.net4 0.24842f
C550 sar9b_0.net4 sar9b_0.net12 0.07571f
C551 sar9b_0._02_ sar9b_0.net36 0.04789f
C552 a_6059_26882# a_5951_26516# 0.05722f
C553 a_9631_26516# a_9536_26516# 0.04983f
C554 a_10371_26490# a_10196_26516# 0.23366f
C555 a_9849_26758# a_9739_26882# 0.09774f
C556 VDPWR a_13053_26516# 0.58415f
C557 VDPWR a_11857_25978# 0.46016f
C558 single_9b_cdac_0.cdac_sw_9b_0.cdac_sw_3_3.nooverlap_clk_0.x4.A single_9b_cdac_0.cdac_sw_9b_0.cdac_sw_3_3.nooverlap_clk_0.sky130_fd_sc_hs__nand2_1_0.Y 0.01751f
C559 sar9b_0.net26 sar9b_0.net29 0.1099f
C560 single_9b_cdac_0.cdac_sw_9b_0.cdac_sw_3_1.nooverlap_clk_0.x6.A single_9b_cdac_0.cdac_sw_9b_0.cdac_sw_3_1.nooverlap_clk_0.x4.A 0.12431f
C561 a_15151_10456# clk 0.19995f
C562 a_35519_29917# single_9b_cdac_0.cdac_sw_9b_0.cdac_sw_3_6.nooverlap_clk_0.x4.A 0.01076f
C563 VDPWR single_9b_cdac_1.cdac_sw_9b_0.cdac_sw_3_0.nooverlap_clk_0.sky130_fd_sc_hs__inv_8_0.A 0.96985f
C564 single_9b_cdac_0.SW[6] single_9b_cdac_0.cdac_sw_9b_0.cdac_sw_3_6.tg_sw_3_3.SWP 0.17461f
C565 a_48343_26999# single_9b_cdac_0.cdac_sw_9b_0.cdac_sw_3_4.nooverlap_clk_0.CLKB0 0.23864f
C566 single_9b_cdac_0.cdac_sw_9b_0.cdac_sw_3_1.nooverlap_clk_0.sky130_fd_sc_hs__inv_8_0.A single_9b_cdac_0.cdac_sw_9b_0.cdac_sw_3_1.nooverlap_clk_0.CLKB0 0.6919f
C567 single_9b_cdac_0.cdac_sw_9b_0.S[4] single_9b_cdac_1.CF[5] 0.01608f
C568 single_9b_cdac_1.cdac_sw_9b_0.cdac_sw_3_8.nooverlap_clk_0.x10.A VDPWR 0.95338f
C569 single_9b_cdac_1.SW[2] sar9b_0.net6 0.02933f
C570 a_9113_24582# a_8379_24340# 0.07009f
C571 single_9b_cdac_0.cdac_sw_9b_0.cdac_sw_3_6.nooverlap_clk_0.CLK0 single_9b_cdac_0.cdac_sw_9b_0.cdac_sw_3_6.tg_sw_3_3.SWN 0.17533f
C572 single_9b_cdac_1.cdac_sw_9b_0.cdac_sw_3_6.nooverlap_clk_0.x1.A single_9b_cdac_1.cdac_sw_9b_0.cdac_sw_3_6.nooverlap_clk_0.sky130_fd_sc_hs__inv_1_1.A 0.10429f
C573 sar9b_0.net30 single_9b_cdac_0.SW[6] 0.03607f
C574 sar9b_0.net31 sar9b_0.net30 0.31742f
C575 VDPWR single_9b_cdac_1.cdac_sw_9b_0.cdac_sw_3_0.nooverlap_clk_0.x4.A 0.62443f
C576 VDPWR a_7203_22682# 0.389f
C577 single_9b_cdac_1.cdac_sw_9b_0.cdac_sw_3_2.nooverlap_clk_0.x10.A single_9b_cdac_1.cdac_sw_9b_0.cdac_sw_3_2.nooverlap_clk_0.x1.A 0.05472f
C578 sar9b_0.clk_div_0.COUNT\[2\] sar9b_0._12_ 0.15911f
C579 a_13053_19988# single_9b_cdac_1.SW[4] 0.03978f
C580 sar9b_0.FINAL a_11689_26758# 0.05005f
C581 a_12961_23802# sar9b_0.net13 0.02716f
C582 sar9b_0.net10 sar9b_0.net1 0.02681f
C583 a_13053_19988# single_9b_cdac_1.SW[2] 0.02272f
C584 uio_out[1] a_5487_27034# 0.0189f
C585 single_9b_cdac_1.cdac_sw_9b_0.cdac_sw_3_0.nooverlap_clk_0.x1.A single_9b_cdac_1.cdac_sw_9b_0.cdac_sw_3_0.nooverlap_clk_0.x6.A 0.03729f
C586 ui_in[0] a_5343_25972# 0.22466f
C587 sar9b_0.net20 sar9b_0.net38 0.30769f
C588 single_9b_cdac_0.cdac_sw_9b_0.cdac_sw_3_7.tg_sw_3_3.SWP single_9b_cdac_0.cdac_sw_9b_0.cdac_sw_3_6.tg_sw_3_3.SWP 0.02666f
C589 sar9b_0.net30 single_9b_cdac_0.SW[4] 0.46053f
C590 ui_in[0] rst_n 0.03102f
C591 single_9b_cdac_0.cdac_sw_9b_0.cdac_sw_3_2.tg_sw_3_3.SWN single_9b_cdac_1.CF[1] 0.03488f
C592 a_38738_16877# single_9b_cdac_1.SW[5] 0.28324f
C593 single_9b_cdac_0.cdac_sw_9b_0.cdac_sw_3_4.nooverlap_clk_0.CLK0 single_9b_cdac_0.cdac_sw_9b_0.cdac_sw_3_3.nooverlap_clk_0.CLK0 0.02618f
C594 tdc_0.OUTN VDPWR 0.61236f
C595 single_9b_cdac_1.CF[4] single_9b_cdac_1.CF[3] 12.2665f
C596 sar9b_0.net40 single_9b_cdac_1.CF[1] 0.11725f
C597 a_9205_23494# a_9552_23252# 0.05116f
C598 a_8637_23252# a_8892_23252# 0.06418f
C599 sar9b_0.net7 a_11121_21076# 0.01074f
C600 a_5393_17977# th_dif_sw_0.CKB 0.1104f
C601 single_9b_cdac_1.cdac_sw_9b_0.cdac_sw_3_0.tg_sw_3_3.SWP VDPWR 3.27824f
C602 a_13347_21620# sar9b_0.net9 0.03084f
C603 VDPWR a_11192_22164# 0.07993f
C604 sar9b_0.net21 sar9b_0.net3 0.20323f
C605 single_9b_cdac_0.cdac_sw_9b_0.cdac_sw_3_5.nooverlap_clk_0.sky130_fd_sc_hs__inv_8_0.A single_9b_cdac_1.CF[5] 0.06019f
C606 single_9b_cdac_0.SW[2] th_dif_sw_0.VCN 0.09453f
C607 a_33936_16877# single_9b_cdac_1.cdac_sw_9b_0.cdac_sw_3_6.nooverlap_clk_0.CLKB0 0.23864f
C608 a_11121_23802# a_11689_23770# 0.18639f
C609 single_9b_cdac_0.cdac_sw_9b_0.cdac_sw_3_8.tg_sw_3_3.SWP single_9b_cdac_0.cdac_sw_9b_0.S[8] 1.50844f
C610 single_9b_cdac_1.cdac_sw_9b_0.cdac_sw_3_6.nooverlap_clk_0.x6.A VDPWR 0.38397f
C611 a_9648_19168# a_9774_19266# 0.18639f
C612 single_9b_cdac_1.cdac_sw_9b_0.cdac_sw_3_4.nooverlap_clk_0.x1.A single_9b_cdac_1.cdac_sw_9b_0.cdac_sw_3_4.nooverlap_clk_0.sky130_fd_sc_hs__inv_1_1.A 0.10429f
C613 clk single_9b_cdac_1.CF[3] 0.08196f
C614 single_9b_cdac_1.cdac_sw_9b_0.cdac_sw_3_6.nooverlap_clk_0.x1.A VDPWR 0.75853f
C615 sar9b_0.net11 sar9b_0.net42 0.0241f
C616 a_13511_25794# sar9b_0.net33 0.02452f
C617 single_9b_cdac_1.CF[2] single_9b_cdac_1.cdac_sw_9b_0.cdac_sw_3_0.nooverlap_clk_0.x1.A 0.06503f
C618 ua[1] dw_17224_1400# 1.44315f
C619 a_16159_13315# tdc_0.phase_detector_0.pd_out_0.B 0.38171f
C620 single_9b_cdac_1.CF[4] single_9b_cdac_1.cdac_sw_9b_0.cdac_sw_3_3.nooverlap_clk_0.x4.A 0.0313f
C621 sar9b_0.net22 VDPWR 0.38814f
C622 ua[1] th_dif_sw_0.th_sw_0.th_sw_main_0.VGS 0.9353f
C623 a_13403_21076# a_13511_21442# 0.05722f
C624 sar9b_0._00_ sar9b_0.net15 0.0192f
C625 single_9b_cdac_1.CF[8] sar9b_0.net29 0.06686f
C626 sar9b_0.net8 sar9b_0.net6 0.02663f
C627 a_6701_20506# sar9b_0.clknet_0_CLK 0.42222f
C628 a_13403_21076# a_13053_21076# 0.21772f
C629 a_14143_21050# a_12887_21076# 0.04357f
C630 sar9b_0.net35 sar9b_0.net38 0.07747f
C631 a_11397_20538# sar9b_0.net42 0.47272f
C632 VDPWR single_9b_cdac_0.cdac_sw_9b_0.cdac_sw_3_2.nooverlap_clk_0.x8.A 0.83441f
C633 single_9b_cdac_0.cdac_sw_9b_0.cdac_sw_3_1.nooverlap_clk_0.sky130_fd_sc_hs__inv_8_0.A single_9b_cdac_0.cdac_sw_9b_0.cdac_sw_3_1.nooverlap_clk_0.x1.A 0.45521f
C634 single_9b_cdac_0.cdac_sw_9b_0.cdac_sw_3_8.tg_sw_3_3.SWP single_9b_cdac_0.cdac_sw_9b_0.cdac_sw_3_8.nooverlap_clk_0.CLK0 0.19266f
C635 a_48343_16877# single_9b_cdac_1.cdac_sw_9b_0.S[3] 0.59531f
C636 sar9b_0.net27 sar9b_0.net42 0.02719f
C637 a_6759_20354# a_6701_20506# 0.01146f
C638 a_13053_19450# sar9b_0.net15 0.04076f
C639 a_9097_22164# clk 0.01625f
C640 a_10311_19450# a_10827_19822# 0.10543f
C641 sar9b_0.net2 a_8892_23252# 0.18816f
C642 a_10955_23802# a_12036_24174# 0.10236f
C643 a_13308_23074# sar9b_0.net1 0.16382f
C644 single_9b_cdac_0.SW[7] single_9b_cdac_0.cdac_sw_9b_0.cdac_sw_3_8.nooverlap_clk_0.CLKB0 0.03585f
C645 single_9b_cdac_1.cdac_sw_9b_0.S[2] single_9b_cdac_1.cdac_sw_9b_0.S[8] 0.22651f
C646 a_21684_3438# a_18214_3039# 0.11186f
C647 a_12059_18362# a_12575_18734# 0.10584f
C648 a_12225_18362# a_12793_18330# 0.17006f
C649 ua[0] single_9b_cdac_0.cdac_sw_9b_0.S[7] 2.02453f
C650 a_5895_19988# sar9b_0.net37 0.23618f
C651 VDPWR single_9b_cdac_1.cdac_sw_9b_0.cdac_sw_3_1.tg_sw_3_3.SWP 3.27843f
C652 single_9b_cdac_1.cdac_sw_9b_0.cdac_sw_3_4.nooverlap_clk_0.sky130_fd_sc_hs__nand2_1_0.Y VDPWR 0.62538f
C653 sar9b_0.net28 single_9b_cdac_1.CF[6] 0.0731f
C654 a_13311_24174# sar9b_0.net39 0.01724f
C655 single_9b_cdac_1.cdac_sw_9b_0.cdac_sw_3_5.nooverlap_clk_0.x1.A single_9b_cdac_1.cdac_sw_9b_0.cdac_sw_3_5.nooverlap_clk_0.x3.Y 0.07579f
C656 clk a_8912_22824# 0.03579f
C657 single_9b_cdac_0.cdac_sw_9b_0.cdac_sw_3_4.nooverlap_clk_0.x4.A single_9b_cdac_0.cdac_sw_9b_0.cdac_sw_3_4.nooverlap_clk_0.x6.A 0.12431f
C658 single_9b_cdac_1.cdac_sw_9b_0.cdac_sw_3_2.nooverlap_clk_0.x1.A single_9b_cdac_1.cdac_sw_9b_0.cdac_sw_3_2.nooverlap_clk_0.x4.A 0.28523f
C659 ua[2] VDPWR 1.88067f
C660 single_9b_cdac_1.cdac_sw_9b_0.cdac_sw_3_0.tg_sw_3_3.SWN single_9b_cdac_1.SW[2] 0.15027f
C661 single_9b_cdac_0.SW[1] single_9b_cdac_0.SW[5] 0.01299f
C662 single_9b_cdac_0.cdac_sw_9b_0.cdac_sw_3_7.nooverlap_clk_0.sky130_fd_sc_hs__inv_8_0.A single_9b_cdac_0.cdac_sw_9b_0.cdac_sw_3_7.nooverlap_clk_0.x1.A 0.45521f
C663 VDPWR a_11689_26758# 0.22889f
C664 single_9b_cdac_0.cdac_sw_9b_0.cdac_sw_3_2.nooverlap_clk_0.x4.A single_9b_cdac_0.cdac_sw_9b_0.cdac_sw_3_2.nooverlap_clk_0.x1.A 0.28523f
C665 sar9b_0.net13 a_12036_26516# 0.02255f
C666 a_6337_22714# a_7035_22708# 0.1942f
C667 sar9b_0.net30 a_14143_23012# 0.06321f
C668 single_9b_cdac_1.cdac_sw_9b_0.S[3] single_9b_cdac_1.SW[3] 0.22939f
C669 single_9b_cdac_1.cdac_sw_9b_0.cdac_sw_3_4.nooverlap_clk_0.sky130_fd_sc_hs__inv_8_0.A single_9b_cdac_1.cdac_sw_9b_0.cdac_sw_3_4.nooverlap_clk_0.x8.A 0.04988f
C670 single_9b_cdac_1.CF[6] sar9b_0.net29 0.03489f
C671 single_9b_cdac_1.SW[1] single_9b_cdac_1.cdac_sw_9b_0.cdac_sw_3_1.tg_sw_3_3.SWN 0.15052f
C672 a_9113_24582# sar9b_0.net38 0.01407f
C673 single_9b_cdac_1.SW[1] single_9b_cdac_1.CF[2] 0.22161f
C674 a_13403_23086# a_13403_22164# 0.01512f
C675 sar9b_0.net11 a_13308_25250# 0.01652f
C676 a_13053_18900# sar9b_0.net1 0.03689f
C677 VDPWR sar9b_0.net6 1.6913f
C678 a_13347_20532# sar9b_0.net39 0.03286f
C679 a_12480_18722# sar9b_0.net35 0.01618f
C680 a_9368_19822# VDPWR 0.27537f
C681 a_8379_25978# a_8545_25978# 0.60715f
C682 a_9535_19962# sar9b_0.net38 0.07946f
C683 a_53154_26999# single_9b_cdac_0.cdac_sw_9b_0.cdac_sw_3_0.nooverlap_clk_0.CLKB0 0.23864f
C684 uo_out[6] a_8613_26681# 0.11032f
C685 VDPWR a_13053_19988# 0.25263f
C686 a_10477_19450# sar9b_0.net2 0.03347f
C687 a_13403_19822# a_13403_18900# 0.01512f
C688 a_9635_26276# sar9b_0.net3 0.32925f
C689 a_5951_26516# sar9b_0.FINAL 0.04613f
C690 a_10827_19822# sar9b_0.net5 0.04358f
C691 a_12887_24890# a_12887_25428# 0.04145f
C692 a_10311_23252# VDPWR 0.43798f
C693 a_5487_27034# sar9b_0.net3 0.27756f
C694 a_12887_19450# a_12887_19988# 0.04145f
C695 sar9b_0.net28 single_9b_cdac_1.CF[7] 0.06036f
C696 single_9b_cdac_1.cdac_sw_9b_0.cdac_sw_3_2.nooverlap_clk_0.sky130_fd_sc_hs__inv_1_1.A single_9b_cdac_1.cdac_sw_9b_0.cdac_sw_3_2.nooverlap_clk_0.sky130_fd_sc_hs__nand2_1_0.Y 0.12223f
C697 single_9b_cdac_1.cdac_sw_9b_0.cdac_sw_3_8.tg_sw_3_3.SWN single_9b_cdac_1.cdac_sw_9b_0.cdac_sw_3_7.tg_sw_3_3.SWN 0.02638f
C698 sar9b_0.net15 sar9b_0.net32 0.50671f
C699 single_9b_cdac_0.cdac_sw_9b_0.cdac_sw_3_3.tg_sw_3_3.SWN single_9b_cdac_0.SW[3] 0.019f
C700 a_13968_25428# VDPWR 0.27606f
C701 sar9b_0.net24 a_12887_26516# 0.01537f
C702 a_14175_21620# single_9b_cdac_1.CF[1] 0.01016f
C703 a_6631_24590# VDPWR 0.21923f
C704 a_11121_21076# sar9b_0.net9 0.01899f
C705 sar9b_0.net2 a_10955_18900# 0.19738f
C706 single_9b_cdac_0.cdac_sw_9b_0.cdac_sw_3_0.tg_sw_3_3.SWN VDPWR 2.82215f
C707 single_9b_cdac_1.CF[7] sar9b_0.net29 0.08942f
C708 single_9b_cdac_0.cdac_sw_9b_0.cdac_sw_3_0.nooverlap_clk_0.CLKB0 single_9b_cdac_1.CF[2] 0.26709f
C709 a_14143_19962# a_13968_19988# 0.23366f
C710 a_13403_19988# a_13308_19988# 0.04983f
C711 a_13621_20230# a_13511_20354# 0.09774f
C712 a_14143_25402# a_14143_25188# 0.02772f
C713 a_12887_25428# a_13053_25428# 0.82418f
C714 single_9b_cdac_1.SW[1] single_9b_cdac_1.cdac_sw_9b_0.S[1] 0.22497f
C715 single_9b_cdac_1.CF[8] single_9b_cdac_1.cdac_sw_9b_0.cdac_sw_3_7.tg_sw_3_3.SWN 0.03484f
C716 single_9b_cdac_1.SW[0] single_9b_cdac_1.cdac_sw_9b_0.cdac_sw_3_2.tg_sw_3_3.SWN 0.1588f
C717 a_6219_22316# sar9b_0.clknet_1_1__leaf_CLK 0.01014f
C718 sar9b_0.net8 a_12887_22164# 0.38078f
C719 sar9b_0.net11 a_8358_23796# 0.01923f
C720 single_9b_cdac_0.cdac_sw_9b_0.cdac_sw_3_0.nooverlap_clk_0.x8.A single_9b_cdac_0.cdac_sw_9b_0.cdac_sw_3_0.nooverlap_clk_0.sky130_fd_sc_hs__inv_1_1.A 0.08121f
C721 a_10827_19822# sar9b_0.net38 0.03557f
C722 sar9b_0.net1 sar9b_0.net43 0.1416f
C723 single_9b_cdac_1.cdac_sw_9b_0.cdac_sw_3_5.nooverlap_clk_0.sky130_fd_sc_hs__nand2_1_0.Y a_41357_15501# 0.01076f
C724 a_12036_21076# a_10955_21076# 0.10236f
C725 sar9b_0.net38 a_9205_23494# 0.01884f
C726 sar9b_0.net25 a_12947_26276# 0.06346f
C727 VDPWR a_6094_27060# 0.22501f
C728 a_13511_25794# a_13621_25670# 0.09774f
C729 a_8545_24340# a_9003_24706# 0.03462f
C730 single_9b_cdac_0.cdac_sw_9b_0.cdac_sw_3_6.nooverlap_clk_0.x6.A single_9b_cdac_0.cdac_sw_9b_0.cdac_sw_3_6.nooverlap_clk_0.x1.A 0.03729f
C731 a_14143_21050# sar9b_0.net15 0.28838f
C732 a_10311_24890# sar9b_0.net4 0.24632f
C733 a_13053_24890# sar9b_0.net39 0.03087f
C734 single_9b_cdac_1.cdac_sw_9b_0.cdac_sw_3_6.nooverlap_clk_0.sky130_fd_sc_hs__nand2_1_0.Y a_36555_15501# 0.01076f
C735 single_9b_cdac_1.cdac_sw_9b_0.S[5] th_dif_sw_0.VCP 6.18357f
C736 a_11045_23494# a_11392_23252# 0.05116f
C737 sar9b_0.net23 a_10371_26490# 0.06153f
C738 single_9b_cdac_1.cdac_sw_9b_0.cdac_sw_3_8.nooverlap_clk_0.x3.Y single_9b_cdac_1.cdac_sw_9b_0.cdac_sw_3_8.nooverlap_clk_0.x4.A 0.07517f
C739 tdc_0.OUTN tdc_0.phase_detector_0.pd_out_0.A 0.11925f
C740 single_9b_cdac_0.cdac_sw_9b_0.cdac_sw_3_6.nooverlap_clk_0.CLK0 single_9b_cdac_1.CF[6] 0.42014f
C741 single_9b_cdac_0.cdac_sw_9b_0.cdac_sw_3_2.nooverlap_clk_0.x1.A single_9b_cdac_0.cdac_sw_9b_0.cdac_sw_3_2.nooverlap_clk_0.sky130_fd_sc_hs__inv_1_1.A 0.10429f
C742 a_5895_19988# a_6502_20124# 0.15293f
C743 a_13499_26516# a_13403_26516# 0.01379f
C744 a_18214_3039# w_17430_1606# 0.14276f
C745 a_12937_27279# a_13379_27398# 0.0133f
C746 single_9b_cdac_1.cdac_sw_9b_0.cdac_sw_3_0.tg_sw_3_3.SWN VDPWR 2.82165f
C747 a_11121_18900# a_11376_18900# 0.06121f
C748 VDPWR a_11579_23796# 0.14637f
C749 ua[0] single_9b_cdac_0.cdac_sw_9b_0.S[4] 1.93709f
C750 clk ena 0.03102f
C751 single_9b_cdac_0.cdac_sw_9b_0.cdac_sw_3_6.nooverlap_clk_0.sky130_fd_sc_hs__inv_8_0.A single_9b_cdac_1.CF[6] 0.06019f
C752 single_9b_cdac_0.cdac_sw_9b_0.cdac_sw_3_5.nooverlap_clk_0.sky130_fd_sc_hs__nand2_1_0.Y single_9b_cdac_1.CF[5] 0.17948f
C753 single_9b_cdac_0.SW[2] single_9b_cdac_1.CF[3] 0.04427f
C754 a_5884_21326# sar9b_0._10_ 0.095f
C755 VDPWR a_12887_22164# 0.45928f
C756 VDPWR a_5951_26516# 0.23567f
C757 single_9b_cdac_1.cdac_sw_9b_0.cdac_sw_3_8.tg_sw_3_3.SWN single_9b_cdac_1.cdac_sw_9b_0.cdac_sw_3_8.tg_sw_3_3.SWP 3.04383f
C758 single_9b_cdac_1.cdac_sw_9b_0.cdac_sw_3_1.nooverlap_clk_0.sky130_fd_sc_hs__inv_1_1.A single_9b_cdac_1.cdac_sw_9b_0.cdac_sw_3_1.nooverlap_clk_0.sky130_fd_sc_hs__nand2_1_0.Y 0.12223f
C759 a_8545_24340# VDPWR 0.5883f
C760 VDPWR sar9b_0.clknet_0_CLK 2.21912f
C761 a_11689_21318# VDPWR 0.23544f
C762 uo_out[0] VDPWR 0.46164f
C763 single_9b_cdac_1.SW[1] th_dif_sw_0.VCN 0.09475f
C764 a_8543_27060# sar9b_0.net3 0.0122f
C765 single_9b_cdac_1.CF[4] single_9b_cdac_1.CF[1] 0.03744f
C766 a_7735_21076# sar9b_0.clknet_0_CLK 0.03666f
C767 a_6759_20354# VDPWR 0.16819f
C768 a_13511_19444# VDPWR 0.1421f
C769 a_10016_20256# a_10055_20130# 0.82f
C770 sar9b_0.net21 a_9809_27279# 0.21809f
C771 VDPWR a_14143_22138# 0.3591f
C772 sar9b_0.net41 a_10012_22164# 0.02552f
C773 a_13308_19810# sar9b_0.net1 0.16206f
C774 a_6343_20354# sar9b_0._00_ 0.01834f
C775 a_10845_25428# a_10827_25262# 0.01248f
C776 single_9b_cdac_1.CF[8] single_9b_cdac_1.cdac_sw_9b_0.cdac_sw_3_8.tg_sw_3_3.SWP 0.10499f
C777 a_13379_27398# sar9b_0.net14 0.11496f
C778 single_9b_cdac_1.cdac_sw_9b_0.cdac_sw_3_2.nooverlap_clk_0.CLK0 VDPWR 2.71729f
C779 clk single_9b_cdac_1.CF[1] 0.08196f
C780 single_9b_cdac_1.SW[8] th_dif_sw_0.VCN 0.09453f
C781 tdc_0.phase_detector_0.INP a_15400_11316# 0.02415f
C782 sar9b_0.net10 a_11192_22164# 0.01925f
C783 a_13621_20230# single_9b_cdac_1.SW[3] 0.01359f
C784 single_9b_cdac_1.SW[1] single_9b_cdac_1.CF[0] 0.30922f
C785 sar9b_0.net36 sar9b_0.net6 0.23972f
C786 single_9b_cdac_1.cdac_sw_9b_0.cdac_sw_3_3.nooverlap_clk_0.CLK0 single_9b_cdac_1.SW[4] 0.24199f
C787 a_12480_18722# a_12059_18362# 0.08297f
C788 a_5579_19676# a_5863_19662# 0.03224f
C789 a_5483_19676# a_5870_19566# 0.03405f
C790 single_9b_cdac_1.CF[7] single_9b_cdac_1.cdac_sw_9b_0.cdac_sw_3_7.tg_sw_3_3.SWN 0.12358f
C791 a_11935_25402# a_11760_25428# 0.23366f
C792 a_49926_29917# single_9b_cdac_0.cdac_sw_9b_0.cdac_sw_3_4.nooverlap_clk_0.x4.A 0.01076f
C793 sar9b_0.net28 sar9b_0.net8 0.02823f
C794 sar9b_0.net27 a_12887_21076# 0.02997f
C795 a_5969_25428# a_7059_25402# 0.04242f
C796 a_6537_25670# a_6319_25428# 0.20964f
C797 sar9b_0.clk_div_0.COUNT\[2\] sar9b_0.clknet_1_1__leaf_CLK 0.01386f
C798 a_8471_20538# a_8637_20538# 0.97386f
C799 a_9281_26516# a_10196_26516# 0.12499f
C800 single_9b_cdac_1.SW[8] single_9b_cdac_1.CF[0] 3.97747f
C801 a_24332_16877# single_9b_cdac_1.cdac_sw_9b_0.cdac_sw_3_8.nooverlap_clk_0.CLKB0 0.23864f
C802 sar9b_0._05_ sar9b_0.net35 0.08535f
C803 a_12427_17812# VDPWR 0.28917f
C804 single_9b_cdac_0.SW[7] single_9b_cdac_0.cdac_sw_9b_0.cdac_sw_3_8.tg_sw_3_3.SWP 0.05167f
C805 sar9b_0.net14 sar9b_0.net34 0.01021f
C806 single_9b_cdac_1.cdac_sw_9b_0.cdac_sw_3_4.nooverlap_clk_0.x1.A single_9b_cdac_1.CF[3] 0.06503f
C807 a_10955_23802# a_11376_24162# 0.08968f
C808 single_9b_cdac_1.cdac_sw_9b_0.S[0] th_dif_sw_0.VCP 0.21837p
C809 single_9b_cdac_0.SW[2] a_14175_24340# 0.11444f
C810 single_9b_cdac_0.cdac_sw_9b_0.cdac_sw_3_6.nooverlap_clk_0.CLKB0 single_9b_cdac_0.cdac_sw_9b_0.cdac_sw_3_6.tg_sw_3_3.SWP 1.71649f
C811 sar9b_0.net2 sar9b_0.net8 0.1282f
C812 a_13053_19450# sar9b_0.net1 0.27184f
C813 a_8545_25978# sar9b_0.net20 0.0109f
C814 a_6337_22714# sar9b_0.clk_div_0.COUNT\[0\] 0.06759f
C815 single_9b_cdac_1.CF[4] sar9b_0.net26 0.2311f
C816 VDPWR a_8637_23252# 0.57978f
C817 a_7145_23226# sar9b_0.clk_div_0.COUNT\[2\] 0.16729f
C818 single_9b_cdac_1.cdac_sw_9b_0.cdac_sw_3_0.tg_sw_3_3.SWN single_9b_cdac_1.cdac_sw_9b_0.cdac_sw_3_4.nooverlap_clk_0.CLKB0 0.01156f
C819 single_9b_cdac_0.cdac_sw_9b_0.cdac_sw_3_0.nooverlap_clk_0.CLKB0 single_9b_cdac_0.cdac_sw_9b_0.cdac_sw_3_4.nooverlap_clk_0.CLKB0 0.02513f
C820 single_9b_cdac_1.SW[1] a_57946_16877# 0.28324f
C821 a_5803_25428# sar9b_0.net3 0.3204f
C822 ui_in[0] th_dif_sw_0.VCN 0.22659f
C823 a_7919_23802# a_6149_23770# 0.01064f
C824 single_9b_cdac_1.cdac_sw_9b_0.cdac_sw_3_5.nooverlap_clk_0.x1.A single_9b_cdac_1.CF[5] 0.06503f
C825 single_9b_cdac_0.SW[2] a_14451_24340# 0.12321f
C826 a_11689_23770# sar9b_0.net13 0.02306f
C827 sar9b_0.net15 a_10196_21076# 0.23472f
C828 VDPWR a_13308_26516# 0.08228f
C829 a_13053_19450# a_13968_19822# 0.12532f
C830 single_9b_cdac_0.cdac_sw_9b_0.cdac_sw_3_7.tg_sw_3_3.SWN single_9b_cdac_0.cdac_sw_9b_0.cdac_sw_3_8.nooverlap_clk_0.CLKB0 0.01152f
C831 a_6960_26338# a_6539_25978# 0.09016f
C832 single_9b_cdac_0.cdac_sw_9b_0.cdac_sw_3_5.nooverlap_clk_0.x8.A VDPWR 0.84061f
C833 single_9b_cdac_1.cdac_sw_9b_0.cdac_sw_3_3.nooverlap_clk_0.x8.A single_9b_cdac_1.cdac_sw_9b_0.cdac_sw_3_3.nooverlap_clk_0.x10.A 0.42509f
C834 sar9b_0.net28 VDPWR 0.94455f
C835 a_12315_25972# a_11857_25978# 0.0329f
C836 single_9b_cdac_1.cdac_sw_9b_0.cdac_sw_3_0.nooverlap_clk_0.CLKB0 single_9b_cdac_1.cdac_sw_9b_0.cdac_sw_3_1.tg_sw_3_3.SWN 0.01198f
C837 sar9b_0.net40 single_9b_cdac_1.SW[4] 0.05604f
C838 single_9b_cdac_1.cdac_sw_9b_0.cdac_sw_3_0.nooverlap_clk_0.CLKB0 single_9b_cdac_1.CF[2] 0.26709f
C839 sar9b_0.net30 sar9b_0.net32 0.01355f
C840 single_9b_cdac_0.cdac_sw_9b_0.cdac_sw_3_1.nooverlap_clk_0.x6.A VDPWR 0.38397f
C841 uio_out[0] a_6094_27060# 0.01547f
C842 single_9b_cdac_1.cdac_sw_9b_0.cdac_sw_3_6.tg_sw_3_3.SWP a_33936_16877# 0.04592f
C843 single_9b_cdac_1.CF[5] sar9b_0.net12 0.02769f
C844 VDPWR sar9b_0.net29 0.61388f
C845 a_57946_26999# VDPWR 1.81495f
C846 single_9b_cdac_1.cdac_sw_9b_0.cdac_sw_3_3.tg_sw_3_3.SWP single_9b_cdac_1.cdac_sw_9b_0.cdac_sw_3_4.tg_sw_3_3.SWP 0.02652f
C847 single_9b_cdac_1.cdac_sw_9b_0.S[0] single_9b_cdac_1.cdac_sw_9b_0.cdac_sw_3_2.tg_sw_3_3.SWP 1.55982f
C848 ua[0] single_9b_cdac_1.cdac_sw_9b_0.S[5] 1.573f
C849 sar9b_0.net15 a_12211_18874# 0.27752f
C850 single_9b_cdac_1.cdac_sw_9b_0.cdac_sw_3_2.nooverlap_clk_0.x8.A single_9b_cdac_1.cdac_sw_9b_0.cdac_sw_3_2.nooverlap_clk_0.x1.A 0.42784f
C851 sar9b_0.net3 a_9175_27364# 0.36126f
C852 VDPWR sar9b_0.net2 4.04999f
C853 a_8545_25978# sar9b_0.net35 0.03421f
C854 a_6058_23618# sar9b_0.clknet_1_1__leaf_CLK 0.041f
C855 a_13968_23086# single_9b_cdac_1.CF[5] 0.01524f
C856 a_7325_26681# sar9b_0.net18 0.22216f
C857 single_9b_cdac_1.CF[8] single_9b_cdac_1.cdac_sw_9b_0.cdac_sw_3_8.nooverlap_clk_0.x8.A 0.31534f
C858 single_9b_cdac_1.cdac_sw_9b_0.cdac_sw_3_3.nooverlap_clk_0.CLKB0 single_9b_cdac_1.SW[0] 0.05632f
C859 single_9b_cdac_0.cdac_sw_9b_0.S[0] single_9b_cdac_0.cdac_sw_9b_0.S[7] 0.2766f
C860 sar9b_0._10_ sar9b_0.net3 0.16077f
C861 a_5487_27034# a_5968_27176# 0.04242f
C862 sar9b_0.net11 sar9b_0.net15 0.42836f
C863 a_5690_27192# a_6007_27302# 0.10236f
C864 a_8931_22164# a_9097_22164# 0.66687f
C865 sar9b_0.net7 a_13899_21620# 0.19067f
C866 sar9b_0.net41 sar9b_0.net12 0.30799f
C867 a_5435_26516# a_6691_26490# 0.04357f
C868 single_9b_cdac_1.CF[7] single_9b_cdac_0.cdac_sw_9b_0.cdac_sw_3_7.nooverlap_clk_0.sky130_fd_sc_hs__nand2_1_0.Y 0.17948f
C869 a_9635_24314# a_9460_24340# 0.23366f
C870 single_9b_cdac_1.CF[4] single_9b_cdac_1.CF[8] 0.01967f
C871 single_9b_cdac_1.cdac_sw_9b_0.cdac_sw_3_4.tg_sw_3_3.SWP single_9b_cdac_1.cdac_sw_9b_0.cdac_sw_3_4.tg_sw_3_3.SWN 3.10626f
C872 single_9b_cdac_1.cdac_sw_9b_0.cdac_sw_3_3.nooverlap_clk_0.CLK0 VDPWR 2.71729f
C873 sar9b_0.net15 a_13403_18900# 0.1876f
C874 sar9b_0.net43 a_11857_25978# 0.56055f
C875 VDPWR a_9843_19137# 0.21549f
C876 sar9b_0.FINAL a_13403_26516# 0.01841f
C877 uo_out[2] ui_in[0] 0.0679f
C878 sar9b_0.FINAL a_12207_26350# 0.0492f
C879 single_9b_cdac_1.cdac_sw_9b_0.cdac_sw_3_5.nooverlap_clk_0.CLK0 VDPWR 2.71729f
C880 single_9b_cdac_1.cdac_sw_9b_0.cdac_sw_3_1.nooverlap_clk_0.sky130_fd_sc_hs__inv_1_1.A single_9b_cdac_1.cdac_sw_9b_0.cdac_sw_3_1.nooverlap_clk_0.x1.A 0.10429f
C881 single_9b_cdac_0.cdac_sw_9b_0.cdac_sw_3_3.nooverlap_clk_0.x4.A single_9b_cdac_0.cdac_sw_9b_0.cdac_sw_3_3.nooverlap_clk_0.x6.A 0.12431f
C882 sar9b_0.net40 a_13899_20532# 0.18688f
C883 a_8453_19450# sar9b_0.net15 0.83891f
C884 single_9b_cdac_1.cdac_sw_9b_0.cdac_sw_3_5.nooverlap_clk_0.CLKB0 VDPWR 2.81428f
C885 single_9b_cdac_1.cdac_sw_9b_0.cdac_sw_3_1.tg_sw_3_3.SWN single_9b_cdac_1.cdac_sw_9b_0.cdac_sw_3_1.nooverlap_clk_0.CLKB0 0.22879f
C886 a_11397_20538# sar9b_0.net15 0.05884f
C887 a_9370_19152# a_9648_19168# 0.12532f
C888 sar9b_0.net40 sar9b_0.net8 0.04313f
C889 clk single_9b_cdac_1.CF[8] 0.08208f
C890 single_9b_cdac_1.CF[8] single_9b_cdac_0.cdac_sw_9b_0.cdac_sw_3_8.nooverlap_clk_0.sky130_fd_sc_hs__nand2_1_0.Y 0.17948f
C891 sar9b_0.net27 sar9b_0.net15 0.7314f
C892 single_9b_cdac_0.cdac_sw_9b_0.cdac_sw_3_4.nooverlap_clk_0.sky130_fd_sc_hs__nand2_1_0.Y single_9b_cdac_0.cdac_sw_9b_0.cdac_sw_3_4.nooverlap_clk_0.sky130_fd_sc_hs__inv_1_1.A 0.12223f
C893 a_7039_22138# sar9b_0._12_ 0.01228f
C894 single_9b_cdac_1.CF[4] single_9b_cdac_1.cdac_sw_9b_0.cdac_sw_3_3.nooverlap_clk_0.x1.A 0.06503f
C895 sar9b_0.net3 sar9b_0.net42 0.03175f
C896 single_9b_cdac_1.SW[8] a_13071_21620# 0.11004f
C897 a_13968_25428# single_9b_cdac_0.SW[6] 0.02356f
C898 single_9b_cdac_1.cdac_sw_9b_0.cdac_sw_3_0.nooverlap_clk_0.x8.A single_9b_cdac_1.cdac_sw_9b_0.cdac_sw_3_0.nooverlap_clk_0.sky130_fd_sc_hs__nand2_1_0.Y 0.26942f
C899 a_11689_19142# sar9b_0.net6 0.04567f
C900 sar9b_0.net11 single_9b_cdac_0.SW[0] 0.2011f
C901 a_11649_27279# sar9b_0.net23 0.22492f
C902 single_9b_cdac_1.SW[1] single_9b_cdac_1.CF[3] 0.22098f
C903 VDPWR a_11579_19266# 0.14636f
C904 uo_out[7] sar9b_0.net3 0.11763f
C905 a_8951_22950# a_8912_22824# 0.87924f
C906 single_9b_cdac_1.SW[8] single_9b_cdac_1.cdac_sw_9b_0.cdac_sw_3_8.nooverlap_clk_0.CLKB0 0.363f
C907 a_12961_23802# a_14051_24100# 0.04242f
C908 a_13529_23770# a_13311_24174# 0.20964f
C909 a_11413_25670# VDPWR 0.21589f
C910 a_11760_25428# sar9b_0.net13 0.06206f
C911 ua[0] single_9b_cdac_1.SW[7] 0.13071f
C912 single_9b_cdac_1.CF[4] single_9b_cdac_1.CF[6] 0.02231f
C913 single_9b_cdac_1.cdac_sw_9b_0.cdac_sw_3_4.nooverlap_clk_0.x8.A VDPWR 0.84042f
C914 a_9132_7271# th_dif_sw_0.th_sw_1.CK 2.28032f
C915 a_8085_23802# a_8783_23796# 0.19497f
C916 single_9b_cdac_0.cdac_sw_9b_0.cdac_sw_3_6.nooverlap_clk_0.CLK0 VDPWR 2.71729f
C917 a_9631_26516# sar9b_0.FINAL 0.03583f
C918 sar9b_0.net27 single_9b_cdac_0.SW[0] 0.07608f
C919 a_13140_18734# sar9b_0.net35 0.07329f
C920 a_5973_23252# sar9b_0._02_ 0.13563f
C921 ua[0] single_9b_cdac_0.cdac_sw_9b_0.cdac_sw_3_8.nooverlap_clk_0.CLKB0 0.13461f
C922 single_9b_cdac_0.SW[5] a_14451_25972# 0.11175f
C923 single_9b_cdac_1.cdac_sw_9b_0.cdac_sw_3_6.nooverlap_clk_0.x3.Y single_9b_cdac_1.cdac_sw_9b_0.cdac_sw_3_6.nooverlap_clk_0.x4.A 0.07517f
C924 sar9b_0._00_ sar9b_0._09_ 0.04225f
C925 single_9b_cdac_0.cdac_sw_9b_0.cdac_sw_3_7.nooverlap_clk_0.x1.A single_9b_cdac_0.cdac_sw_9b_0.cdac_sw_3_7.nooverlap_clk_0.x8.A 0.42784f
C926 a_6651_23520# VDPWR 0.39697f
C927 single_9b_cdac_0.cdac_sw_9b_0.cdac_sw_3_2.tg_sw_3_3.SWN VDPWR 2.82223f
C928 VDPWR single_9b_cdac_0.cdac_sw_9b_0.cdac_sw_3_6.nooverlap_clk_0.sky130_fd_sc_hs__inv_8_0.A 0.96901f
C929 a_5895_19988# sar9b_0._01_ 0.12192f
C930 clk single_9b_cdac_1.CF[6] 0.08196f
C931 single_9b_cdac_1.cdac_sw_9b_0.S[1] single_9b_cdac_1.cdac_sw_9b_0.cdac_sw_3_1.nooverlap_clk_0.CLKB0 0.3601f
C932 a_13379_27398# uo_out[1] 0.02551f
C933 ua[0] single_9b_cdac_1.cdac_sw_9b_0.S[0] 1.20078f
C934 single_9b_cdac_1.cdac_sw_9b_0.cdac_sw_3_7.tg_sw_3_3.SWN VDPWR 2.82172f
C935 single_9b_cdac_0.cdac_sw_9b_0.cdac_sw_3_5.nooverlap_clk_0.x1.A single_9b_cdac_0.cdac_sw_9b_0.cdac_sw_3_5.nooverlap_clk_0.x3.Y 0.07579f
C936 single_9b_cdac_0.cdac_sw_9b_0.cdac_sw_3_2.nooverlap_clk_0.x4.A single_9b_cdac_0.cdac_sw_9b_0.cdac_sw_3_2.nooverlap_clk_0.x8.A 0.0303f
C937 sar9b_0.net40 VDPWR 1.82514f
C938 single_9b_cdac_1.cdac_sw_9b_0.cdac_sw_3_1.tg_sw_3_3.SWN single_9b_cdac_1.cdac_sw_9b_0.cdac_sw_3_1.nooverlap_clk_0.CLK0 0.17533f
C939 single_9b_cdac_1.cdac_sw_9b_0.S[8] single_9b_cdac_1.cdac_sw_9b_0.cdac_sw_3_8.nooverlap_clk_0.CLK0 0.26427f
C940 a_8453_19450# a_8803_19822# 0.20669f
C941 sar9b_0.clk_div_0.COUNT\[1\] VDPWR 1.86193f
C942 a_8287_19450# a_9543_19748# 0.04348f
C943 sar9b_0.net37 a_14143_18874# 0.06995f
C944 single_9b_cdac_0.cdac_sw_9b_0.cdac_sw_3_6.nooverlap_clk_0.x8.A single_9b_cdac_0.cdac_sw_9b_0.cdac_sw_3_6.nooverlap_clk_0.x6.A 0.11216f
C945 uio_in[7] uio_in[6] 0.03102f
C946 single_9b_cdac_0.cdac_sw_9b_0.cdac_sw_3_8.nooverlap_clk_0.x8.A single_9b_cdac_0.cdac_sw_9b_0.cdac_sw_3_8.nooverlap_clk_0.sky130_fd_sc_hs__nand2_1_0.Y 0.26942f
C947 a_11231_20538# a_12487_20836# 0.04357f
C948 a_11397_20538# a_11747_20910# 0.20646f
C949 sar9b_0.net37 sar9b_0._08_ 0.11761f
C950 single_9b_cdac_0.cdac_sw_9b_0.cdac_sw_3_8.tg_sw_3_3.SWN m2_23774_26966# 0.26684f
C951 a_16331_9671# th_dif_sw_0.VCN 0.0647f
C952 a_9021_19418# sar9b_0.net4 0.0315f
C953 single_9b_cdac_0.cdac_sw_9b_0.S[8] single_9b_cdac_0.cdac_sw_9b_0.cdac_sw_3_8.nooverlap_clk_0.CLK0 0.26427f
C954 a_6226_23364# a_6058_23618# 0.23992f
C955 a_53154_16877# single_9b_cdac_1.cdac_sw_9b_0.cdac_sw_3_0.nooverlap_clk_0.CLKB0 0.23864f
C956 ua[1] w_17430_1606# 0.90873f
C957 single_9b_cdac_0.cdac_sw_9b_0.cdac_sw_3_4.nooverlap_clk_0.CLK0 single_9b_cdac_0.cdac_sw_9b_0.cdac_sw_3_4.tg_sw_3_3.SWN 0.17533f
C958 a_6047_26516# a_5951_26516# 0.01379f
C959 sar9b_0.net15 a_12683_18356# 0.0122f
C960 sar9b_0.net37 sar9b_0.net4 0.04582f
C961 single_9b_cdac_1.CF[4] single_9b_cdac_1.CF[7] 0.02099f
C962 VDPWR a_13403_26516# 0.20583f
C963 VDPWR a_12207_26350# 0.20349f
C964 a_14451_18356# single_9b_cdac_1.SW[1] 0.11083f
C965 a_6171_22714# VDPWR 0.45346f
C966 sar9b_0.clk_div_0.COUNT\[3\] sar9b_0.clknet_0_CLK 0.20427f
C967 a_10482_3438# VDPWR 0.07094f
C968 VDPWR single_9b_cdac_1.cdac_sw_9b_0.cdac_sw_3_0.nooverlap_clk_0.x8.A 0.84082f
C969 sar9b_0.net15 single_9b_cdac_0.SW[8] 0.03016f
C970 single_9b_cdac_0.cdac_sw_9b_0.cdac_sw_3_8.nooverlap_clk_0.sky130_fd_sc_hs__inv_8_0.A single_9b_cdac_0.cdac_sw_9b_0.cdac_sw_3_8.nooverlap_clk_0.CLKB0 0.6919f
C971 a_13899_21620# sar9b_0.net9 0.03381f
C972 single_9b_cdac_0.cdac_sw_9b_0.S[4] single_9b_cdac_0.cdac_sw_9b_0.S[0] 0.43802f
C973 VDPWR a_10771_22164# 0.4511f
C974 a_9635_24314# a_8379_24340# 0.04357f
C975 clk single_9b_cdac_1.CF[7] 0.08196f
C976 sar9b_0.net15 sar9b_0.net42 1.7973f
C977 single_9b_cdac_0.SW[2] sar9b_0.net26 0.05532f
C978 single_9b_cdac_0.cdac_sw_9b_0.cdac_sw_3_4.nooverlap_clk_0.sky130_fd_sc_hs__nand2_1_0.Y single_9b_cdac_0.cdac_sw_9b_0.cdac_sw_3_4.nooverlap_clk_0.x8.A 0.26942f
C979 sar9b_0.net2 sar9b_0.net36 0.22188f
C980 single_9b_cdac_1.cdac_sw_9b_0.cdac_sw_3_8.nooverlap_clk_0.x4.A single_9b_cdac_1.cdac_sw_9b_0.cdac_sw_3_8.nooverlap_clk_0.sky130_fd_sc_hs__nand2_1_0.Y 0.01751f
C981 VDPWR a_8431_22682# 0.36938f
C982 VDPWR a_12795_23802# 0.45419f
C983 sar9b_0.FINAL a_12211_26490# 0.01155f
C984 single_9b_cdac_0.cdac_sw_9b_0.cdac_sw_3_1.tg_sw_3_3.SWN single_9b_cdac_0.cdac_sw_9b_0.cdac_sw_3_0.tg_sw_3_3.SWN 0.02784f
C985 single_9b_cdac_1.cdac_sw_9b_0.S[1] single_9b_cdac_1.cdac_sw_9b_0.cdac_sw_3_1.nooverlap_clk_0.CLK0 0.26427f
C986 uio_out[1] sar9b_0.net3 0.16104f
C987 single_9b_cdac_1.CF[7] single_9b_cdac_0.cdac_sw_9b_0.cdac_sw_3_7.nooverlap_clk_0.x10.A 0.02149f
C988 a_13053_22714# a_13621_22682# 0.18639f
C989 a_13053_25428# sar9b_0.net33 0.26172f
C990 a_14175_21620# sar9b_0.net8 0.19401f
C991 a_54032_17740# single_9b_cdac_1.SW[2] 0.18991f
C992 single_9b_cdac_1.cdac_sw_9b_0.cdac_sw_3_4.tg_sw_3_3.SWP a_48343_16877# 0.04592f
C993 a_38738_16877# single_9b_cdac_1.cdac_sw_9b_0.S[5] 0.59531f
C994 sar9b_0.net16 th_dif_sw_0.CKB 0.01072f
C995 a_9205_23494# a_9095_23618# 0.09774f
C996 a_9727_23226# a_9552_23252# 0.23366f
C997 a_8987_23252# a_8892_23252# 0.04983f
C998 ua[1] th_dif_sw_0.VCN 3.30291f
C999 VDPWR a_9631_26516# 0.20456f
C1000 single_9b_cdac_1.cdac_sw_9b_0.cdac_sw_3_8.tg_sw_3_3.SWP VDPWR 3.26837f
C1001 single_9b_cdac_1.SW[0] a_14143_18874# 0.02681f
C1002 a_11689_23770# a_11471_24174# 0.20964f
C1003 a_11121_23802# a_12211_24100# 0.04242f
C1004 a_9648_19168# a_9988_19266# 0.03462f
C1005 single_9b_cdac_1.CF[4] single_9b_cdac_1.SW[4] 1.90184f
C1006 single_9b_cdac_0.SW[5] single_9b_cdac_0.SW[3] 0.02709f
C1007 single_9b_cdac_1.cdac_sw_9b_0.cdac_sw_3_2.nooverlap_clk_0.CLKB0 single_9b_cdac_1.cdac_sw_9b_0.S[0] 0.36044f
C1008 single_9b_cdac_1.CF[4] single_9b_cdac_1.SW[2] 0.01297f
C1009 ui_in[4] ui_in[3] 0.03102f
C1010 a_10955_26516# a_11121_26516# 0.58235f
C1011 sar9b_0.net37 single_9b_cdac_1.SW[0] 0.01793f
C1012 single_9b_cdac_0.cdac_sw_9b_0.cdac_sw_3_2.nooverlap_clk_0.x8.A single_9b_cdac_0.cdac_sw_9b_0.cdac_sw_3_2.nooverlap_clk_0.sky130_fd_sc_hs__inv_1_1.A 0.08121f
C1013 a_11397_20538# a_11652_20898# 0.05639f
C1014 VDPWR single_9b_cdac_0.cdac_sw_9b_0.cdac_sw_3_7.nooverlap_clk_0.sky130_fd_sc_hs__nand2_1_0.Y 0.62555f
C1015 clk single_9b_cdac_1.SW[4] 0.0853f
C1016 a_13968_21076# a_13053_21076# 0.12532f
C1017 a_13308_21076# a_12887_21076# 0.08638f
C1018 a_9175_27364# a_9809_27279# 0.01774f
C1019 clk single_9b_cdac_1.SW[2] 0.10884f
C1020 single_9b_cdac_1.cdac_sw_9b_0.cdac_sw_3_4.tg_sw_3_3.SWP single_9b_cdac_1.SW[3] 0.17185f
C1021 single_9b_cdac_1.cdac_sw_9b_0.cdac_sw_3_8.nooverlap_clk_0.sky130_fd_sc_hs__inv_8_0.A single_9b_cdac_1.cdac_sw_9b_0.cdac_sw_3_8.nooverlap_clk_0.x8.A 0.04988f
C1022 a_13403_23086# a_12887_22714# 0.11535f
C1023 a_11747_20910# sar9b_0.net42 0.03098f
C1024 VDPWR single_9b_cdac_0.cdac_sw_9b_0.cdac_sw_3_2.nooverlap_clk_0.x6.A 0.38397f
C1025 a_13403_19822# sar9b_0.net15 0.1569f
C1026 a_7919_27066# a_8085_27066# 0.61331f
C1027 tdc_0.delay_gate_ori_0.sky130_fd_sc_hs__and2_1_0.A a_15265_9613# 0.16728f
C1028 single_9b_cdac_0.SW[2] single_9b_cdac_1.CF[8] 0.016f
C1029 a_11045_19418# a_10827_19822# 0.20964f
C1030 a_14175_21620# VDPWR 0.19614f
C1031 sar9b_0._14_ sar9b_0._15_ 0.08045f
C1032 single_9b_cdac_1.SW[6] single_9b_cdac_1.SW[5] 8.06818f
C1033 sar9b_0.net2 sar9b_0.net10 0.10839f
C1034 single_9b_cdac_1.cdac_sw_9b_0.cdac_sw_3_2.tg_sw_3_3.SWP single_9b_cdac_1.cdac_sw_9b_0.cdac_sw_3_2.tg_sw_3_3.SWN 3.10626f
C1035 a_6907_19444# a_6759_20354# 0.01516f
C1036 sar9b_0.FINAL sar9b_0.net39 0.18329f
C1037 single_9b_cdac_1.SW[6] single_9b_cdac_1.SW[3] 0.07f
C1038 clk sar9b_0.FINAL 0.0412f
C1039 a_21368_4076# VDPWR 0.07474f
C1040 a_12793_18330# a_12575_18734# 0.20964f
C1041 a_12225_18362# a_13315_18660# 0.04188f
C1042 a_12059_18362# a_13140_18734# 0.10232f
C1043 a_10311_24890# sar9b_0.net41 0.01683f
C1044 uo_out[5] VDPWR 0.68912f
C1045 sar9b_0._04_ a_6337_22714# 0.26643f
C1046 sar9b_0.net40 a_13621_21318# 0.01323f
C1047 a_6502_20124# sar9b_0.net37 0.01624f
C1048 sar9b_0.net27 a_13621_22406# 0.01395f
C1049 a_57946_16877# single_9b_cdac_1.cdac_sw_9b_0.cdac_sw_3_1.nooverlap_clk_0.CLKB0 0.23864f
C1050 single_9b_cdac_1.cdac_sw_9b_0.cdac_sw_3_5.nooverlap_clk_0.sky130_fd_sc_hs__inv_1_1.A VDPWR 0.38716f
C1051 a_6315_21050# a_6674_21050# 0.14121f
C1052 clk a_9038_22708# 0.01523f
C1053 sar9b_0.net31 sar9b_0.net29 0.18682f
C1054 a_13053_24890# sar9b_0.net13 0.03469f
C1055 sar9b_0.net11 sar9b_0.net1 0.04673f
C1056 VDPWR a_12211_26490# 0.3423f
C1057 a_10935_23618# sar9b_0.net15 0.0122f
C1058 single_9b_cdac_1.cdac_sw_9b_0.cdac_sw_3_4.nooverlap_clk_0.sky130_fd_sc_hs__inv_8_0.A single_9b_cdac_1.cdac_sw_9b_0.cdac_sw_3_4.nooverlap_clk_0.x1.A 0.45521f
C1059 single_9b_cdac_1.cdac_sw_9b_0.S[3] single_9b_cdac_1.cdac_sw_9b_0.S[5] 0.97085f
C1060 a_5435_26516# a_5343_25972# 0.01109f
C1061 a_14143_23012# a_14143_22138# 0.02541f
C1062 a_12887_24890# a_13053_24890# 0.88541f
C1063 single_9b_cdac_1.cdac_sw_9b_0.S[4] single_9b_cdac_1.cdac_sw_9b_0.S[5] 18.9631f
C1064 a_13053_24890# a_13968_25262# 0.12532f
C1065 sar9b_0.net9 a_12887_22714# 0.30284f
C1066 sar9b_0.net40 a_9113_25946# 0.04303f
C1067 a_8379_25978# a_8895_26350# 0.10434f
C1068 single_9b_cdac_1.CF[0] single_9b_cdac_1.cdac_sw_9b_0.cdac_sw_3_2.nooverlap_clk_0.sky130_fd_sc_hs__inv_1_1.A 0.01887f
C1069 a_5863_19662# sar9b_0.clknet_1_0__leaf_CLK 0.23913f
C1070 sar9b_0.net8 sar9b_0.net39 0.04104f
C1071 VDPWR a_13403_19988# 0.1939f
C1072 single_9b_cdac_0.SW[2] single_9b_cdac_1.CF[6] 0.02024f
C1073 sar9b_0.clknet_1_0__leaf_CLK a_8637_20538# 0.01326f
C1074 a_14143_19748# a_14143_18874# 0.02541f
C1075 a_11691_25978# sar9b_0.net3 0.30563f
C1076 single_9b_cdac_1.SW[1] single_9b_cdac_1.CF[1] 1.81416f
C1077 a_7055_26350# a_7273_25946# 0.20964f
C1078 a_7795_26276# a_6705_25978# 0.04242f
C1079 single_9b_cdac_0.cdac_sw_9b_0.S[1] a_58824_26990# 0.22352f
C1080 a_7055_26350# sar9b_0.net3 0.17611f
C1081 a_13053_24890# a_13053_25428# 0.02783f
C1082 sar9b_0.net3 a_7273_25946# 0.17046f
C1083 a_11045_23494# VDPWR 0.21193f
C1084 th_dif_sw_0.CKB th_dif_sw_0.CK 0.08084f
C1085 a_13053_19450# a_13053_19988# 0.02783f
C1086 a_6943_22316# a_6679_22316# 0.14348f
C1087 sar9b_0._12_ VDPWR 1.49714f
C1088 ua[0] single_9b_cdac_0.cdac_sw_9b_0.cdac_sw_3_8.tg_sw_3_3.SWP 1.17995f
C1089 sar9b_0.net37 a_14143_19748# 0.02625f
C1090 a_13511_25794# VDPWR 0.13439f
C1091 single_9b_cdac_0.cdac_sw_9b_0.S[1] single_9b_cdac_0.cdac_sw_9b_0.S[8] 0.22526f
C1092 VDPWR single_9b_cdac_1.cdac_sw_9b_0.cdac_sw_3_8.nooverlap_clk_0.x8.A 0.84061f
C1093 a_7055_26350# sar9b_0.net19 0.01477f
C1094 a_13053_22714# VDPWR 0.48987f
C1095 single_9b_cdac_1.SW[7] single_9b_cdac_1.cdac_sw_9b_0.cdac_sw_3_7.nooverlap_clk_0.CLK0 0.24198f
C1096 single_9b_cdac_1.cdac_sw_9b_0.cdac_sw_3_4.nooverlap_clk_0.x3.Y single_9b_cdac_1.CF[3] 0.12898f
C1097 a_7273_25946# sar9b_0.net19 0.01864f
C1098 single_9b_cdac_0.cdac_sw_9b_0.cdac_sw_3_5.nooverlap_clk_0.x10.A single_9b_cdac_0.cdac_sw_9b_0.cdac_sw_3_5.nooverlap_clk_0.sky130_fd_sc_hs__inv_8_0.A 0.05105f
C1099 sar9b_0.net3 sar9b_0.net19 0.33424f
C1100 sar9b_0.clk_div_0.COUNT\[0\] a_6714_24340# 0.01111f
C1101 sar9b_0.net42 a_11652_20898# 0.02901f
C1102 single_9b_cdac_1.CF[4] VDPWR 2.55506f
C1103 a_13053_25428# a_13621_25670# 0.18098f
C1104 sar9b_0.net40 a_10187_22138# 0.07602f
C1105 single_9b_cdac_0.cdac_sw_9b_0.cdac_sw_3_2.nooverlap_clk_0.sky130_fd_sc_hs__inv_8_0.A single_9b_cdac_1.CF[0] 0.06019f
C1106 single_9b_cdac_0.SW[2] single_9b_cdac_1.CF[7] 0.02393f
C1107 single_9b_cdac_1.cdac_sw_9b_0.S[7] th_dif_sw_0.VCP 1.54513f
C1108 sar9b_0.net40 sar9b_0.net10 0.10672f
C1109 sar9b_0._07_ a_6859_21710# 0.04252f
C1110 VDPWR sar9b_0.net39 4.45384f
C1111 sar9b_0.net37 a_5619_23252# 0.03422f
C1112 sar9b_0.net30 single_9b_cdac_0.SW[8] 0.0305f
C1113 clk VDPWR 3.72644f
C1114 ua[0] single_9b_cdac_1.cdac_sw_9b_0.cdac_sw_3_2.tg_sw_3_3.SWN 3.10045f
C1115 VDPWR single_9b_cdac_0.cdac_sw_9b_0.cdac_sw_3_8.nooverlap_clk_0.sky130_fd_sc_hs__nand2_1_0.Y 0.62555f
C1116 single_9b_cdac_1.cdac_sw_9b_0.S[2] single_9b_cdac_1.cdac_sw_9b_0.cdac_sw_3_0.tg_sw_3_3.SWP 1.55946f
C1117 single_9b_cdac_1.CF[8] single_9b_cdac_0.cdac_sw_9b_0.cdac_sw_3_8.tg_sw_3_3.SWN 0.12358f
C1118 a_6451_21326# VDPWR 0.18469f
C1119 sar9b_0.net25 sar9b_0.net33 0.01645f
C1120 sar9b_0.net2 a_13053_18900# 0.23485f
C1121 a_8895_24340# a_9003_24706# 0.05722f
C1122 a_13308_21076# sar9b_0.net15 0.02765f
C1123 a_13403_25262# sar9b_0.net39 0.01169f
C1124 sar9b_0.net28 a_14143_23012# 0.01637f
C1125 VDPWR single_9b_cdac_0.cdac_sw_9b_0.cdac_sw_3_7.nooverlap_clk_0.x10.A 0.95338f
C1126 a_8931_22164# a_9665_22406# 0.05811f
C1127 single_9b_cdac_0.cdac_sw_9b_0.cdac_sw_3_6.nooverlap_clk_0.CLK0 single_9b_cdac_0.SW[6] 0.24443f
C1128 a_11567_23226# a_11392_23252# 0.23366f
C1129 sar9b_0.net15 a_12887_21076# 0.58868f
C1130 sar9b_0.net26 single_9b_cdac_1.SW[1] 0.02465f
C1131 a_5895_19988# a_6930_20241# 0.04869f
C1132 a_6061_19988# a_6343_20354# 0.15384f
C1133 a_14143_23012# sar9b_0.net29 0.03054f
C1134 single_9b_cdac_1.SW[7] single_9b_cdac_1.cdac_sw_9b_0.cdac_sw_3_7.tg_sw_3_3.SWP 0.17154f
C1135 sar9b_0.net3 a_9115_26516# 0.30478f
C1136 single_9b_cdac_1.cdac_sw_9b_0.S[3] single_9b_cdac_1.cdac_sw_9b_0.S[0] 0.47668f
C1137 a_13511_22708# a_13403_23086# 0.05722f
C1138 single_9b_cdac_0.SW[5] single_9b_cdac_0.cdac_sw_9b_0.cdac_sw_3_5.nooverlap_clk_0.CLK0 0.244f
C1139 a_11471_18900# a_11376_18900# 0.04983f
C1140 a_11689_19142# a_11579_19266# 0.09774f
C1141 a_8708_19810# VDPWR 0.07871f
C1142 single_9b_cdac_1.cdac_sw_9b_0.S[4] single_9b_cdac_1.cdac_sw_9b_0.S[0] 0.43802f
C1143 sar9b_0.net22 a_9635_26276# 0.06273f
C1144 single_9b_cdac_0.SW[7] single_9b_cdac_0.cdac_sw_9b_0.cdac_sw_3_8.nooverlap_clk_0.CLK0 0.02552f
C1145 sar9b_0.net10 a_10771_22164# 0.36726f
C1146 single_9b_cdac_0.cdac_sw_9b_0.cdac_sw_3_1.nooverlap_clk_0.x1.A single_9b_cdac_0.cdac_sw_9b_0.cdac_sw_3_1.nooverlap_clk_0.sky130_fd_sc_hs__nand2_1_0.Y 0.01003f
C1147 single_9b_cdac_1.SW[8] sar9b_0.net26 0.04421f
C1148 single_9b_cdac_1.cdac_sw_9b_0.cdac_sw_3_6.nooverlap_clk_0.CLKB0 single_9b_cdac_1.cdac_sw_9b_0.cdac_sw_3_7.nooverlap_clk_0.CLKB0 0.02632f
C1149 single_9b_cdac_0.cdac_sw_9b_0.cdac_sw_3_5.nooverlap_clk_0.x4.A VDPWR 0.62443f
C1150 single_9b_cdac_0.cdac_sw_9b_0.cdac_sw_3_3.nooverlap_clk_0.x1.A single_9b_cdac_0.cdac_sw_9b_0.cdac_sw_3_3.nooverlap_clk_0.x8.A 0.42784f
C1151 VDPWR a_6516_26516# 0.27606f
C1152 sar9b_0.net42 sar9b_0.net1 0.0328f
C1153 sar9b_0._03_ a_7919_23802# 0.07547f
C1154 sar9b_0.net10 a_12795_23802# 0.24542f
C1155 single_9b_cdac_0.cdac_sw_9b_0.cdac_sw_3_5.nooverlap_clk_0.sky130_fd_sc_hs__inv_1_1.A single_9b_cdac_0.cdac_sw_9b_0.cdac_sw_3_5.nooverlap_clk_0.x1.A 0.10429f
C1156 a_8895_24340# VDPWR 0.20649f
C1157 a_12211_21050# VDPWR 0.35549f
C1158 sar9b_0.net15 sar9b_0.net3 0.14557f
C1159 sar9b_0._10_ sar9b_0._02_ 0.11828f
C1160 uo_out[7] uo_out[6] 2.96309f
C1161 a_9738_20240# VDPWR 0.28023f
C1162 a_10016_20256# a_10142_20354# 0.18122f
C1163 a_10055_20130# a_10211_20225# 0.10751f
C1164 a_9167_18874# VDPWR 0.39373f
C1165 VDPWR a_13308_22164# 0.08234f
C1166 ua[0] single_9b_cdac_0.cdac_sw_9b_0.cdac_sw_3_2.nooverlap_clk_0.CLK0 0.11907f
C1167 a_13071_21620# sar9b_0.net5 0.03206f
C1168 tdc_0.phase_detector_0.INP a_15151_10456# 0.10793f
C1169 VDPWR single_9b_cdac_0.cdac_sw_9b_0.cdac_sw_3_4.nooverlap_clk_0.x6.A 0.38397f
C1170 a_14143_19962# single_9b_cdac_1.SW[3] 0.01251f
C1171 a_8471_20538# a_6701_20506# 0.01068f
C1172 a_13053_19450# a_13511_19444# 0.03462f
C1173 VDPWR a_16357_9613# 0.18873f
C1174 a_5863_19662# a_5870_19566# 0.97453f
C1175 single_9b_cdac_0.SW[5] th_dif_sw_0.VCN 0.09465f
C1176 a_10827_19822# a_10935_19444# 0.05722f
C1177 single_9b_cdac_0.cdac_sw_9b_0.cdac_sw_3_2.nooverlap_clk_0.sky130_fd_sc_hs__nand2_1_0.Y VDPWR 0.6205f
C1178 single_9b_cdac_1.SW[8] single_9b_cdac_1.cdac_sw_9b_0.cdac_sw_3_8.tg_sw_3_3.SWN 0.1495f
C1179 a_5969_25428# a_6224_25428# 0.06121f
C1180 a_11195_25428# a_11291_25428# 0.01379f
C1181 a_6537_25670# a_6884_25428# 0.05116f
C1182 single_9b_cdac_1.CF[8] single_9b_cdac_1.SW[1] 0.2162f
C1183 a_8471_20538# a_8910_20532# 0.27314f
C1184 a_8637_20538# a_9078_20506# 0.12497f
C1185 sar9b_0.net11 a_13511_24884# 0.02847f
C1186 single_9b_cdac_1.cdac_sw_9b_0.cdac_sw_3_2.nooverlap_clk_0.CLKB0 single_9b_cdac_1.cdac_sw_9b_0.cdac_sw_3_2.tg_sw_3_3.SWN 0.22879f
C1187 a_9281_26516# a_9739_26882# 0.03462f
C1188 a_9132_7271# th_dif_sw_0.th_sw_1.CKB 0.01594f
C1189 sar9b_0._06_ sar9b_0._15_ 0.10248f
C1190 single_9b_cdac_1.cdac_sw_9b_0.cdac_sw_3_6.nooverlap_clk_0.x8.A single_9b_cdac_1.cdac_sw_9b_0.cdac_sw_3_6.nooverlap_clk_0.x10.A 0.42509f
C1191 single_9b_cdac_0.cdac_sw_9b_0.cdac_sw_3_3.nooverlap_clk_0.x8.A single_9b_cdac_0.cdac_sw_9b_0.cdac_sw_3_3.nooverlap_clk_0.sky130_fd_sc_hs__nand2_1_0.Y 0.26942f
C1192 th_dif_sw_0.CKB VDPWR 1.24724f
C1193 a_48343_26999# VDPWR 1.81495f
C1194 single_9b_cdac_1.SW[8] single_9b_cdac_1.CF[8] 2.12011f
C1195 a_13308_25250# sar9b_0.net1 0.15827f
C1196 single_9b_cdac_0.cdac_sw_9b_0.cdac_sw_3_1.tg_sw_3_3.SWN single_9b_cdac_0.cdac_sw_9b_0.cdac_sw_3_2.tg_sw_3_3.SWN 0.02638f
C1197 a_9631_21076# a_9727_21076# 0.01379f
C1198 a_9670_22708# a_8951_22950# 0.08561f
C1199 sar9b_0.net15 a_12027_22138# 0.27399f
C1200 a_8379_25978# a_8800_26338# 0.08341f
C1201 VDPWR a_8987_23252# 0.19851f
C1202 single_9b_cdac_1.CF[6] single_9b_cdac_0.cdac_sw_9b_0.cdac_sw_3_6.nooverlap_clk_0.x4.A 0.0313f
C1203 a_8637_20538# sar9b_0.net38 0.01697f
C1204 single_9b_cdac_0.cdac_sw_9b_0.cdac_sw_3_1.nooverlap_clk_0.sky130_fd_sc_hs__inv_8_0.A single_9b_cdac_1.CF[1] 0.06019f
C1205 a_33936_16877# VDPWR 1.81495f
C1206 single_9b_cdac_0.cdac_sw_9b_0.cdac_sw_3_0.nooverlap_clk_0.x8.A single_9b_cdac_0.cdac_sw_9b_0.cdac_sw_3_0.nooverlap_clk_0.sky130_fd_sc_hs__nand2_1_0.Y 0.26942f
C1207 VDPWR a_11121_23802# 0.64532f
C1208 single_9b_cdac_0.cdac_sw_9b_0.cdac_sw_3_0.nooverlap_clk_0.x1.A single_9b_cdac_0.cdac_sw_9b_0.cdac_sw_3_0.nooverlap_clk_0.x4.A 0.28523f
C1209 a_12211_24100# sar9b_0.net13 0.01647f
C1210 sar9b_0.net15 a_9739_21442# 0.01227f
C1211 single_9b_cdac_0.cdac_sw_9b_0.S[2] single_9b_cdac_0.cdac_sw_9b_0.S[7] 0.245f
C1212 a_13621_21318# sar9b_0.net39 0.01415f
C1213 sar9b_0.net7 a_12312_20910# 0.01477f
C1214 single_9b_cdac_0.cdac_sw_9b_0.cdac_sw_3_6.nooverlap_clk_0.x1.A single_9b_cdac_0.cdac_sw_9b_0.cdac_sw_3_6.nooverlap_clk_0.sky130_fd_sc_hs__inv_8_0.A 0.45521f
C1215 single_9b_cdac_0.SW[7] a_14175_25972# 0.01087f
C1216 single_9b_cdac_0.cdac_sw_9b_0.cdac_sw_3_7.nooverlap_clk_0.x4.A single_9b_cdac_0.cdac_sw_9b_0.cdac_sw_3_7.nooverlap_clk_0.x8.A 0.0303f
C1217 sar9b_0._01_ sar9b_0._08_ 0.04258f
C1218 sar9b_0.net34 single_9b_cdac_0.SW[8] 0.13267f
C1219 single_9b_cdac_1.SW[1] single_9b_cdac_1.CF[6] 0.22097f
C1220 single_9b_cdac_0.cdac_sw_9b_0.cdac_sw_3_3.tg_sw_3_3.SWP VDPWR 3.27795f
C1221 single_9b_cdac_1.cdac_sw_9b_0.cdac_sw_3_3.nooverlap_clk_0.x1.A single_9b_cdac_1.cdac_sw_9b_0.cdac_sw_3_3.nooverlap_clk_0.x10.A 0.05472f
C1222 ua[0] single_9b_cdac_1.cdac_sw_9b_0.S[7] 2.03301f
C1223 a_12315_25972# a_12207_26350# 0.05722f
C1224 single_9b_cdac_0.cdac_sw_9b_0.cdac_sw_3_0.nooverlap_clk_0.sky130_fd_sc_hs__inv_8_0.A single_9b_cdac_0.cdac_sw_9b_0.cdac_sw_3_0.nooverlap_clk_0.CLKB0 0.6919f
C1225 a_11935_25402# sar9b_0.FINAL 0.11093f
C1226 a_29134_26999# single_9b_cdac_0.cdac_sw_9b_0.cdac_sw_3_7.nooverlap_clk_0.CLKB0 0.23864f
C1227 sar9b_0._01_ sar9b_0.net37 0.3479f
C1228 single_9b_cdac_1.CF[4] single_9b_cdac_0.cdac_sw_9b_0.S[3] 0.01514f
C1229 single_9b_cdac_1.cdac_sw_9b_0.cdac_sw_3_5.tg_sw_3_3.SWP single_9b_cdac_1.cdac_sw_9b_0.cdac_sw_3_5.tg_sw_3_3.SWN 3.10626f
C1230 single_9b_cdac_1.cdac_sw_9b_0.cdac_sw_3_7.nooverlap_clk_0.x8.A single_9b_cdac_1.cdac_sw_9b_0.cdac_sw_3_7.nooverlap_clk_0.sky130_fd_sc_hs__inv_1_1.A 0.08121f
C1231 a_12225_18362# VDPWR 0.2546f
C1232 uo_out[1] uo_out[0] 2.97285f
C1233 a_6539_25978# sar9b_0.net38 0.61762f
C1234 single_9b_cdac_1.cdac_sw_9b_0.cdac_sw_3_8.nooverlap_clk_0.CLKB0 single_9b_cdac_1.cdac_sw_9b_0.cdac_sw_3_7.nooverlap_clk_0.CLKB0 0.02632f
C1235 sar9b_0.net40 sar9b_0.net43 0.20555f
C1236 sar9b_0.net3 a_9809_27279# 0.03853f
C1237 a_13347_20532# sar9b_0.net5 0.01091f
C1238 a_8895_26350# sar9b_0.net35 0.01255f
C1239 single_9b_cdac_1.CF[6] sar9b_0.net13 0.07095f
C1240 single_9b_cdac_0.SW[2] VDPWR 2.19884f
C1241 a_9097_22164# sar9b_0.net38 0.03982f
C1242 VDPWR single_9b_cdac_0.cdac_sw_9b_0.cdac_sw_3_0.nooverlap_clk_0.x4.A 0.62443f
C1243 single_9b_cdac_0.cdac_sw_9b_0.cdac_sw_3_4.nooverlap_clk_0.CLKB0 single_9b_cdac_0.cdac_sw_9b_0.cdac_sw_3_4.nooverlap_clk_0.sky130_fd_sc_hs__inv_8_0.A 0.6919f
C1244 a_62748_16877# VDPWR 1.81495f
C1245 single_9b_cdac_0.SW[0] sar9b_0.net15 0.19877f
C1246 single_9b_cdac_1.cdac_sw_9b_0.cdac_sw_3_0.tg_sw_3_3.SWN single_9b_cdac_1.cdac_sw_9b_0.S[2] 0.84424f
C1247 single_9b_cdac_1.CF[8] single_9b_cdac_1.cdac_sw_9b_0.cdac_sw_3_8.nooverlap_clk_0.x1.A 0.06503f
C1248 sar9b_0._12_ sar9b_0.net10 0.01867f
C1249 sar9b_0.net3 a_5968_27176# 0.05482f
C1250 single_9b_cdac_1.CF[4] single_9b_cdac_0.cdac_sw_9b_0.cdac_sw_3_3.nooverlap_clk_0.x10.A 0.02149f
C1251 single_9b_cdac_1.cdac_sw_9b_0.cdac_sw_3_1.nooverlap_clk_0.sky130_fd_sc_hs__inv_8_0.A single_9b_cdac_1.cdac_sw_9b_0.cdac_sw_3_1.nooverlap_clk_0.CLKB0 0.6919f
C1252 a_10679_25428# sar9b_0.net42 0.03993f
C1253 sar9b_0.net4 a_7735_17812# 0.16848f
C1254 single_9b_cdac_1.CF[7] single_9b_cdac_1.SW[1] 0.22097f
C1255 a_13623_21620# sar9b_0.net7 0.064f
C1256 single_9b_cdac_0.cdac_sw_9b_0.cdac_sw_3_5.tg_sw_3_3.SWP single_9b_cdac_0.cdac_sw_9b_0.cdac_sw_3_6.tg_sw_3_3.SWP 0.02666f
C1257 single_9b_cdac_1.CF[0] single_9b_cdac_1.cdac_sw_9b_0.cdac_sw_3_2.nooverlap_clk_0.sky130_fd_sc_hs__inv_8_0.A 0.06019f
C1258 uio_out[0] a_6516_26516# 0.05222f
C1259 sar9b_0.net37 sar9b_0.net41 0.37412f
C1260 ua[0] single_9b_cdac_1.cdac_sw_9b_0.cdac_sw_3_3.nooverlap_clk_0.CLKB0 0.12358f
C1261 sar9b_0.net4 sar9b_0.net41 1.29763f
C1262 sar9b_0.net15 a_13968_18900# 0.30634f
C1263 sar9b_0.net38 a_8912_22824# 0.03715f
C1264 sar9b_0.net43 a_12207_26350# 0.02803f
C1265 ua[0] single_9b_cdac_0.cdac_sw_9b_0.cdac_sw_3_0.nooverlap_clk_0.CLK0 0.12088f
C1266 single_9b_cdac_1.SW[6] a_14175_20532# 0.11564f
C1267 a_59529_29917# single_9b_cdac_0.cdac_sw_9b_0.cdac_sw_3_1.nooverlap_clk_0.x4.A 0.01076f
C1268 a_8803_19822# sar9b_0.net15 0.18781f
C1269 single_9b_cdac_1.SW[5] th_dif_sw_0.VCN 0.09453f
C1270 a_16222_11316# VDPWR 0.52162f
C1271 single_9b_cdac_1.cdac_sw_9b_0.cdac_sw_3_4.tg_sw_3_3.SWN single_9b_cdac_1.CF[3] 0.12359f
C1272 a_11747_20910# sar9b_0.net15 0.16895f
C1273 a_14451_23252# sar9b_0.net29 0.02097f
C1274 single_9b_cdac_1.SW[3] th_dif_sw_0.VCN 0.09465f
C1275 sar9b_0.clk_div_0.COUNT\[3\] sar9b_0._12_ 0.49586f
C1276 a_13347_20532# sar9b_0.net38 0.18483f
C1277 sar9b_0.net10 sar9b_0.net39 0.02158f
C1278 single_9b_cdac_1.CF[7] single_9b_cdac_1.cdac_sw_9b_0.cdac_sw_3_7.nooverlap_clk_0.sky130_fd_sc_hs__inv_8_0.A 0.06019f
C1279 clk sar9b_0.net10 0.03867f
C1280 sar9b_0._11_ a_6149_23770# 0.05234f
C1281 single_9b_cdac_1.CF[7] sar9b_0.net13 0.0857f
C1282 a_12795_23802# sar9b_0.net43 0.10386f
C1283 a_13071_20532# single_9b_cdac_1.SW[2] 0.10835f
C1284 sar9b_0.net3 a_5601_26516# 0.027f
C1285 single_9b_cdac_1.cdac_sw_9b_0.cdac_sw_3_0.nooverlap_clk_0.x1.A single_9b_cdac_1.cdac_sw_9b_0.cdac_sw_3_0.nooverlap_clk_0.sky130_fd_sc_hs__nand2_1_0.Y 0.01003f
C1286 a_12211_18874# sar9b_0.net6 0.04111f
C1287 a_10937_22164# sar9b_0.net9 0.74109f
C1288 VDPWR sar9b_0.clknet_1_1__leaf_CLK 2.57441f
C1289 a_29134_16877# single_9b_cdac_1.cdac_sw_9b_0.cdac_sw_3_7.nooverlap_clk_0.CLKB0 0.23864f
C1290 single_9b_cdac_1.cdac_sw_9b_0.cdac_sw_3_3.nooverlap_clk_0.sky130_fd_sc_hs__nand2_1_0.Y single_9b_cdac_1.cdac_sw_9b_0.cdac_sw_3_3.nooverlap_clk_0.sky130_fd_sc_hs__inv_1_1.A 0.12223f
C1291 single_9b_cdac_1.CF[1] single_9b_cdac_1.cdac_sw_9b_0.cdac_sw_3_1.nooverlap_clk_0.CLKB0 0.26707f
C1292 single_9b_cdac_1.SW[0] single_9b_cdac_1.cdac_sw_9b_0.cdac_sw_3_0.nooverlap_clk_0.CLK0 0.03931f
C1293 single_9b_cdac_1.SW[5] single_9b_cdac_1.CF[0] 0.56253f
C1294 VDPWR a_7345_21594# 1.30101f
C1295 a_10477_24890# a_10732_25250# 0.05936f
C1296 a_13308_21076# sar9b_0.net1 0.15972f
C1297 single_9b_cdac_1.SW[3] single_9b_cdac_1.CF[0] 0.37966f
C1298 a_8951_22950# a_9038_22708# 0.07009f
C1299 a_8912_22824# a_9107_22682# 0.2298f
C1300 single_9b_cdac_1.SW[0] single_9b_cdac_1.CF[5] 0.22459f
C1301 a_13403_25428# sar9b_0.net15 0.18928f
C1302 a_5579_19676# VDPWR 0.21972f
C1303 single_9b_cdac_1.cdac_sw_9b_0.cdac_sw_3_4.nooverlap_clk_0.x6.A VDPWR 0.38397f
C1304 a_11935_25402# VDPWR 0.45036f
C1305 single_9b_cdac_1.cdac_sw_9b_0.cdac_sw_3_5.nooverlap_clk_0.CLK0 single_9b_cdac_1.cdac_sw_9b_0.cdac_sw_3_6.nooverlap_clk_0.CLK0 0.02632f
C1306 single_9b_cdac_0.cdac_sw_9b_0.cdac_sw_3_0.tg_sw_3_3.SWN single_9b_cdac_0.cdac_sw_9b_0.cdac_sw_3_4.tg_sw_3_3.SWN 0.02519f
C1307 a_6537_25670# VDPWR 0.22486f
C1308 a_12887_21076# sar9b_0.net1 0.18688f
C1309 single_9b_cdac_1.cdac_sw_9b_0.cdac_sw_3_4.nooverlap_clk_0.x1.A VDPWR 0.75815f
C1310 a_8471_20538# VDPWR 0.70823f
C1311 VDPWR a_11303_25794# 0.14384f
C1312 a_24332_16877# VDPWR 1.81495f
C1313 a_10196_26516# sar9b_0.FINAL 0.04636f
C1314 single_9b_cdac_1.SW[1] single_9b_cdac_1.SW[4] 0.218f
C1315 single_9b_cdac_1.CF[4] single_9b_cdac_0.SW[4] 1.90123f
C1316 single_9b_cdac_0.cdac_sw_9b_0.S[4] single_9b_cdac_0.cdac_sw_9b_0.S[2] 0.27936f
C1317 clk single_9b_cdac_0.SW[6] 0.10884f
C1318 single_9b_cdac_1.SW[1] single_9b_cdac_1.SW[2] 16.6551f
C1319 a_6960_26338# VDPWR 0.07683f
C1320 a_7145_23226# VDPWR 0.20389f
C1321 a_13053_22714# a_13308_23074# 0.06418f
C1322 single_9b_cdac_0.cdac_sw_9b_0.cdac_sw_3_2.nooverlap_clk_0.x4.A single_9b_cdac_0.cdac_sw_9b_0.cdac_sw_3_2.nooverlap_clk_0.x6.A 0.12431f
C1323 single_9b_cdac_0.cdac_sw_9b_0.cdac_sw_3_8.nooverlap_clk_0.x10.A single_9b_cdac_0.cdac_sw_9b_0.cdac_sw_3_8.tg_sw_3_3.SWN 0.69086f
C1324 a_8453_19450# a_9368_19822# 0.11876f
C1325 single_9b_cdac_0.cdac_sw_9b_0.cdac_sw_3_7.nooverlap_clk_0.CLK0 a_30012_26990# 0.14695f
C1326 clk single_9b_cdac_0.SW[4] 0.0853f
C1327 single_9b_cdac_1.SW[8] single_9b_cdac_1.SW[4] 0.07308f
C1328 single_9b_cdac_1.SW[0] single_9b_cdac_1.cdac_sw_9b_0.cdac_sw_3_6.tg_sw_3_3.SWN 0.12586f
C1329 single_9b_cdac_1.SW[8] single_9b_cdac_1.SW[2] 0.224f
C1330 single_9b_cdac_0.cdac_sw_9b_0.cdac_sw_3_5.nooverlap_clk_0.CLKB0 single_9b_cdac_0.cdac_sw_9b_0.cdac_sw_3_5.nooverlap_clk_0.CLK0 2.7611f
C1331 uo_out[6] sar9b_0.net3 0.06122f
C1332 a_48343_26999# single_9b_cdac_0.cdac_sw_9b_0.S[3] 0.59531f
C1333 VDPWR a_5945_26191# 0.28994f
C1334 a_14143_21050# sar9b_0.net28 0.0999f
C1335 sar9b_0.net3 sar9b_0.net1 0.07008f
C1336 single_9b_cdac_0.cdac_sw_9b_0.cdac_sw_3_8.tg_sw_3_3.SWN VDPWR 2.824f
C1337 a_9543_19748# sar9b_0.net4 0.08238f
C1338 sar9b_0.net8 a_13071_20532# 0.11023f
C1339 a_12487_20836# sar9b_0.net37 0.03506f
C1340 sar9b_0.net27 a_13053_19988# 0.03505f
C1341 sar9b_0.net37 a_12887_19988# 0.03683f
C1342 single_9b_cdac_1.CF[1] single_9b_cdac_1.cdac_sw_9b_0.cdac_sw_3_1.nooverlap_clk_0.CLK0 0.42014f
C1343 a_13308_23074# sar9b_0.net39 0.0135f
C1344 single_9b_cdac_1.CF[4] single_9b_cdac_0.cdac_sw_9b_0.cdac_sw_3_3.nooverlap_clk_0.CLK0 0.42014f
C1345 a_6319_25428# a_6415_25428# 0.01379f
C1346 a_8931_22164# VDPWR 0.43481f
C1347 VDPWR a_13968_26516# 0.29688f
C1348 VDPWR a_12772_26350# 0.2954f
C1349 single_9b_cdac_0.SW[5] sar9b_0.net33 0.02907f
C1350 single_9b_cdac_0.cdac_sw_9b_0.cdac_sw_3_4.nooverlap_clk_0.x1.A single_9b_cdac_0.cdac_sw_9b_0.cdac_sw_3_4.nooverlap_clk_0.x6.A 0.03729f
C1351 a_12225_18362# sar9b_0.net36 0.02221f
C1352 a_10477_23252# sar9b_0.net12 0.61918f
C1353 a_8800_26338# sar9b_0.net20 0.01698f
C1354 single_9b_cdac_0.cdac_sw_9b_0.cdac_sw_3_5.nooverlap_clk_0.CLK0 a_39616_26990# 0.14695f
C1355 sar9b_0.net17 sar9b_0.FINAL 0.10582f
C1356 VDPWR single_9b_cdac_1.cdac_sw_9b_0.cdac_sw_3_0.nooverlap_clk_0.x1.A 0.75899f
C1357 sar9b_0.FINAL sar9b_0.net13 0.49715f
C1358 a_13308_25428# sar9b_0.net12 0.01419f
C1359 a_14451_21620# sar9b_0.net9 0.20287f
C1360 VDPWR a_11505_22406# 0.22753f
C1361 sar9b_0.net22 sar9b_0.net42 0.03653f
C1362 a_13623_21620# sar9b_0.net9 0.03429f
C1363 single_9b_cdac_1.cdac_sw_9b_0.cdac_sw_3_5.nooverlap_clk_0.x3.Y single_9b_cdac_1.CF[5] 0.12898f
C1364 single_9b_cdac_0.cdac_sw_9b_0.cdac_sw_3_6.nooverlap_clk_0.CLK0 single_9b_cdac_0.cdac_sw_9b_0.cdac_sw_3_6.nooverlap_clk_0.CLKB0 2.7611f
C1365 a_13308_19988# sar9b_0.net38 0.01212f
C1366 VDPWR a_8951_22950# 0.48546f
C1367 a_13968_19988# single_9b_cdac_1.SW[4] 0.01368f
C1368 VDPWR a_13529_23770# 0.2111f
C1369 sar9b_0.FINAL a_11376_26516# 0.01509f
C1370 a_33936_16877# single_9b_cdac_1.cdac_sw_9b_0.S[6] 0.59531f
C1371 single_9b_cdac_0.cdac_sw_9b_0.cdac_sw_3_6.nooverlap_clk_0.sky130_fd_sc_hs__inv_8_0.A single_9b_cdac_0.cdac_sw_9b_0.cdac_sw_3_6.nooverlap_clk_0.CLKB0 0.6919f
C1372 a_14175_18356# VDPWR 0.26518f
C1373 single_9b_cdac_0.cdac_sw_9b_0.cdac_sw_3_4.nooverlap_clk_0.sky130_fd_sc_hs__inv_8_0.A single_9b_cdac_1.CF[3] 0.06019f
C1374 sar9b_0.net15 a_13621_22406# 0.17746f
C1375 a_13053_22714# a_14143_23012# 0.04242f
C1376 single_9b_cdac_1.SW[8] sar9b_0.net8 0.06051f
C1377 VDPWR a_13071_20532# 0.19313f
C1378 VDPWR a_13876_24174# 0.29723f
C1379 a_8287_19450# sar9b_0.net35 0.03358f
C1380 sar9b_0.net7 a_12036_21076# 0.0641f
C1381 a_6226_23364# VDPWR 0.1863f
C1382 a_8637_20538# sar9b_0._05_ 0.21117f
C1383 single_9b_cdac_0.cdac_sw_9b_0.S[0] single_9b_cdac_0.cdac_sw_9b_0.cdac_sw_3_2.nooverlap_clk_0.CLK0 0.28813f
C1384 a_13053_25428# sar9b_0.FINAL 0.28865f
C1385 VDPWR a_10196_26516# 0.2928f
C1386 single_9b_cdac_1.cdac_sw_9b_0.cdac_sw_3_1.nooverlap_clk_0.sky130_fd_sc_hs__inv_1_1.A single_9b_cdac_1.CF[1] 0.01887f
C1387 sar9b_0.clk_div_0.COUNT\[1\] a_8085_23802# 0.18561f
C1388 a_11689_23770# a_12036_24174# 0.05116f
C1389 a_10955_21076# VDPWR 0.44102f
C1390 VDPWR single_9b_cdac_0.cdac_sw_9b_0.cdac_sw_3_6.nooverlap_clk_0.x4.A 0.62443f
C1391 single_9b_cdac_1.SW[0] single_9b_cdac_1.cdac_sw_9b_0.cdac_sw_3_2.tg_sw_3_3.SWP 0.17717f
C1392 single_9b_cdac_0.cdac_sw_9b_0.cdac_sw_3_3.nooverlap_clk_0.x1.A single_9b_cdac_0.cdac_sw_9b_0.cdac_sw_3_3.nooverlap_clk_0.sky130_fd_sc_hs__nand2_1_0.Y 0.01003f
C1393 a_12937_27279# sar9b_0.net39 0.02835f
C1394 ua[0] single_9b_cdac_0.cdac_sw_9b_0.S[8] 16.3985f
C1395 a_10955_26516# a_11471_26516# 0.11082f
C1396 a_8545_24340# sar9b_0.net11 0.28352f
C1397 single_9b_cdac_1.cdac_sw_9b_0.cdac_sw_3_7.nooverlap_clk_0.CLK0 single_9b_cdac_1.cdac_sw_9b_0.S[7] 0.28813f
C1398 single_9b_cdac_0.SW[0] sar9b_0.net30 0.03125f
C1399 a_13403_21076# a_13499_21076# 0.01379f
C1400 single_9b_cdac_1.SW[1] VDPWR 2.32102f
C1401 sar9b_0.net15 sar9b_0.net1 0.36887f
C1402 a_11747_20910# a_11652_20898# 0.04983f
C1403 single_9b_cdac_1.CF[2] sar9b_0.net9 0.05843f
C1404 a_13216_24162# sar9b_0.net12 0.01042f
C1405 sar9b_0.clknet_1_1__leaf_CLK sar9b_0.net36 0.04301f
C1406 sar9b_0.net42 sar9b_0.net6 0.02258f
C1407 a_13511_21442# a_13053_21076# 0.03063f
C1408 single_9b_cdac_1.cdac_sw_9b_0.cdac_sw_3_8.nooverlap_clk_0.sky130_fd_sc_hs__inv_8_0.A single_9b_cdac_1.cdac_sw_9b_0.cdac_sw_3_8.nooverlap_clk_0.x1.A 0.45521f
C1409 a_13968_23086# a_12887_22714# 0.10236f
C1410 single_9b_cdac_0.cdac_sw_9b_0.cdac_sw_3_7.nooverlap_clk_0.CLK0 single_9b_cdac_0.cdac_sw_9b_0.S[7] 0.28813f
C1411 a_7919_27066# a_8435_27438# 0.10599f
C1412 sar9b_0.net39 a_8653_27034# 0.04363f
C1413 a_13968_19822# sar9b_0.net15 0.26438f
C1414 sar9b_0.net2 a_9352_22164# 0.15725f
C1415 sar9b_0._13_ sar9b_0.net3 0.44342f
C1416 a_5579_19676# sar9b_0.net36 0.01742f
C1417 sar9b_0.net27 a_12887_22164# 0.03063f
C1418 clk a_8653_27034# 0.01224f
C1419 a_16222_11316# tdc_0.phase_detector_0.pd_out_0.A 0.48692f
C1420 ua[0] single_9b_cdac_0.cdac_sw_9b_0.cdac_sw_3_8.nooverlap_clk_0.CLK0 0.13178f
C1421 single_9b_cdac_0.cdac_sw_9b_0.cdac_sw_3_7.nooverlap_clk_0.x4.A single_9b_cdac_0.cdac_sw_9b_0.cdac_sw_3_7.nooverlap_clk_0.x1.A 0.28523f
C1422 single_9b_cdac_1.SW[8] VDPWR 2.17836f
C1423 single_9b_cdac_1.cdac_sw_9b_0.cdac_sw_3_3.nooverlap_clk_0.x10.A VDPWR 0.95338f
C1424 a_12887_26516# a_13899_25972# 0.01008f
C1425 single_9b_cdac_1.SW[3] single_9b_cdac_1.CF[3] 1.84733f
C1426 sar9b_0.net37 a_6149_23770# 0.03783f
C1427 sar9b_0.net7 single_9b_cdac_1.CF[0] 0.02531f
C1428 single_9b_cdac_1.cdac_sw_9b_0.cdac_sw_3_5.nooverlap_clk_0.x10.A VDPWR 0.95338f
C1429 single_9b_cdac_1.cdac_sw_9b_0.cdac_sw_3_7.nooverlap_clk_0.sky130_fd_sc_hs__inv_8_0.A VDPWR 0.96907f
C1430 sar9b_0.net17 VDPWR 0.67523f
C1431 a_18214_3039# VDPWR 0.51112f
C1432 VDPWR sar9b_0.net13 1.78571f
C1433 a_12793_18330# a_13140_18734# 0.05116f
C1434 a_10311_23252# sar9b_0.net42 0.01408f
C1435 single_9b_cdac_0.cdac_sw_9b_0.cdac_sw_3_6.nooverlap_clk_0.x8.A single_9b_cdac_0.cdac_sw_9b_0.cdac_sw_3_6.nooverlap_clk_0.sky130_fd_sc_hs__inv_8_0.A 0.04988f
C1436 a_6930_20241# sar9b_0.net37 0.05599f
C1437 a_6315_21050# VDPWR 0.19126f
C1438 single_9b_cdac_1.cdac_sw_9b_0.S[3] single_9b_cdac_1.cdac_sw_9b_0.S[7] 0.45223f
C1439 tdc_0.phase_detector_0.INN clk 0.04168f
C1440 single_9b_cdac_1.cdac_sw_9b_0.S[4] single_9b_cdac_1.cdac_sw_9b_0.S[7] 1.63295f
C1441 tdc_0.delay_gate_ori_0.sky130_fd_sc_hs__and2_1_0.A a_14871_9671# 0.18915f
C1442 a_6007_27302# a_6163_27034# 0.10748f
C1443 a_6679_22316# a_6973_22414# 0.0111f
C1444 a_12887_24890# VDPWR 0.42437f
C1445 VDPWR a_11376_26516# 0.07967f
C1446 VDPWR a_13968_25262# 0.29592f
C1447 single_9b_cdac_0.cdac_sw_9b_0.cdac_sw_3_3.tg_sw_3_3.SWP single_9b_cdac_0.SW[4] 0.17303f
C1448 a_6219_22316# sar9b_0._07_ 0.09859f
C1449 a_6679_22316# a_7039_22138# 0.03275f
C1450 single_9b_cdac_0.cdac_sw_9b_0.cdac_sw_3_0.nooverlap_clk_0.CLKB0 VDPWR 2.81434f
C1451 single_9b_cdac_1.cdac_sw_9b_0.cdac_sw_3_4.nooverlap_clk_0.x4.A a_49926_15495# 0.01076f
C1452 single_9b_cdac_1.cdac_sw_9b_0.cdac_sw_3_7.nooverlap_clk_0.x8.A single_9b_cdac_1.cdac_sw_9b_0.cdac_sw_3_7.nooverlap_clk_0.sky130_fd_sc_hs__nand2_1_0.Y 0.26942f
C1453 a_9115_21076# a_9281_21076# 0.61654f
C1454 a_10055_20130# sar9b_0.net8 0.44083f
C1455 single_9b_cdac_1.cdac_sw_9b_0.S[7] single_9b_cdac_1.cdac_sw_9b_0.cdac_sw_3_7.tg_sw_3_3.SWP 1.56111f
C1456 a_13968_23086# a_13968_22164# 0.0125f
C1457 sar9b_0.clknet_1_0__leaf_CLK a_6701_20506# 1.87819f
C1458 a_12887_24890# a_13403_25262# 0.11535f
C1459 a_13053_24890# a_13621_24858# 0.18499f
C1460 single_9b_cdac_0.SW[2] single_9b_cdac_0.SW[6] 0.01791f
C1461 single_9b_cdac_0.SW[2] sar9b_0.net31 0.06389f
C1462 a_12303_26350# a_12207_26350# 0.01379f
C1463 a_8379_25978# a_9460_26350# 0.10236f
C1464 sar9b_0.net40 a_9635_26276# 0.0553f
C1465 a_13379_27398# sar9b_0.net15 0.12486f
C1466 sar9b_0._09_ sar9b_0.net3 0.44879f
C1467 single_9b_cdac_1.cdac_sw_9b_0.cdac_sw_3_0.nooverlap_clk_0.x4.A single_9b_cdac_1.cdac_sw_9b_0.cdac_sw_3_0.nooverlap_clk_0.x3.Y 0.07517f
C1468 VDPWR a_13968_19988# 0.27607f
C1469 VDPWR a_13053_25428# 0.26346f
C1470 sar9b_0.net11 a_8637_23252# 0.04466f
C1471 a_13968_19822# a_13968_18900# 0.0125f
C1472 a_10311_19450# a_10477_19450# 0.574f
C1473 sar9b_0.net15 a_10356_20354# 0.01612f
C1474 a_7620_26350# a_7273_25946# 0.05116f
C1475 ui_in[0] VDPWR 1.63989f
C1476 single_9b_cdac_0.SW[2] single_9b_cdac_0.SW[4] 0.0195f
C1477 a_7620_26350# sar9b_0.net3 0.23689f
C1478 th_dif_sw_0.VCP th_dif_sw_0.th_sw_1.CK 1.0224f
C1479 single_9b_cdac_0.cdac_sw_9b_0.S[7] th_dif_sw_0.VCN 1.54513f
C1480 a_13621_24858# a_13621_25670# 0.01212f
C1481 ua[0] single_9b_cdac_1.SW[0] 1.99402f
C1482 single_9b_cdac_0.cdac_sw_9b_0.cdac_sw_3_3.tg_sw_3_3.SWP single_9b_cdac_0.cdac_sw_9b_0.cdac_sw_3_3.nooverlap_clk_0.CLK0 0.19266f
C1483 a_11567_23226# VDPWR 0.40771f
C1484 a_13899_23252# sar9b_0.net13 0.03781f
C1485 a_13621_19418# a_13621_20230# 0.01212f
C1486 single_9b_cdac_1.cdac_sw_9b_0.S[4] single_9b_cdac_1.cdac_sw_9b_0.cdac_sw_3_3.nooverlap_clk_0.CLKB0 0.36044f
C1487 VDPWR single_9b_cdac_1.cdac_sw_9b_0.cdac_sw_3_8.nooverlap_clk_0.x6.A 0.38397f
C1488 a_11691_25978# a_11857_25978# 0.72372f
C1489 single_9b_cdac_0.SW[5] single_9b_cdac_0.cdac_sw_9b_0.cdac_sw_3_6.tg_sw_3_3.SWN 0.03636f
C1490 single_9b_cdac_0.cdac_sw_9b_0.cdac_sw_3_2.nooverlap_clk_0.sky130_fd_sc_hs__nand2_1_0.Y single_9b_cdac_0.cdac_sw_9b_0.cdac_sw_3_2.nooverlap_clk_0.x4.A 0.01751f
C1491 a_7620_26350# sar9b_0.net19 0.01457f
C1492 VDPWR single_9b_cdac_1.cdac_sw_9b_0.cdac_sw_3_8.nooverlap_clk_0.x1.A 0.75853f
C1493 single_9b_cdac_0.SW[0] single_9b_cdac_0.cdac_sw_9b_0.cdac_sw_3_2.nooverlap_clk_0.CLKB0 0.363f
C1494 uio_in[1] uio_in[0] 0.03102f
C1495 single_9b_cdac_0.SW[7] a_13899_25972# 0.12069f
C1496 sar9b_0.net23 sar9b_0.FINAL 0.09753f
C1497 a_13347_20532# single_9b_cdac_1.SW[3] 0.10976f
C1498 sar9b_0.net34 sar9b_0.net15 0.02033f
C1499 a_14175_18356# sar9b_0.net36 0.07501f
C1500 sar9b_0.net21 uo_out[5] 0.21163f
C1501 single_9b_cdac_1.cdac_sw_9b_0.cdac_sw_3_0.nooverlap_clk_0.CLKB0 single_9b_cdac_1.SW[2] 0.3633f
C1502 a_10055_20130# VDPWR 0.46158f
C1503 sar9b_0.net3 a_11857_25978# 0.02767f
C1504 single_9b_cdac_1.SW[6] single_9b_cdac_1.SW[7] 5.89918f
C1505 a_39616_17740# single_9b_cdac_1.SW[5] 0.18991f
C1506 single_9b_cdac_1.cdac_sw_9b_0.cdac_sw_3_4.nooverlap_clk_0.CLK0 single_9b_cdac_1.cdac_sw_9b_0.cdac_sw_3_3.nooverlap_clk_0.CLK0 0.02618f
C1507 single_9b_cdac_0.SW[7] single_9b_cdac_0.cdac_sw_9b_0.cdac_sw_3_7.tg_sw_3_3.SWN 0.15499f
C1508 sar9b_0.net27 sar9b_0.net28 0.55421f
C1509 sar9b_0.clk_div_0.COUNT\[3\] a_7345_21594# 0.04639f
C1510 sar9b_0.net11 sar9b_0.net2 0.0909f
C1511 sar9b_0.clk_div_0.COUNT\[1\] a_7817_23252# 0.04533f
C1512 tdc_0.RDY th_dif_sw_0.CK 0.05485f
C1513 single_9b_cdac_0.cdac_sw_9b_0.cdac_sw_3_3.nooverlap_clk_0.x4.A a_45123_29917# 0.01076f
C1514 a_8471_20538# sar9b_0.clk_div_0.COUNT\[3\] 0.06386f
C1515 single_9b_cdac_1.CF[4] single_9b_cdac_0.cdac_sw_9b_0.cdac_sw_3_3.nooverlap_clk_0.CLKB0 0.26707f
C1516 single_9b_cdac_0.cdac_sw_9b_0.cdac_sw_3_3.nooverlap_clk_0.x8.A single_9b_cdac_0.cdac_sw_9b_0.cdac_sw_3_3.nooverlap_clk_0.x6.A 0.11216f
C1517 a_10477_19450# sar9b_0.net5 0.85223f
C1518 single_9b_cdac_0.cdac_sw_9b_0.cdac_sw_3_3.tg_sw_3_3.SWN VDPWR 2.82223f
C1519 sar9b_0.net25 sar9b_0.FINAL 0.47091f
C1520 sar9b_0._02_ a_5977_22708# 0.01266f
C1521 a_8931_22164# a_10187_22138# 0.04348f
C1522 a_9097_22164# a_9447_22164# 0.2208f
C1523 a_10477_23252# a_10732_23252# 0.06121f
C1524 a_15151_10456# tdc_0.delay_gate_ori_0.sky130_fd_sc_hs__and2_1_0.A 0.09051f
C1525 a_10679_25428# sar9b_0.net15 0.30545f
C1526 a_8931_22164# sar9b_0.net10 0.7546f
C1527 sar9b_0.net37 a_10774_20354# 0.01613f
C1528 a_6061_19988# a_6759_20354# 0.13928f
C1529 single_9b_cdac_1.CF[0] sar9b_0.net9 0.02404f
C1530 a_29134_26999# VDPWR 1.81495f
C1531 a_13053_22164# a_13403_22164# 0.2298f
C1532 sar9b_0._09_ sar9b_0.net15 0.26694f
C1533 sar9b_0.net7 a_13071_21620# 0.03581f
C1534 a_13621_21318# single_9b_cdac_1.SW[8] 0.01222f
C1535 a_10955_18900# sar9b_0.net5 0.02833f
C1536 sar9b_0.net10 a_11505_22406# 0.02453f
C1537 single_9b_cdac_0.cdac_sw_9b_0.cdac_sw_3_5.nooverlap_clk_0.x6.A VDPWR 0.38397f
C1538 a_10477_24890# a_11045_24858# 0.18122f
C1539 a_9281_21076# sar9b_0.net38 0.03762f
C1540 VDPWR sar9b_0.net18 0.21046f
C1541 single_9b_cdac_0.SW[8] a_25210_26990# 0.18991f
C1542 sar9b_0.net10 a_8951_22950# 0.17043f
C1543 sar9b_0.net15 a_13511_24884# 0.01897f
C1544 a_9460_24340# VDPWR 0.29562f
C1545 single_9b_cdac_0.cdac_sw_9b_0.S[6] single_9b_cdac_0.cdac_sw_9b_0.S[7] 14.3479f
C1546 sar9b_0.net22 sar9b_0.net3 0.47648f
C1547 a_11376_21076# VDPWR 0.08456f
C1548 sar9b_0.net17 sar9b_0.net36 0.23318f
C1549 sar9b_0.net4 a_9687_19042# 0.01772f
C1550 a_10477_19450# sar9b_0.net38 0.0214f
C1551 single_9b_cdac_1.cdac_sw_9b_0.cdac_sw_3_2.nooverlap_clk_0.CLKB0 single_9b_cdac_1.SW[0] 0.36674f
C1552 single_9b_cdac_0.cdac_sw_9b_0.cdac_sw_3_1.nooverlap_clk_0.sky130_fd_sc_hs__inv_8_0.A VDPWR 0.96901f
C1553 a_5856_26516# sar9b_0.FINAL 0.01637f
C1554 a_10211_20225# a_10142_20354# 0.20964f
C1555 a_9648_19168# VDPWR 0.59588f
C1556 sar9b_0.net21 sar9b_0.net39 0.11591f
C1557 sar9b_0.net23 VDPWR 0.49761f
C1558 single_9b_cdac_0.cdac_sw_9b_0.cdac_sw_3_2.tg_sw_3_3.SWP single_9b_cdac_0.SW[0] 0.17156f
C1559 single_9b_cdac_1.cdac_sw_9b_0.cdac_sw_3_5.nooverlap_clk_0.CLK0 single_9b_cdac_1.cdac_sw_9b_0.cdac_sw_3_5.tg_sw_3_3.SWP 0.19266f
C1560 single_9b_cdac_0.cdac_sw_9b_0.cdac_sw_3_2.nooverlap_clk_0.sky130_fd_sc_hs__nand2_1_0.Y single_9b_cdac_0.cdac_sw_9b_0.cdac_sw_3_2.nooverlap_clk_0.sky130_fd_sc_hs__inv_1_1.A 0.12223f
C1561 a_8340_27426# a_8085_27066# 0.05587f
C1562 sar9b_0.net15 a_13053_26516# 0.061f
C1563 ua[0] single_9b_cdac_0.cdac_sw_9b_0.S[1] 1.18579f
C1564 clk a_17125_9355# 0.02939f
C1565 single_9b_cdac_1.cdac_sw_9b_0.cdac_sw_3_5.tg_sw_3_3.SWP single_9b_cdac_1.cdac_sw_9b_0.cdac_sw_3_5.nooverlap_clk_0.CLKB0 1.71649f
C1566 a_6587_21852# a_6859_21710# 0.13675f
C1567 single_9b_cdac_1.cdac_sw_9b_0.cdac_sw_3_4.nooverlap_clk_0.x4.A single_9b_cdac_1.CF[3] 0.0313f
C1568 a_12887_21076# sar9b_0.net6 0.02223f
C1569 a_13403_19822# a_13511_19444# 0.05722f
C1570 a_12671_18734# a_12575_18734# 0.01379f
C1571 a_5870_19566# a_6070_19721# 0.08301f
C1572 a_5863_19662# a_5999_19822# 0.14145f
C1573 single_9b_cdac_0.cdac_sw_9b_0.S[4] th_dif_sw_0.VCN 12.6822f
C1574 single_9b_cdac_1.cdac_sw_9b_0.cdac_sw_3_7.nooverlap_clk_0.x8.A single_9b_cdac_1.cdac_sw_9b_0.cdac_sw_3_7.nooverlap_clk_0.x10.A 0.42509f
C1575 sar9b_0.net40 sar9b_0.net11 0.01996f
C1576 a_7059_25402# a_6884_25428# 0.23366f
C1577 a_6537_25670# a_6427_25794# 0.09774f
C1578 a_6319_25428# a_6224_25428# 0.04983f
C1579 a_8471_20538# a_9335_20532# 0.03224f
C1580 a_8637_20538# a_9503_20506# 0.03405f
C1581 a_9078_20506# a_8910_20532# 0.23992f
C1582 sar9b_0.net11 sar9b_0.clk_div_0.COUNT\[1\] 0.08018f
C1583 single_9b_cdac_1.cdac_sw_9b_0.cdac_sw_3_0.nooverlap_clk_0.CLKB0 VDPWR 2.81434f
C1584 single_9b_cdac_0.SW[0] a_63626_26990# 0.18991f
C1585 ui_in[0] sar9b_0.net36 0.01036f
C1586 th_dif_sw_0.th_sw_1.CK th_dif_sw_0.th_sw_1.CKB 4.72443f
C1587 single_9b_cdac_1.cdac_sw_9b_0.cdac_sw_3_8.tg_sw_3_3.SWN m2_23774_17236# 0.26684f
C1588 single_9b_cdac_1.cdac_sw_9b_0.cdac_sw_3_6.nooverlap_clk_0.x1.A single_9b_cdac_1.cdac_sw_9b_0.cdac_sw_3_6.nooverlap_clk_0.x10.A 0.05472f
C1589 sar9b_0.clknet_1_0__leaf_CLK VDPWR 2.48376f
C1590 uio_out[0] ui_in[0] 0.06786f
C1591 uo_out[1] clk 0.0457f
C1592 sar9b_0.net3 a_11689_26758# 0.18562f
C1593 a_11287_22164# a_11395_22530# 0.05722f
C1594 a_16331_9671# VDPWR 0.67026f
C1595 sar9b_0.net25 VDPWR 0.3499f
C1596 single_9b_cdac_1.cdac_sw_9b_0.S[2] a_54032_17740# 0.22367f
C1597 a_9115_21076# sar9b_0.net8 0.61793f
C1598 single_9b_cdac_1.cdac_sw_9b_0.cdac_sw_3_4.nooverlap_clk_0.x3.Y VDPWR 0.3196f
C1599 ua[0] single_9b_cdac_0.SW[7] 0.25507f
C1600 sar9b_0.net40 sar9b_0.net27 0.19323f
C1601 tdc_0.OUTP a_16555_12124# 0.01017f
C1602 a_9670_22708# a_9107_22682# 0.04983f
C1603 sar9b_0.net2 sar9b_0.net42 0.46637f
C1604 single_9b_cdac_1.SW[2] sar9b_0.net5 0.04738f
C1605 single_9b_cdac_1.cdac_sw_9b_0.cdac_sw_3_4.nooverlap_clk_0.sky130_fd_sc_hs__nand2_1_0.Y a_50962_15501# 0.01076f
C1606 single_9b_cdac_1.cdac_sw_9b_0.cdac_sw_3_6.nooverlap_clk_0.x8.A single_9b_cdac_1.cdac_sw_9b_0.cdac_sw_3_6.nooverlap_clk_0.x6.A 0.11216f
C1607 single_9b_cdac_0.SW[5] single_9b_cdac_1.CF[8] 0.01513f
C1608 sar9b_0.net15 a_11192_22164# 0.01651f
C1609 VDPWR a_9552_23252# 0.29592f
C1610 single_9b_cdac_0.cdac_sw_9b_0.cdac_sw_3_7.nooverlap_clk_0.x10.A single_9b_cdac_0.cdac_sw_9b_0.cdac_sw_3_7.nooverlap_clk_0.sky130_fd_sc_hs__inv_8_0.A 0.05105f
C1611 single_9b_cdac_1.cdac_sw_9b_0.cdac_sw_3_6.nooverlap_clk_0.x8.A single_9b_cdac_1.cdac_sw_9b_0.cdac_sw_3_6.nooverlap_clk_0.x1.A 0.42784f
C1612 tdc_0.phase_detector_0.INN a_16222_11316# 0.02415f
C1613 VDPWR a_11471_24174# 0.23138f
C1614 sar9b_0.net10 sar9b_0.net13 0.34447f
C1615 a_55773_29911# single_9b_cdac_0.cdac_sw_9b_0.cdac_sw_3_0.nooverlap_clk_0.sky130_fd_sc_hs__nand2_1_0.Y 0.01076f
C1616 single_9b_cdac_1.CF[7] single_9b_cdac_1.cdac_sw_9b_0.cdac_sw_3_7.nooverlap_clk_0.CLKB0 0.26707f
C1617 sar9b_0._11_ sar9b_0._03_ 0.11922f
C1618 sar9b_0.net11 a_8431_22682# 0.06735f
C1619 single_9b_cdac_0.cdac_sw_9b_0.S[0] single_9b_cdac_0.cdac_sw_9b_0.S[8] 0.23119f
C1620 sar9b_0.net11 a_12795_23802# 0.03027f
C1621 tdc_0.RDY VDPWR 0.59644f
C1622 single_9b_cdac_1.cdac_sw_9b_0.S[5] single_9b_cdac_1.cdac_sw_9b_0.S[1] 0.26958f
C1623 VDPWR a_5856_26516# 0.09797f
C1624 single_9b_cdac_0.SW[5] a_38738_26999# 0.28324f
C1625 single_9b_cdac_1.cdac_sw_9b_0.cdac_sw_3_7.nooverlap_clk_0.x1.A single_9b_cdac_1.cdac_sw_9b_0.cdac_sw_3_7.nooverlap_clk_0.sky130_fd_sc_hs__inv_1_1.A 0.10429f
C1626 single_9b_cdac_0.cdac_sw_9b_0.cdac_sw_3_3.nooverlap_clk_0.x8.A single_9b_cdac_0.cdac_sw_9b_0.cdac_sw_3_3.nooverlap_clk_0.sky130_fd_sc_hs__inv_8_0.A 0.04988f
C1627 a_12575_18734# VDPWR 0.19568f
C1628 single_9b_cdac_0.cdac_sw_9b_0.cdac_sw_3_8.nooverlap_clk_0.sky130_fd_sc_hs__inv_1_1.A single_9b_cdac_0.cdac_sw_9b_0.cdac_sw_3_8.nooverlap_clk_0.x1.A 0.10429f
C1629 VDPWR single_9b_cdac_1.cdac_sw_9b_0.cdac_sw_3_1.nooverlap_clk_0.CLKB0 2.81428f
C1630 th_dif_sw_0.VCN a_14897_9355# 0.05461f
C1631 a_6679_22316# VDPWR 0.20399f
C1632 a_9115_21076# VDPWR 0.45092f
C1633 single_9b_cdac_1.SW[2] sar9b_0.net38 0.07653f
C1634 single_9b_cdac_0.cdac_sw_9b_0.cdac_sw_3_3.tg_sw_3_3.SWP single_9b_cdac_0.cdac_sw_9b_0.cdac_sw_3_3.nooverlap_clk_0.CLKB0 1.71649f
C1635 a_12961_23802# sar9b_0.net12 0.02451f
C1636 a_6674_21050# sar9b_0._07_ 0.03131f
C1637 ua[1] VDPWR 2.05857f
C1638 a_8379_24340# VDPWR 0.46591f
C1639 sar9b_0.net27 a_12795_23802# 0.03082f
C1640 a_6171_22714# a_6525_22708# 0.05761f
C1641 single_9b_cdac_0.SW[5] single_9b_cdac_1.CF[6] 0.09395f
C1642 a_10311_19450# VDPWR 0.46625f
C1643 single_9b_cdac_0.cdac_sw_9b_0.S[4] single_9b_cdac_0.cdac_sw_9b_0.S[6] 1.87907f
C1644 sar9b_0.clknet_1_0__leaf_CLK a_6249_19988# 0.01024f
C1645 sar9b_0.net26 single_9b_cdac_1.SW[5] 0.04392f
C1646 sar9b_0.net31 a_13968_25262# 0.01032f
C1647 single_9b_cdac_1.SW[0] single_9b_cdac_1.cdac_sw_9b_0.cdac_sw_3_7.nooverlap_clk_0.CLK0 0.03931f
C1648 single_9b_cdac_1.CF[3] sar9b_0.net9 0.10042f
C1649 sar9b_0.net8 sar9b_0.net5 0.02482f
C1650 sar9b_0.net26 single_9b_cdac_1.SW[3] 0.04389f
C1651 a_11231_20538# a_12312_20910# 0.10236f
C1652 a_14871_9671# a_14897_9355# 0.06748f
C1653 sar9b_0.FINAL sar9b_0.net38 0.10611f
C1654 a_12487_20836# sar9b_0.net41 0.05708f
C1655 sar9b_0.net3 a_6094_27060# 0.16663f
C1656 single_9b_cdac_1.cdac_sw_9b_0.cdac_sw_3_0.nooverlap_clk_0.CLKB0 single_9b_cdac_1.cdac_sw_9b_0.cdac_sw_3_4.nooverlap_clk_0.CLKB0 0.02513f
C1657 sar9b_0.net41 a_12887_19988# 0.01845f
C1658 sar9b_0.clk_div_0.COUNT\[0\] sar9b_0._11_ 0.18325f
C1659 a_10311_19450# a_11392_19822# 0.10236f
C1660 a_10477_19450# a_11567_19748# 0.04242f
C1661 uio_out[0] sar9b_0.net18 0.20229f
C1662 ua[0] single_9b_cdac_0.cdac_sw_9b_0.cdac_sw_3_4.tg_sw_3_3.SWP 1.15113f
C1663 sar9b_0.net38 a_9038_22708# 0.01059f
C1664 single_9b_cdac_1.cdac_sw_9b_0.cdac_sw_3_3.tg_sw_3_3.SWP single_9b_cdac_1.SW[4] 0.17175f
C1665 VDPWR a_10406_19266# 0.08395f
C1666 single_9b_cdac_0.SW[6] a_13053_25428# 0.0329f
C1667 sar9b_0.net15 sar9b_0.net6 0.28405f
C1668 single_9b_cdac_0.cdac_sw_9b_0.cdac_sw_3_0.nooverlap_clk_0.sky130_fd_sc_hs__inv_1_1.A single_9b_cdac_1.CF[2] 0.01887f
C1669 a_9368_19822# sar9b_0.net15 0.27584f
C1670 single_9b_cdac_1.cdac_sw_9b_0.cdac_sw_3_5.nooverlap_clk_0.sky130_fd_sc_hs__inv_8_0.A single_9b_cdac_1.cdac_sw_9b_0.cdac_sw_3_5.nooverlap_clk_0.CLKB0 0.6919f
C1671 a_16527_10454# VDPWR 0.3789f
C1672 single_9b_cdac_0.cdac_sw_9b_0.cdac_sw_3_5.tg_sw_3_3.SWN single_9b_cdac_0.cdac_sw_9b_0.cdac_sw_3_3.tg_sw_3_3.SWN 0.02638f
C1673 sar9b_0.net40 sar9b_0.net42 0.35074f
C1674 sar9b_0.net15 a_13053_19988# 0.03421f
C1675 VDPWR single_9b_cdac_1.cdac_sw_9b_0.cdac_sw_3_1.nooverlap_clk_0.CLK0 2.71729f
C1676 single_9b_cdac_0.cdac_sw_9b_0.cdac_sw_3_3.nooverlap_clk_0.x10.A single_9b_cdac_0.cdac_sw_9b_0.cdac_sw_3_3.tg_sw_3_3.SWN 0.69086f
C1677 a_13623_20532# single_9b_cdac_1.SW[4] 0.10865f
C1678 single_9b_cdac_0.SW[5] single_9b_cdac_1.CF[7] 0.02016f
C1679 a_10477_24890# VDPWR 0.2679f
C1680 a_13623_20532# single_9b_cdac_1.SW[2] 0.02408f
C1681 a_11567_25188# sar9b_0.net13 0.06737f
C1682 sar9b_0.net8 sar9b_0.net38 0.03838f
C1683 sar9b_0.net3 a_5951_26516# 0.15585f
C1684 single_9b_cdac_0.cdac_sw_9b_0.cdac_sw_3_6.nooverlap_clk_0.x1.A single_9b_cdac_0.cdac_sw_9b_0.cdac_sw_3_6.nooverlap_clk_0.x4.A 0.28523f
C1685 single_9b_cdac_0.SW[1] a_58824_26990# 0.18991f
C1686 a_10311_23252# sar9b_0.net15 0.30059f
C1687 sar9b_0.net3 sar9b_0.clknet_0_CLK 0.103f
C1688 VDPWR single_9b_cdac_1.cdac_sw_9b_0.cdac_sw_3_2.nooverlap_clk_0.sky130_fd_sc_hs__inv_1_1.A 0.38317f
C1689 single_9b_cdac_1.cdac_sw_9b_0.cdac_sw_3_3.tg_sw_3_3.SWN single_9b_cdac_1.SW[4] 0.1498f
C1690 VDPWR sar9b_0.net5 1.67258f
C1691 single_9b_cdac_1.SW[0] single_9b_cdac_1.cdac_sw_9b_0.cdac_sw_3_7.tg_sw_3_3.SWP 0.08409f
C1692 a_10827_25262# a_10732_25250# 0.04983f
C1693 a_9107_22682# a_9038_22708# 0.20964f
C1694 single_9b_cdac_0.cdac_sw_9b_0.S[6] a_33936_26999# 0.59531f
C1695 a_13968_25428# sar9b_0.net15 0.23547f
C1696 ua[0] single_9b_cdac_1.cdac_sw_9b_0.cdac_sw_3_0.nooverlap_clk_0.CLK0 0.12088f
C1697 a_5870_19566# VDPWR 0.36177f
C1698 a_7059_25402# VDPWR 0.38803f
C1699 a_9078_20506# VDPWR 0.18468f
C1700 single_9b_cdac_1.cdac_sw_9b_0.S[0] single_9b_cdac_1.cdac_sw_9b_0.S[1] 17.6208f
C1701 single_9b_cdac_1.CF[4] single_9b_cdac_0.cdac_sw_9b_0.cdac_sw_3_4.tg_sw_3_3.SWN 0.03482f
C1702 ua[0] single_9b_cdac_1.CF[5] 3.57763f
C1703 a_10923_19822# a_10827_19822# 0.01379f
C1704 single_9b_cdac_0.cdac_sw_9b_0.cdac_sw_3_0.tg_sw_3_3.SWN single_9b_cdac_0.cdac_sw_9b_0.cdac_sw_3_0.tg_sw_3_3.SWP 3.10626f
C1705 a_11392_19822# sar9b_0.net5 0.05873f
C1706 sar9b_0.net42 a_10771_22164# 0.02093f
C1707 single_9b_cdac_0.cdac_sw_9b_0.cdac_sw_3_3.nooverlap_clk_0.x1.A single_9b_cdac_0.cdac_sw_9b_0.cdac_sw_3_3.nooverlap_clk_0.x6.A 0.03729f
C1708 a_16159_13315# a_16185_12837# 0.01114f
C1709 tdc_0.phase_detector_0.INP VDPWR 0.59622f
C1710 a_13857_27279# a_14175_27060# 0.04629f
C1711 a_12937_27279# sar9b_0.net13 0.01007f
C1712 sar9b_0.net7 single_9b_cdac_1.CF[1] 0.07641f
C1713 single_9b_cdac_0.cdac_sw_9b_0.cdac_sw_3_1.tg_sw_3_3.SWN single_9b_cdac_0.cdac_sw_9b_0.cdac_sw_3_0.nooverlap_clk_0.CLKB0 0.01175f
C1714 single_9b_cdac_1.CF[8] single_9b_cdac_1.cdac_sw_9b_0.cdac_sw_3_8.nooverlap_clk_0.x3.Y 0.12898f
C1715 single_9b_cdac_1.cdac_sw_9b_0.cdac_sw_3_1.nooverlap_clk_0.sky130_fd_sc_hs__inv_1_1.A VDPWR 0.38716f
C1716 single_9b_cdac_0.cdac_sw_9b_0.cdac_sw_3_1.nooverlap_clk_0.sky130_fd_sc_hs__nand2_1_0.Y single_9b_cdac_1.CF[1] 0.17948f
C1717 VDPWR sar9b_0.net38 1.66557f
C1718 single_9b_cdac_0.cdac_sw_9b_0.cdac_sw_3_5.nooverlap_clk_0.x8.A single_9b_cdac_0.cdac_sw_9b_0.cdac_sw_3_5.nooverlap_clk_0.sky130_fd_sc_hs__inv_1_1.A 0.08121f
C1719 VDPWR single_9b_cdac_0.cdac_sw_9b_0.cdac_sw_3_2.nooverlap_clk_0.sky130_fd_sc_hs__inv_8_0.A 0.94957f
C1720 single_9b_cdac_0.cdac_sw_9b_0.cdac_sw_3_3.tg_sw_3_3.SWN single_9b_cdac_0.SW[4] 0.1516f
C1721 sar9b_0.net12 a_12887_25428# 0.45699f
C1722 VDPWR a_11855_20532# 0.14532f
C1723 ua[0] single_9b_cdac_1.cdac_sw_9b_0.cdac_sw_3_6.tg_sw_3_3.SWN 3.10215f
C1724 single_9b_cdac_0.cdac_sw_9b_0.S[1] single_9b_cdac_0.cdac_sw_9b_0.cdac_sw_3_1.tg_sw_3_3.SWP 1.55946f
C1725 sar9b_0.net37 a_13621_20230# 0.01869f
C1726 single_9b_cdac_1.SW[7] th_dif_sw_0.VCN 0.09453f
C1727 uo_out[5] a_9175_27364# 0.01438f
C1728 a_5856_26516# sar9b_0.net36 0.15774f
C1729 single_9b_cdac_1.CF[6] single_9b_cdac_1.SW[5] 0.01475f
C1730 a_11392_19822# sar9b_0.net38 0.03915f
C1731 a_12575_18734# sar9b_0.net36 0.03563f
C1732 sar9b_0.net1 a_13053_26516# 0.22366f
C1733 a_12887_26516# a_13621_26758# 0.07009f
C1734 th_dif_sw_0.VCP th_dif_sw_0.th_sw_1.CKB 0.31462f
C1735 a_10827_23252# sar9b_0.net12 0.03358f
C1736 single_9b_cdac_1.CF[6] single_9b_cdac_1.SW[3] 0.0149f
C1737 sar9b_0.net15 a_11579_23796# 0.02031f
C1738 sar9b_0.net13 sar9b_0.net43 0.78052f
C1739 sar9b_0.clknet_1_1__leaf_CLK a_8085_23802# 0.01332f
C1740 a_29134_26999# single_9b_cdac_0.cdac_sw_9b_0.cdac_sw_3_7.tg_sw_3_3.SWP 0.04592f
C1741 ua[0] th_dif_sw_0.VCP 1.01099f
C1742 sar9b_0.net11 sar9b_0.net39 0.01929f
C1743 single_9b_cdac_0.cdac_sw_9b_0.cdac_sw_3_1.nooverlap_clk_0.x8.A single_9b_cdac_0.cdac_sw_9b_0.cdac_sw_3_1.nooverlap_clk_0.x6.A 0.11216f
C1744 sar9b_0.net27 a_13053_22714# 0.03856f
C1745 VDPWR single_9b_cdac_1.cdac_sw_9b_0.cdac_sw_3_7.nooverlap_clk_0.CLKB0 2.81428f
C1746 clk sar9b_0.net11 0.02351f
C1747 single_9b_cdac_0.cdac_sw_9b_0.cdac_sw_3_2.tg_sw_3_3.SWP single_9b_cdac_0.cdac_sw_9b_0.cdac_sw_3_2.nooverlap_clk_0.CLKB0 1.71649f
C1748 sar9b_0.net15 a_12887_22164# 0.32537f
C1749 single_9b_cdac_1.cdac_sw_9b_0.cdac_sw_3_3.tg_sw_3_3.SWP VDPWR 3.27833f
C1750 VDPWR a_9107_22682# 0.20626f
C1751 single_9b_cdac_1.SW[7] single_9b_cdac_1.CF[0] 1.10054f
C1752 VDPWR a_14051_24100# 0.36524f
C1753 a_8545_24340# sar9b_0.net15 0.02569f
C1754 sar9b_0.net15 sar9b_0.clknet_0_CLK 0.17182f
C1755 sar9b_0.net15 a_11689_21318# 0.19941f
C1756 single_9b_cdac_0.cdac_sw_9b_0.cdac_sw_3_3.tg_sw_3_3.SWN single_9b_cdac_0.cdac_sw_9b_0.cdac_sw_3_3.nooverlap_clk_0.CLK0 0.17533f
C1757 single_9b_cdac_0.cdac_sw_9b_0.cdac_sw_3_2.nooverlap_clk_0.x1.A single_9b_cdac_0.cdac_sw_9b_0.cdac_sw_3_2.nooverlap_clk_0.x8.A 0.42784f
C1758 a_12480_18722# VDPWR 0.07927f
C1759 single_9b_cdac_0.cdac_sw_9b_0.cdac_sw_3_7.nooverlap_clk_0.sky130_fd_sc_hs__nand2_1_0.Y single_9b_cdac_0.cdac_sw_9b_0.cdac_sw_3_7.nooverlap_clk_0.x8.A 0.26942f
C1760 sar9b_0.net15 a_13511_19444# 0.01443f
C1761 sar9b_0.net15 a_14143_22138# 0.27822f
C1762 a_9665_22406# a_9447_22164# 0.20964f
C1763 single_9b_cdac_1.SW[1] a_58824_17740# 0.18991f
C1764 VDPWR a_13623_20532# 0.18851f
C1765 a_5973_23252# sar9b_0.clknet_1_1__leaf_CLK 0.01136f
C1766 sar9b_0.net27 sar9b_0.net39 0.0165f
C1767 tdc_0.OUTN sar9b_0.net1 0.01729f
C1768 ua[0] single_9b_cdac_0.cdac_sw_9b_0.cdac_sw_3_7.tg_sw_3_3.SWN 3.10218f
C1769 single_9b_cdac_0.cdac_sw_9b_0.cdac_sw_3_4.nooverlap_clk_0.x8.A single_9b_cdac_0.cdac_sw_9b_0.cdac_sw_3_4.nooverlap_clk_0.x6.A 0.11216f
C1770 VDPWR a_9739_26882# 0.14211f
C1771 single_9b_cdac_1.cdac_sw_9b_0.cdac_sw_3_4.tg_sw_3_3.SWN VDPWR 2.82171f
C1772 single_9b_cdac_1.CF[7] single_9b_cdac_1.SW[5] 0.01475f
C1773 single_9b_cdac_0.cdac_sw_9b_0.S[0] single_9b_cdac_0.cdac_sw_9b_0.S[1] 17.6208f
C1774 sar9b_0.clk_div_0.COUNT\[1\] a_8358_23796# 0.03349f
C1775 a_12211_24100# a_12036_24174# 0.23366f
C1776 single_9b_cdac_1.cdac_sw_9b_0.cdac_sw_3_3.tg_sw_3_3.SWN VDPWR 2.82172f
C1777 sar9b_0.clknet_1_0__leaf_CLK sar9b_0.clk_div_0.COUNT\[3\] 0.02415f
C1778 single_9b_cdac_1.CF[7] single_9b_cdac_1.SW[3] 0.0149f
C1779 sar9b_0.net37 sar9b_0.net35 0.02643f
C1780 single_9b_cdac_0.cdac_sw_9b_0.cdac_sw_3_1.nooverlap_clk_0.x4.A single_9b_cdac_0.cdac_sw_9b_0.cdac_sw_3_1.nooverlap_clk_0.sky130_fd_sc_hs__nand2_1_0.Y 0.01751f
C1781 sar9b_0.net4 sar9b_0.net35 0.57519f
C1782 VDPWR a_8800_24340# 0.08243f
C1783 a_10955_26516# a_12036_26516# 0.10236f
C1784 ua[0] single_9b_cdac_1.cdac_sw_9b_0.cdac_sw_3_2.tg_sw_3_3.SWP 1.14951f
C1785 sar9b_0._13_ sar9b_0._09_ 0.169f
C1786 sar9b_0.net37 sar9b_0.clk_div_0.COUNT\[0\] 0.12937f
C1787 a_8453_19450# a_8708_19810# 0.05639f
C1788 single_9b_cdac_1.cdac_sw_9b_0.cdac_sw_3_8.tg_sw_3_3.SWP single_9b_cdac_1.cdac_sw_9b_0.cdac_sw_3_8.nooverlap_clk_0.CLK0 0.19266f
C1789 single_9b_cdac_0.cdac_sw_9b_0.S[0] a_62748_26999# 0.59531f
C1790 a_14143_25188# a_14451_24340# 0.01215f
C1791 a_13419_23796# a_12961_23802# 0.03462f
C1792 single_9b_cdac_0.cdac_sw_9b_0.cdac_sw_3_0.nooverlap_clk_0.x4.A single_9b_cdac_0.cdac_sw_9b_0.cdac_sw_3_0.nooverlap_clk_0.x3.Y 0.07517f
C1793 a_10166_3438# th_dif_sw_0.th_sw_1.CK 0.04838f
C1794 sar9b_0.net39 a_9175_27364# 0.06154f
C1795 a_7919_27066# a_9000_27438# 0.10236f
C1796 a_9635_24314# sar9b_0.net12 0.06059f
C1797 sar9b_0.net33 a_13623_25972# 0.19821f
C1798 single_9b_cdac_1.CF[1] sar9b_0.net9 0.11616f
C1799 sar9b_0.net15 a_8637_23252# 0.02677f
C1800 sar9b_0.net4 a_9113_24582# 0.0221f
C1801 a_38738_26999# single_9b_cdac_0.cdac_sw_9b_0.cdac_sw_3_5.nooverlap_clk_0.CLKB0 0.23864f
C1802 single_9b_cdac_0.cdac_sw_9b_0.cdac_sw_3_7.nooverlap_clk_0.CLKB0 single_9b_cdac_0.cdac_sw_9b_0.S[7] 0.36044f
C1803 single_9b_cdac_0.cdac_sw_9b_0.cdac_sw_3_5.nooverlap_clk_0.x4.A single_9b_cdac_0.cdac_sw_9b_0.cdac_sw_3_5.nooverlap_clk_0.x3.Y 0.07517f
C1804 m2_23774_17236# VDPWR 0.19016f
C1805 single_9b_cdac_0.SW[5] VDPWR 2.11999f
C1806 a_13315_18660# a_13140_18734# 0.23366f
C1807 a_11045_23494# sar9b_0.net42 0.02664f
C1808 a_9535_19962# sar9b_0.net37 0.03762f
C1809 tdc_0.delay_gate_ori_1.sky130_fd_sc_hs__and2_1_0.A VDPWR 0.45583f
C1810 a_7059_21228# VDPWR 0.21276f
C1811 single_9b_cdac_0.cdac_sw_9b_0.cdac_sw_3_3.nooverlap_clk_0.x1.A single_9b_cdac_0.cdac_sw_9b_0.cdac_sw_3_3.nooverlap_clk_0.sky130_fd_sc_hs__inv_8_0.A 0.45521f
C1812 single_9b_cdac_1.SW[4] single_9b_cdac_1.SW[5] 10.2692f
C1813 single_9b_cdac_1.cdac_sw_9b_0.cdac_sw_3_5.nooverlap_clk_0.x4.A single_9b_cdac_1.cdac_sw_9b_0.cdac_sw_3_5.nooverlap_clk_0.sky130_fd_sc_hs__nand2_1_0.Y 0.01751f
C1814 a_6315_21050# sar9b_0._00_ 0.05632f
C1815 a_5968_27176# a_6094_27060# 0.18517f
C1816 a_6007_27302# sar9b_0.net35 0.1658f
C1817 sar9b_0.net40 a_12887_21076# 0.02321f
C1818 single_9b_cdac_1.SW[2] single_9b_cdac_1.SW[5] 0.22404f
C1819 single_9b_cdac_1.SW[3] single_9b_cdac_1.SW[4] 12.6576f
C1820 sar9b_0.net28 sar9b_0.net15 0.18445f
C1821 a_13621_24858# VDPWR 0.20706f
C1822 a_7919_23802# a_8273_23796# 0.06222f
C1823 single_9b_cdac_1.SW[2] single_9b_cdac_1.SW[3] 14.9532f
C1824 a_10774_20354# sar9b_0.net41 0.02489f
C1825 a_11567_19748# VDPWR 0.41412f
C1826 single_9b_cdac_1.cdac_sw_9b_0.cdac_sw_3_1.tg_sw_3_3.SWN single_9b_cdac_1.cdac_sw_9b_0.cdac_sw_3_2.tg_sw_3_3.SWN 0.02638f
C1827 single_9b_cdac_0.cdac_sw_9b_0.cdac_sw_3_0.tg_sw_3_3.SWN single_9b_cdac_0.cdac_sw_9b_0.cdac_sw_3_0.nooverlap_clk_0.x10.A 0.69086f
C1828 single_9b_cdac_1.cdac_sw_9b_0.cdac_sw_3_7.nooverlap_clk_0.x1.A single_9b_cdac_1.cdac_sw_9b_0.cdac_sw_3_7.nooverlap_clk_0.sky130_fd_sc_hs__nand2_1_0.Y 0.01003f
C1829 a_9115_21076# a_9631_21076# 0.11082f
C1830 a_9281_21076# a_9849_21318# 0.17589f
C1831 single_9b_cdac_0.cdac_sw_9b_0.cdac_sw_3_0.nooverlap_clk_0.CLK0 single_9b_cdac_0.cdac_sw_9b_0.S[2] 0.26625f
C1832 single_9b_cdac_1.cdac_sw_9b_0.cdac_sw_3_5.nooverlap_clk_0.x8.A single_9b_cdac_1.cdac_sw_9b_0.cdac_sw_3_5.nooverlap_clk_0.x4.A 0.0303f
C1833 a_13053_24890# a_14143_25188# 0.04242f
C1834 a_13621_24858# a_13403_25262# 0.20964f
C1835 sar9b_0.net15 sar9b_0.net29 0.01722f
C1836 sar9b_0.net1 sar9b_0.net6 0.08798f
C1837 clk single_9b_cdac_0.SW[8] 0.22068f
C1838 a_6907_19444# sar9b_0.clknet_1_0__leaf_CLK 0.31124f
C1839 sar9b_0.net42 sar9b_0.net39 0.04708f
C1840 VDPWR a_13511_20354# 0.13232f
C1841 a_11567_19748# a_11392_19822# 0.23366f
C1842 single_9b_cdac_0.SW[2] single_9b_cdac_0.cdac_sw_9b_0.cdac_sw_3_4.tg_sw_3_3.SWN 0.01427f
C1843 single_9b_cdac_1.cdac_sw_9b_0.cdac_sw_3_4.nooverlap_clk_0.CLKB0 single_9b_cdac_1.cdac_sw_9b_0.cdac_sw_3_4.tg_sw_3_3.SWN 0.22879f
C1844 tdc_0.phase_detector_0.INP tdc_0.phase_detector_0.pd_out_0.A 0.04344f
C1845 a_10477_19450# a_11045_19418# 0.17444f
C1846 a_13053_19988# sar9b_0.net1 0.2294f
C1847 sar9b_0.net15 sar9b_0.net2 1.06442f
C1848 a_9113_25946# sar9b_0.net38 0.03604f
C1849 sar9b_0.net40 sar9b_0.net3 0.30016f
C1850 a_6169_26758# a_6163_27034# 0.01057f
C1851 a_5435_26516# sar9b_0.FINAL 0.76608f
C1852 single_9b_cdac_0.cdac_sw_9b_0.cdac_sw_3_5.nooverlap_clk_0.x8.A single_9b_cdac_0.cdac_sw_9b_0.cdac_sw_3_5.nooverlap_clk_0.x1.A 0.42784f
C1853 single_9b_cdac_0.SW[1] single_9b_cdac_0.cdac_sw_9b_0.S[1] 0.22497f
C1854 a_63626_17740# single_9b_cdac_1.cdac_sw_9b_0.S[0] 0.22513f
C1855 sar9b_0.net3 sar9b_0.clk_div_0.COUNT\[1\] 0.22343f
C1856 sar9b_0.net28 single_9b_cdac_0.SW[0] 0.03703f
C1857 a_13623_23252# VDPWR 0.23241f
C1858 a_14451_23252# sar9b_0.net13 0.20286f
C1859 a_13403_19822# a_13403_19988# 0.01481f
C1860 single_9b_cdac_1.cdac_sw_9b_0.cdac_sw_3_2.nooverlap_clk_0.CLKB0 single_9b_cdac_1.cdac_sw_9b_0.cdac_sw_3_2.tg_sw_3_3.SWP 1.71649f
C1861 a_11691_25978# a_12207_26350# 0.11238f
C1862 a_13899_20532# single_9b_cdac_1.SW[5] 0.11098f
C1863 sar9b_0.net12 a_9727_23226# 0.02415f
C1864 single_9b_cdac_0.cdac_sw_9b_0.cdac_sw_3_7.nooverlap_clk_0.x10.A single_9b_cdac_0.cdac_sw_9b_0.cdac_sw_3_7.nooverlap_clk_0.x8.A 0.42509f
C1865 VDPWR single_9b_cdac_0.cdac_sw_9b_0.cdac_sw_3_4.nooverlap_clk_0.sky130_fd_sc_hs__inv_8_0.A 0.96835f
C1866 single_9b_cdac_0.SW[0] sar9b_0.net29 0.03649f
C1867 a_10827_19822# sar9b_0.net4 0.04038f
C1868 sar9b_0.net15 a_9843_19137# 0.18207f
C1869 single_9b_cdac_1.CF[4] single_9b_cdac_1.cdac_sw_9b_0.cdac_sw_3_3.nooverlap_clk_0.sky130_fd_sc_hs__inv_8_0.A 0.06019f
C1870 a_12480_18722# sar9b_0.net36 0.02104f
C1871 single_9b_cdac_1.cdac_sw_9b_0.cdac_sw_3_6.nooverlap_clk_0.sky130_fd_sc_hs__nand2_1_0.Y single_9b_cdac_1.CF[6] 0.17948f
C1872 a_10142_20354# VDPWR 0.20915f
C1873 sar9b_0.net3 a_12207_26350# 0.1566f
C1874 single_9b_cdac_1.CF[2] single_9b_cdac_1.cdac_sw_9b_0.cdac_sw_3_0.nooverlap_clk_0.sky130_fd_sc_hs__inv_1_1.A 0.01887f
C1875 a_39616_17740# single_9b_cdac_1.cdac_sw_9b_0.S[5] 0.22512f
C1876 VDPWR single_9b_cdac_1.cdac_sw_9b_0.cdac_sw_3_2.nooverlap_clk_0.sky130_fd_sc_hs__inv_8_0.A 0.94957f
C1877 single_9b_cdac_0.SW[2] sar9b_0.net11 0.01228f
C1878 a_5601_26516# a_5951_26516# 0.21971f
C1879 single_9b_cdac_0.SW[1] single_9b_cdac_0.SW[7] 0.01285f
C1880 tdc_0.OUTP th_dif_sw_0.CK 0.11641f
C1881 single_9b_cdac_1.CF[8] single_9b_cdac_0.cdac_sw_9b_0.S[7] 0.01879f
C1882 single_9b_cdac_0.cdac_sw_9b_0.cdac_sw_3_6.nooverlap_clk_0.x8.A single_9b_cdac_0.cdac_sw_9b_0.cdac_sw_3_6.nooverlap_clk_0.x4.A 0.0303f
C1883 a_48343_16877# VDPWR 1.81495f
C1884 a_10955_18900# a_11121_18900# 0.61032f
C1885 a_6943_22316# sar9b_0._14_ 0.01028f
C1886 a_9078_20506# sar9b_0.clk_div_0.COUNT\[3\] 0.03726f
C1887 sar9b_0._05_ VDPWR 0.3639f
C1888 single_9b_cdac_1.CF[0] single_9b_cdac_0.cdac_sw_9b_0.cdac_sw_3_2.nooverlap_clk_0.x3.Y 0.12898f
C1889 a_6337_22714# VDPWR 0.28476f
C1890 sar9b_0.net10 sar9b_0.net38 0.11973f
C1891 single_9b_cdac_1.cdac_sw_9b_0.S[8] single_9b_cdac_1.cdac_sw_9b_0.cdac_sw_3_8.tg_sw_3_3.SWP 1.50841f
C1892 sar9b_0.net15 a_11579_19266# 0.02132f
C1893 a_7735_21076# sar9b_0._05_ 0.08902f
C1894 single_9b_cdac_1.cdac_sw_9b_0.cdac_sw_3_1.nooverlap_clk_0.x6.A single_9b_cdac_1.cdac_sw_9b_0.cdac_sw_3_1.nooverlap_clk_0.x8.A 0.11216f
C1895 a_12887_22164# a_13621_22406# 0.07009f
C1896 a_9097_22164# a_10012_22164# 0.12532f
C1897 a_8931_22164# a_9352_22164# 0.09016f
C1898 sar9b_0.net25 sar9b_0.net14 0.18704f
C1899 a_10827_23252# a_10732_23252# 0.04983f
C1900 a_11045_23494# a_10935_23618# 0.09774f
C1901 single_9b_cdac_1.cdac_sw_9b_0.S[4] single_9b_cdac_1.CF[5] 0.01608f
C1902 a_13968_25262# sar9b_0.net32 0.0467f
C1903 single_9b_cdac_1.cdac_sw_9b_0.cdac_sw_3_7.nooverlap_clk_0.x4.A a_30717_15495# 0.01076f
C1904 a_10211_20225# a_10521_19988# 0.01379f
C1905 a_11413_25670# sar9b_0.net15 0.1709f
C1906 sar9b_0.net24 uo_out[2] 0.10415f
C1907 a_13053_22164# a_13968_22164# 0.12532f
C1908 a_6171_22714# a_6778_22682# 0.13601f
C1909 single_9b_cdac_1.SW[7] a_29134_16877# 0.28324f
C1910 single_9b_cdac_1.cdac_sw_9b_0.cdac_sw_3_8.nooverlap_clk_0.x8.A single_9b_cdac_1.cdac_sw_9b_0.cdac_sw_3_8.nooverlap_clk_0.sky130_fd_sc_hs__inv_1_1.A 0.08121f
C1911 a_14143_21050# single_9b_cdac_1.SW[8] 0.02014f
C1912 VDPWR single_9b_cdac_1.SW[5] 2.19638f
C1913 sar9b_0.net3 a_9631_26516# 0.15535f
C1914 single_9b_cdac_0.cdac_sw_9b_0.cdac_sw_3_3.tg_sw_3_3.SWN single_9b_cdac_0.cdac_sw_9b_0.cdac_sw_3_3.nooverlap_clk_0.CLKB0 0.22875f
C1915 VDPWR single_9b_cdac_1.SW[3] 2.26788f
C1916 sar9b_0.clk_div_0.COUNT\[3\] sar9b_0.net38 0.03194f
C1917 a_13053_25428# sar9b_0.net32 0.03163f
C1918 a_11045_24858# a_10827_25262# 0.20964f
C1919 a_10477_24890# a_11567_25188# 0.04182f
C1920 a_9631_21076# sar9b_0.net38 0.01069f
C1921 sar9b_0.net40 sar9b_0.net15 0.19482f
C1922 a_12887_22164# sar9b_0.net1 0.18279f
C1923 VDPWR a_5435_26516# 0.47473f
C1924 uo_out[1] ui_in[0] 0.06797f
C1925 single_9b_cdac_1.cdac_sw_9b_0.cdac_sw_3_8.nooverlap_clk_0.x3.Y VDPWR 0.3196f
C1926 ua[0] single_9b_cdac_1.cdac_sw_9b_0.cdac_sw_3_2.nooverlap_clk_0.CLKB0 0.11944f
C1927 a_11471_24174# a_11567_24174# 0.01379f
C1928 a_11287_22164# a_10937_22164# 0.20755f
C1929 a_12027_22138# a_10771_22164# 0.04357f
C1930 a_8545_25978# VDPWR 0.58982f
C1931 a_8340_27426# a_8435_27438# 0.04983f
C1932 sar9b_0.net15 a_13403_26516# 0.16273f
C1933 single_9b_cdac_1.CF[0] single_9b_cdac_1.cdac_sw_9b_0.cdac_sw_3_2.tg_sw_3_3.SWN 0.12358f
C1934 a_5619_23252# sar9b_0.clk_div_0.COUNT\[0\] 0.0112f
C1935 sar9b_0.net42 a_11121_23802# 0.0358f
C1936 single_9b_cdac_1.cdac_sw_9b_0.S[3] th_dif_sw_0.VCP 27.329f
C1937 single_9b_cdac_0.cdac_sw_9b_0.cdac_sw_3_2.tg_sw_3_3.SWN single_9b_cdac_0.SW[0] 0.14962f
C1938 single_9b_cdac_1.cdac_sw_9b_0.S[4] th_dif_sw_0.VCP 12.6822f
C1939 uio_in[6] uio_in[5] 0.03102f
C1940 a_12683_18356# a_12225_18362# 0.02761f
C1941 single_9b_cdac_1.CF[8] single_9b_cdac_1.cdac_sw_9b_0.cdac_sw_3_8.nooverlap_clk_0.sky130_fd_sc_hs__nand2_1_0.Y 0.17948f
C1942 a_6070_19721# a_5999_19822# 0.23992f
C1943 single_9b_cdac_1.cdac_sw_9b_0.cdac_sw_3_7.nooverlap_clk_0.x1.A single_9b_cdac_1.cdac_sw_9b_0.cdac_sw_3_7.nooverlap_clk_0.x10.A 0.05472f
C1944 sar9b_0.net31 a_14051_24100# 0.06346f
C1945 a_26951_29911# single_9b_cdac_0.cdac_sw_9b_0.cdac_sw_3_8.nooverlap_clk_0.sky130_fd_sc_hs__nand2_1_0.Y 0.01076f
C1946 sar9b_0.net15 a_10771_22164# 0.37399f
C1947 single_9b_cdac_0.cdac_sw_9b_0.S[2] single_9b_cdac_0.cdac_sw_9b_0.S[8] 0.22651f
C1948 single_9b_cdac_0.cdac_sw_9b_0.cdac_sw_3_7.nooverlap_clk_0.sky130_fd_sc_hs__nand2_1_0.Y single_9b_cdac_0.cdac_sw_9b_0.cdac_sw_3_7.nooverlap_clk_0.x1.A 0.01003f
C1949 sar9b_0.net17 a_5487_27034# 0.09627f
C1950 a_60565_29911# single_9b_cdac_0.cdac_sw_9b_0.cdac_sw_3_1.nooverlap_clk_0.sky130_fd_sc_hs__nand2_1_0.Y 0.01076f
C1951 a_6726_27060# a_6007_27302# 0.08638f
C1952 uo_out[5] sar9b_0.net3 0.16567f
C1953 a_9078_20506# a_9335_20532# 0.03684f
C1954 a_48343_16877# single_9b_cdac_1.cdac_sw_9b_0.cdac_sw_3_4.nooverlap_clk_0.CLKB0 0.23864f
C1955 a_15400_11316# tdc_0.phase_detector_0.pd_out_0.B 0.48689f
C1956 sar9b_0.net15 a_8431_22682# 0.27815f
C1957 a_5803_25428# a_6537_25670# 0.07009f
C1958 sar9b_0.net37 a_5969_25428# 0.46115f
C1959 sar9b_0.net15 a_12795_23802# 0.70914f
C1960 a_6525_22708# sar9b_0.clknet_1_1__leaf_CLK 0.02177f
C1961 sar9b_0.net41 a_9849_26758# 0.05642f
C1962 a_9115_26516# a_9631_26516# 0.10584f
C1963 sar9b_0.net3 a_12211_26490# 0.34199f
C1964 sar9b_0.clknet_1_0__leaf_CLK sar9b_0._00_ 0.12847f
C1965 a_9849_21318# sar9b_0.net8 0.0431f
C1966 single_9b_cdac_0.cdac_sw_9b_0.cdac_sw_3_5.tg_sw_3_3.SWN single_9b_cdac_0.SW[5] 0.15242f
C1967 a_12427_17812# sar9b_0.net1 0.05304f
C1968 single_9b_cdac_0.SW[2] single_9b_cdac_0.SW[8] 0.01792f
C1969 a_6483_23618# sar9b_0.net37 0.01351f
C1970 single_9b_cdac_0.SW[5] single_9b_cdac_0.cdac_sw_9b_0.S[5] 0.22549f
C1971 sar9b_0.net30 sar9b_0.net29 0.14815f
C1972 VDPWR a_9447_22164# 0.20816f
C1973 single_9b_cdac_1.cdac_sw_9b_0.cdac_sw_3_6.nooverlap_clk_0.x1.A single_9b_cdac_1.cdac_sw_9b_0.cdac_sw_3_6.nooverlap_clk_0.x6.A 0.03729f
C1974 VDPWR a_9095_23618# 0.1421f
C1975 single_9b_cdac_0.cdac_sw_9b_0.cdac_sw_3_4.nooverlap_clk_0.sky130_fd_sc_hs__nand2_1_0.Y a_50962_29911# 0.01076f
C1976 tdc_0.phase_detector_0.INN a_16527_10454# 0.10585f
C1977 a_9335_20532# sar9b_0.net38 0.02457f
C1978 a_7795_26276# sar9b_0.net20 0.06275f
C1979 VDPWR a_12036_24174# 0.32158f
C1980 single_9b_cdac_0.cdac_sw_9b_0.cdac_sw_3_0.nooverlap_clk_0.CLK0 single_9b_cdac_1.CF[2] 0.42016f
C1981 single_9b_cdac_1.cdac_sw_9b_0.S[7] single_9b_cdac_1.cdac_sw_9b_0.S[1] 0.25258f
C1982 single_9b_cdac_1.cdac_sw_9b_0.cdac_sw_3_4.nooverlap_clk_0.CLKB0 single_9b_cdac_1.SW[3] 0.36322f
C1983 single_9b_cdac_0.cdac_sw_9b_0.cdac_sw_3_6.nooverlap_clk_0.x10.A single_9b_cdac_0.cdac_sw_9b_0.cdac_sw_3_6.tg_sw_3_3.SWN 0.69086f
C1984 single_9b_cdac_0.SW[1] single_9b_cdac_1.CF[5] 0.02021f
C1985 a_13308_21076# sar9b_0.net39 0.01658f
C1986 a_13308_26516# sar9b_0.net1 0.16095f
C1987 single_9b_cdac_0.SW[0] a_12795_23802# 0.02468f
C1988 a_10477_19450# a_10935_19444# 0.03063f
C1989 a_13621_22682# a_13403_23086# 0.20964f
C1990 tdc_0.OUTP VDPWR 0.53461f
C1991 single_9b_cdac_0.cdac_sw_9b_0.cdac_sw_3_2.nooverlap_clk_0.CLK0 single_9b_cdac_1.CF[0] 0.42014f
C1992 a_12887_21076# sar9b_0.net39 0.08484f
C1993 sar9b_0.net7 sar9b_0.net8 0.70176f
C1994 sar9b_0.net3 sar9b_0._12_ 0.01812f
C1995 a_6224_25428# sar9b_0.FINAL 0.02323f
C1996 single_9b_cdac_0.cdac_sw_9b_0.cdac_sw_3_5.nooverlap_clk_0.CLKB0 VDPWR 2.81428f
C1997 a_13140_18734# VDPWR 0.27504f
C1998 sar9b_0.net37 sar9b_0._04_ 0.13989f
C1999 single_9b_cdac_0.cdac_sw_9b_0.cdac_sw_3_5.nooverlap_clk_0.x10.A single_9b_cdac_1.CF[5] 0.02149f
C2000 a_7813_22316# VDPWR 0.16498f
C2001 sar9b_0.net34 uo_out[0] 0.09218f
C2002 sar9b_0._07_ VDPWR 0.4866f
C2003 single_9b_cdac_1.cdac_sw_9b_0.cdac_sw_3_0.tg_sw_3_3.SWP single_9b_cdac_1.cdac_sw_9b_0.cdac_sw_3_1.tg_sw_3_3.SWP 0.02813f
C2004 single_9b_cdac_0.cdac_sw_9b_0.cdac_sw_3_3.nooverlap_clk_0.sky130_fd_sc_hs__inv_1_1.A VDPWR 0.38715f
C2005 a_9849_21318# VDPWR 0.21503f
C2006 single_9b_cdac_0.SW[5] single_9b_cdac_0.SW[6] 8.31124f
C2007 single_9b_cdac_0.SW[5] sar9b_0.net31 0.23688f
C2008 ui_in[3] ui_in[2] 0.03102f
C2009 single_9b_cdac_1.cdac_sw_9b_0.cdac_sw_3_6.nooverlap_clk_0.sky130_fd_sc_hs__nand2_1_0.Y single_9b_cdac_1.cdac_sw_9b_0.cdac_sw_3_6.nooverlap_clk_0.sky130_fd_sc_hs__inv_1_1.A 0.12223f
C2010 a_14175_21620# sar9b_0.net15 0.01141f
C2011 a_11045_19418# VDPWR 0.21329f
C2012 single_9b_cdac_1.cdac_sw_9b_0.cdac_sw_3_4.tg_sw_3_3.SWP single_9b_cdac_1.SW[0] 0.08409f
C2013 sar9b_0.net2 sar9b_0.net1 0.51274f
C2014 sar9b_0.net3 sar9b_0.net39 0.32662f
C2015 tdc_0.phase_detector_0.INN tdc_0.phase_detector_0.INP 1.21226f
C2016 clk sar9b_0.net3 0.08416f
C2017 single_9b_cdac_0.SW[5] single_9b_cdac_0.SW[4] 10.2228f
C2018 th_dif_sw_0.th_sw_0.th_sw_main_0.VGS th_dif_sw_0.th_sw_1.CK 0.22597f
C2019 a_11965_20506# a_12312_20910# 0.05116f
C2020 a_8637_20538# a_8825_20532# 0.09972f
C2021 th_dif_sw_0.CKB a_21177_7457# 0.6816f
C2022 a_13623_23252# sar9b_0.net10 0.18451f
C2023 a_16331_9671# a_17125_9355# 0.06748f
C2024 single_9b_cdac_1.cdac_sw_9b_0.cdac_sw_3_1.nooverlap_clk_0.CLK0 a_58824_17740# 0.14695f
C2025 ua[0] single_9b_cdac_0.cdac_sw_9b_0.cdac_sw_3_1.tg_sw_3_3.SWP 1.15122f
C2026 sar9b_0.net27 a_13876_24174# 0.02343f
C2027 ua[0] single_9b_cdac_1.cdac_sw_9b_0.cdac_sw_3_7.nooverlap_clk_0.CLK0 0.12077f
C2028 single_9b_cdac_0.cdac_sw_9b_0.cdac_sw_3_1.nooverlap_clk_0.x10.A single_9b_cdac_0.cdac_sw_9b_0.cdac_sw_3_1.nooverlap_clk_0.x1.A 0.05472f
C2029 single_9b_cdac_1.SW[6] single_9b_cdac_1.SW[0] 0.02369f
C2030 a_11045_19418# a_11392_19822# 0.05116f
C2031 sar9b_0.net37 a_5785_23252# 0.03604f
C2032 a_5435_26516# sar9b_0.net36 0.21505f
C2033 sar9b_0.net7 VDPWR 1.9188f
C2034 a_13308_19810# sar9b_0.net5 0.02663f
C2035 single_9b_cdac_0.cdac_sw_9b_0.cdac_sw_3_4.nooverlap_clk_0.x1.A single_9b_cdac_0.cdac_sw_9b_0.cdac_sw_3_4.nooverlap_clk_0.sky130_fd_sc_hs__inv_8_0.A 0.45521f
C2036 sar9b_0.FINAL a_8085_27066# 0.21321f
C2037 VDPWR a_11121_18900# 0.63007f
C2038 single_9b_cdac_0.cdac_sw_9b_0.cdac_sw_3_1.nooverlap_clk_0.CLKB0 single_9b_cdac_0.cdac_sw_9b_0.S[1] 0.3601f
C2039 single_9b_cdac_0.cdac_sw_9b_0.cdac_sw_3_1.nooverlap_clk_0.sky130_fd_sc_hs__nand2_1_0.Y VDPWR 0.62555f
C2040 single_9b_cdac_1.cdac_sw_9b_0.cdac_sw_3_5.nooverlap_clk_0.sky130_fd_sc_hs__nand2_1_0.Y VDPWR 0.62555f
C2041 a_8545_25978# a_9003_25972# 0.03462f
C2042 single_9b_cdac_0.cdac_sw_9b_0.cdac_sw_3_6.nooverlap_clk_0.CLK0 single_9b_cdac_0.cdac_sw_9b_0.cdac_sw_3_6.tg_sw_3_3.SWP 0.19266f
C2043 single_9b_cdac_1.cdac_sw_9b_0.cdac_sw_3_6.nooverlap_clk_0.sky130_fd_sc_hs__nand2_1_0.Y VDPWR 0.62555f
C2044 tdc_0.delay_gate_ori_0.sky130_fd_sc_hs__and2_1_0.A VDPWR 0.45581f
C2045 sar9b_0._09_ sar9b_0.clknet_0_CLK 0.01447f
C2046 sar9b_0.net25 uo_out[1] 0.05153f
C2047 single_9b_cdac_1.cdac_sw_9b_0.S[0] single_9b_cdac_1.CF[1] 0.01492f
C2048 single_9b_cdac_1.cdac_sw_9b_0.cdac_sw_3_4.nooverlap_clk_0.x4.A VDPWR 0.62443f
C2049 sar9b_0.net15 a_13403_19988# 0.15351f
C2050 single_9b_cdac_1.cdac_sw_9b_0.cdac_sw_3_5.nooverlap_clk_0.x8.A VDPWR 0.84061f
C2051 a_10827_25262# VDPWR 0.20176f
C2052 single_9b_cdac_0.cdac_sw_9b_0.cdac_sw_3_7.nooverlap_clk_0.x10.A single_9b_cdac_0.cdac_sw_9b_0.cdac_sw_3_7.nooverlap_clk_0.x1.A 0.05472f
C2053 single_9b_cdac_0.cdac_sw_9b_0.cdac_sw_3_8.tg_sw_3_3.SWN single_9b_cdac_0.SW[8] 0.15864f
C2054 sar9b_0.net11 sar9b_0.net13 0.28047f
C2055 sar9b_0.net3 a_6516_26516# 0.24357f
C2056 a_14175_23252# single_9b_cdac_1.CF[6] 0.12138f
C2057 ua[0] single_9b_cdac_1.cdac_sw_9b_0.S[3] 1.59199f
C2058 a_49221_17740# single_9b_cdac_1.cdac_sw_9b_0.S[3] 0.22497f
C2059 single_9b_cdac_1.cdac_sw_9b_0.cdac_sw_3_4.nooverlap_clk_0.x10.A single_9b_cdac_1.cdac_sw_9b_0.cdac_sw_3_4.nooverlap_clk_0.x8.A 0.42509f
C2060 a_10166_3438# th_dif_sw_0.th_sw_1.CKB 0.06484f
C2061 a_11045_23494# sar9b_0.net15 0.16532f
C2062 ua[0] single_9b_cdac_1.cdac_sw_9b_0.S[4] 1.94556f
C2063 single_9b_cdac_1.CF[5] a_12887_22714# 0.03043f
C2064 VDPWR a_12887_18900# 0.48265f
C2065 sar9b_0.net11 a_12887_24890# 0.30739f
C2066 a_8545_25978# a_9113_25946# 0.17589f
C2067 a_13511_25794# sar9b_0.net15 0.01764f
C2068 single_9b_cdac_1.SW[8] sar9b_0.net27 0.0412f
C2069 a_5999_19822# VDPWR 0.21774f
C2070 sar9b_0.net15 a_13053_22714# 0.05981f
C2071 a_11121_26516# a_11471_26516# 0.20669f
C2072 a_13308_19810# sar9b_0.net38 0.01773f
C2073 a_6224_25428# VDPWR 0.09475f
C2074 single_9b_cdac_0.cdac_sw_9b_0.cdac_sw_3_6.nooverlap_clk_0.x3.Y single_9b_cdac_1.CF[6] 0.12898f
C2075 ua[0] single_9b_cdac_0.cdac_sw_9b_0.S[0] 1.19231f
C2076 clk a_9115_26516# 0.01768f
C2077 a_9503_20506# VDPWR 0.41061f
C2078 ua[0] single_9b_cdac_1.cdac_sw_9b_0.cdac_sw_3_7.tg_sw_3_3.SWP 1.15121f
C2079 a_5870_19566# sar9b_0._00_ 0.24557f
C2080 sar9b_0.clk_div_0.COUNT\[0\] a_6610_22708# 0.04021f
C2081 single_9b_cdac_1.cdac_sw_9b_0.S[2] single_9b_cdac_1.cdac_sw_9b_0.cdac_sw_3_0.nooverlap_clk_0.CLKB0 0.36013f
C2082 sar9b_0.net27 sar9b_0.net13 0.02672f
C2083 single_9b_cdac_0.cdac_sw_9b_0.cdac_sw_3_7.nooverlap_clk_0.CLKB0 single_9b_cdac_0.cdac_sw_9b_0.cdac_sw_3_8.nooverlap_clk_0.CLKB0 0.02632f
C2084 a_13053_19450# sar9b_0.net5 0.24057f
C2085 sar9b_0._05_ sar9b_0.clk_div_0.COUNT\[3\] 0.16535f
C2086 uo_out[4] VDPWR 0.80891f
C2087 a_13053_24890# sar9b_0.net12 0.01776f
C2088 sar9b_0.net12 a_10732_25250# 0.15794f
C2089 single_9b_cdac_1.SW[7] sar9b_0.net26 0.10571f
C2090 sar9b_0.net8 sar9b_0.net9 0.29302f
C2091 sar9b_0.net15 sar9b_0.net39 0.70719f
C2092 a_13403_23086# VDPWR 0.20032f
C2093 clk sar9b_0.net15 0.04335f
C2094 sar9b_0.net40 sar9b_0.net1 0.01856f
C2095 a_6451_21326# sar9b_0.net15 0.05043f
C2096 a_14175_23252# single_9b_cdac_1.CF[7] 0.11331f
C2097 a_13053_19988# sar9b_0.net6 0.34486f
C2098 VDPWR single_9b_cdac_0.cdac_sw_9b_0.S[7] 4.16163f
C2099 single_9b_cdac_0.cdac_sw_9b_0.cdac_sw_3_3.tg_sw_3_3.SWN single_9b_cdac_0.cdac_sw_9b_0.cdac_sw_3_4.tg_sw_3_3.SWN 0.02624f
C2100 single_9b_cdac_0.cdac_sw_9b_0.cdac_sw_3_3.tg_sw_3_3.SWP single_9b_cdac_0.cdac_sw_9b_0.cdac_sw_3_5.tg_sw_3_3.SWP 0.02666f
C2101 single_9b_cdac_1.cdac_sw_9b_0.cdac_sw_3_0.tg_sw_3_3.SWN single_9b_cdac_1.cdac_sw_9b_0.cdac_sw_3_0.tg_sw_3_3.SWP 3.10626f
C2102 sar9b_0.net42 a_13071_20532# 0.05439f
C2103 sar9b_0.net27 a_13968_19988# 0.04955f
C2104 a_12887_19988# a_13621_20230# 0.07009f
C2105 sar9b_0.net37 a_14143_19962# 0.05462f
C2106 single_9b_cdac_1.CF[4] single_9b_cdac_0.SW[0] 0.47599f
C2107 single_9b_cdac_0.cdac_sw_9b_0.S[1] single_9b_cdac_0.cdac_sw_9b_0.S[2] 16.9154f
C2108 VDPWR a_8085_27066# 0.457f
C2109 uo_out[5] a_9809_27279# 0.1104f
C2110 a_13053_19450# sar9b_0.net38 0.01249f
C2111 single_9b_cdac_0.cdac_sw_9b_0.cdac_sw_3_0.nooverlap_clk_0.x8.A single_9b_cdac_0.cdac_sw_9b_0.cdac_sw_3_0.nooverlap_clk_0.x6.A 0.11216f
C2112 a_13140_18734# sar9b_0.net36 0.03899f
C2113 a_10955_21076# sar9b_0.net42 0.02622f
C2114 a_12887_26516# a_14143_26490# 0.04357f
C2115 a_12887_26516# a_12947_26276# 0.01116f
C2116 a_11392_23252# sar9b_0.net12 0.05234f
C2117 a_10732_19810# a_10311_19450# 0.08671f
C2118 a_8708_19810# sar9b_0.net15 0.17092f
C2119 a_12887_19450# single_9b_cdac_1.SW[2] 0.03118f
C2120 single_9b_cdac_1.cdac_sw_9b_0.S[5] single_9b_cdac_1.CF[6] 0.01664f
C2121 clk single_9b_cdac_0.SW[0] 0.08236f
C2122 a_6483_23618# a_5619_23252# 0.03224f
C2123 VDPWR sar9b_0.net9 1.68577f
C2124 tdc_0.OUTP tdc_0.phase_detector_0.pd_out_0.A 0.26382f
C2125 a_8895_24340# sar9b_0.net15 0.15327f
C2126 sar9b_0.net15 a_12211_21050# 0.3433f
C2127 single_9b_cdac_0.cdac_sw_9b_0.cdac_sw_3_2.nooverlap_clk_0.x1.A single_9b_cdac_0.cdac_sw_9b_0.cdac_sw_3_2.nooverlap_clk_0.x6.A 0.03729f
C2128 single_9b_cdac_0.cdac_sw_9b_0.cdac_sw_3_2.tg_sw_3_3.SWN single_9b_cdac_0.cdac_sw_9b_0.cdac_sw_3_2.nooverlap_clk_0.CLKB0 0.22875f
C2129 a_12795_23802# sar9b_0.net1 0.22038f
C2130 a_10254_2858# th_dif_sw_0.th_sw_1.CKB 0.42927f
C2131 sar9b_0.net37 a_10016_20256# 0.54527f
C2132 uio_out[1] a_5945_26191# 0.10961f
C2133 sar9b_0.net4 a_10016_20256# 0.02723f
C2134 a_9738_20240# sar9b_0.net15 0.23673f
C2135 sar9b_0.net15 a_9167_18874# 0.27945f
C2136 a_13308_26516# a_13053_26516# 0.06418f
C2137 m2_23774_26966# single_9b_cdac_0.cdac_sw_9b_0.cdac_sw_3_8.tg_sw_3_3.SWP 0.37833f
C2138 a_9665_22406# a_10012_22164# 0.05116f
C2139 a_13403_25428# a_13511_25794# 0.05722f
C2140 single_9b_cdac_0.cdac_sw_9b_0.cdac_sw_3_0.nooverlap_clk_0.sky130_fd_sc_hs__nand2_1_0.Y single_9b_cdac_1.CF[2] 0.17948f
C2141 single_9b_cdac_0.SW[7] a_14451_25972# 0.01019f
C2142 single_9b_cdac_0.cdac_sw_9b_0.cdac_sw_3_6.nooverlap_clk_0.x10.A single_9b_cdac_1.CF[6] 0.02149f
C2143 VDPWR a_14175_20532# 0.19323f
C2144 VDPWR a_11376_24162# 0.08534f
C2145 sar9b_0.net10 a_9447_22164# 0.04848f
C2146 a_8987_23252# a_9083_23252# 0.01379f
C2147 single_9b_cdac_1.CF[8] single_9b_cdac_0.cdac_sw_9b_0.cdac_sw_3_8.nooverlap_clk_0.CLKB0 0.26707f
C2148 sar9b_0.clk_div_0.COUNT\[1\] a_8783_23796# 0.04692f
C2149 sar9b_0.net42 sar9b_0.net13 0.07299f
C2150 ua[0] single_9b_cdac_0.SW[1] 0.14864f
C2151 a_12036_24174# sar9b_0.net10 0.03211f
C2152 single_9b_cdac_0.cdac_sw_9b_0.cdac_sw_3_5.nooverlap_clk_0.x4.A single_9b_cdac_0.cdac_sw_9b_0.cdac_sw_3_5.nooverlap_clk_0.x1.A 0.28523f
C2153 single_9b_cdac_1.CF[4] single_9b_cdac_0.cdac_sw_9b_0.cdac_sw_3_3.nooverlap_clk_0.x3.Y 0.12898f
C2154 single_9b_cdac_0.cdac_sw_9b_0.cdac_sw_3_5.tg_sw_3_3.SWN single_9b_cdac_0.cdac_sw_9b_0.cdac_sw_3_5.nooverlap_clk_0.CLKB0 0.22875f
C2155 a_15265_9613# th_dif_sw_0.VCP 0.10972f
C2156 VDPWR single_9b_cdac_1.cdac_sw_9b_0.cdac_sw_3_8.nooverlap_clk_0.sky130_fd_sc_hs__nand2_1_0.Y 0.62555f
C2157 single_9b_cdac_1.cdac_sw_9b_0.cdac_sw_3_2.nooverlap_clk_0.x4.A a_64331_15495# 0.01076f
C2158 single_9b_cdac_0.cdac_sw_9b_0.cdac_sw_3_5.nooverlap_clk_0.CLKB0 single_9b_cdac_0.cdac_sw_9b_0.S[5] 0.36037f
C2159 a_10732_19810# sar9b_0.net5 0.17243f
C2160 sar9b_0.net42 a_11376_26516# 0.16138f
C2161 a_13403_25428# sar9b_0.net39 0.01093f
C2162 a_10935_19444# VDPWR 0.13806f
C2163 a_8803_19822# a_8708_19810# 0.04983f
C2164 a_13419_23796# a_13311_24174# 0.05722f
C2165 single_9b_cdac_0.cdac_sw_9b_0.cdac_sw_3_7.nooverlap_clk_0.CLK0 single_9b_cdac_0.cdac_sw_9b_0.cdac_sw_3_8.nooverlap_clk_0.CLK0 0.02632f
C2166 single_9b_cdac_1.SW[0] single_9b_cdac_1.cdac_sw_9b_0.cdac_sw_3_1.tg_sw_3_3.SWN 0.12586f
C2167 th_dif_sw_0.th_sw_1.th_sw_main_0.VGS th_dif_sw_0.th_sw_1.CK 0.22609f
C2168 single_9b_cdac_1.SW[0] single_9b_cdac_1.CF[2] 0.22502f
C2169 sar9b_0._13_ sar9b_0.clk_div_0.COUNT\[1\] 0.02538f
C2170 sar9b_0.net39 a_9809_27279# 0.02902f
C2171 single_9b_cdac_0.cdac_sw_9b_0.S[5] a_39616_26990# 0.22512f
C2172 single_9b_cdac_1.cdac_sw_9b_0.cdac_sw_3_3.nooverlap_clk_0.x10.A single_9b_cdac_1.cdac_sw_9b_0.cdac_sw_3_3.nooverlap_clk_0.sky130_fd_sc_hs__inv_8_0.A 0.05105f
C2173 a_10679_25428# a_11413_25670# 0.05348f
C2174 single_9b_cdac_1.cdac_sw_9b_0.cdac_sw_3_5.nooverlap_clk_0.CLK0 single_9b_cdac_1.cdac_sw_9b_0.cdac_sw_3_5.tg_sw_3_3.SWN 0.17533f
C2175 sar9b_0.net26 a_13623_24340# 0.23399f
C2176 a_5619_23252# a_5785_23252# 0.96639f
C2177 a_9543_19748# a_9535_19962# 0.02013f
C2178 sar9b_0.net15 a_8987_23252# 0.15261f
C2179 sar9b_0.net4 a_9635_24314# 0.07354f
C2180 single_9b_cdac_1.cdac_sw_9b_0.cdac_sw_3_5.nooverlap_clk_0.CLKB0 single_9b_cdac_1.cdac_sw_9b_0.cdac_sw_3_5.tg_sw_3_3.SWN 0.22879f
C2181 sar9b_0.net15 a_11121_23802# 0.06469f
C2182 single_9b_cdac_1.cdac_sw_9b_0.cdac_sw_3_5.nooverlap_clk_0.x10.A single_9b_cdac_1.cdac_sw_9b_0.cdac_sw_3_5.nooverlap_clk_0.sky130_fd_sc_hs__inv_8_0.A 0.05105f
C2183 single_9b_cdac_0.cdac_sw_9b_0.S[4] VDPWR 4.15222f
C2184 single_9b_cdac_1.cdac_sw_9b_0.S[8] a_24332_16877# 0.59531f
C2185 a_11567_23226# sar9b_0.net42 0.09257f
C2186 a_46159_29911# single_9b_cdac_0.cdac_sw_9b_0.cdac_sw_3_3.nooverlap_clk_0.sky130_fd_sc_hs__nand2_1_0.Y 0.01076f
C2187 uo_out[5] uo_out[6] 3.02379f
C2188 uo_out[7] ui_in[0] 0.06786f
C2189 a_10732_19810# sar9b_0.net38 0.02478f
C2190 single_9b_cdac_0.cdac_sw_9b_0.S[8] th_dif_sw_0.VCN 0.82395f
C2191 sar9b_0.net3 sar9b_0.clknet_1_1__leaf_CLK 0.12972f
C2192 a_7813_22316# sar9b_0.clk_div_0.COUNT\[3\] 0.04228f
C2193 single_9b_cdac_1.SW[8] single_9b_cdac_1.cdac_sw_9b_0.cdac_sw_3_8.nooverlap_clk_0.CLK0 0.24288f
C2194 sar9b_0._13_ a_6171_22714# 0.0175f
C2195 a_14143_25188# VDPWR 0.36677f
C2196 sar9b_0.net40 a_10679_25428# 0.02981f
C2197 sar9b_0.net3 a_7345_21594# 0.0248f
C2198 a_12887_19450# VDPWR 0.41681f
C2199 single_9b_cdac_1.cdac_sw_9b_0.cdac_sw_3_5.nooverlap_clk_0.x6.A single_9b_cdac_1.cdac_sw_9b_0.cdac_sw_3_5.nooverlap_clk_0.x4.A 0.12431f
C2200 single_9b_cdac_0.cdac_sw_9b_0.cdac_sw_3_2.tg_sw_3_3.SWP single_9b_cdac_0.cdac_sw_9b_0.cdac_sw_3_2.tg_sw_3_3.SWN 3.10626f
C2201 a_9849_21318# a_9631_21076# 0.20964f
C2202 a_9281_21076# a_10371_21050# 0.04242f
C2203 a_9115_21076# a_10196_21076# 0.10236f
C2204 dw_12589_1395# th_dif_sw_0.th_sw_1.CKB 0.24193f
C2205 sar9b_0.net2 a_11192_22164# 0.01121f
C2206 single_9b_cdac_1.cdac_sw_9b_0.cdac_sw_3_5.nooverlap_clk_0.x1.A single_9b_cdac_1.cdac_sw_9b_0.cdac_sw_3_5.nooverlap_clk_0.x4.A 0.28523f
C2207 single_9b_cdac_1.cdac_sw_9b_0.cdac_sw_3_0.nooverlap_clk_0.x1.A single_9b_cdac_1.cdac_sw_9b_0.cdac_sw_3_0.nooverlap_clk_0.x3.Y 0.07579f
C2208 sar9b_0.net15 a_12225_18362# 0.0242f
C2209 VDPWR a_43540_26999# 1.81495f
C2210 single_9b_cdac_1.cdac_sw_9b_0.cdac_sw_3_2.nooverlap_clk_0.x10.A single_9b_cdac_1.cdac_sw_9b_0.cdac_sw_3_2.nooverlap_clk_0.sky130_fd_sc_hs__inv_8_0.A 0.05105f
C2211 single_9b_cdac_0.cdac_sw_9b_0.cdac_sw_3_5.nooverlap_clk_0.CLKB0 single_9b_cdac_0.SW[4] 0.01402f
C2212 a_6537_25670# sar9b_0.net3 0.17643f
C2213 a_7055_26350# a_6960_26338# 0.04983f
C2214 single_9b_cdac_1.cdac_sw_9b_0.S[7] a_29134_16877# 0.59531f
C2215 a_12887_24890# a_13308_25250# 0.09313f
C2216 single_9b_cdac_1.SW[7] single_9b_cdac_1.CF[7] 2.07035f
C2217 single_9b_cdac_0.SW[7] single_9b_cdac_0.SW[3] 0.026f
C2218 single_9b_cdac_0.cdac_sw_9b_0.cdac_sw_3_5.nooverlap_clk_0.sky130_fd_sc_hs__inv_8_0.A VDPWR 0.96901f
C2219 single_9b_cdac_1.CF[4] sar9b_0.net30 0.01417f
C2220 sar9b_0.net3 a_6960_26338# 0.02814f
C2221 single_9b_cdac_1.CF[1] single_9b_cdac_1.cdac_sw_9b_0.cdac_sw_3_2.tg_sw_3_3.SWN 0.03484f
C2222 a_12112_26338# sar9b_0.FINAL 0.02219f
C2223 a_7145_23226# sar9b_0.net3 0.05785f
C2224 single_9b_cdac_0.cdac_sw_9b_0.cdac_sw_3_3.nooverlap_clk_0.x4.A VDPWR 0.62443f
C2225 single_9b_cdac_0.SW[2] single_9b_cdac_0.cdac_sw_9b_0.cdac_sw_3_0.tg_sw_3_3.SWP 0.17157f
C2226 a_6315_21050# a_5884_21326# 0.01727f
C2227 single_9b_cdac_1.cdac_sw_9b_0.cdac_sw_3_1.nooverlap_clk_0.x4.A a_59529_15495# 0.01076f
C2228 single_9b_cdac_0.cdac_sw_9b_0.S[3] single_9b_cdac_0.cdac_sw_9b_0.S[7] 0.45223f
C2229 sar9b_0.net17 uio_out[1] 0.23492f
C2230 a_5951_26516# a_6094_27060# 0.01057f
C2231 sar9b_0.clknet_1_1__leaf_CLK a_6778_22682# 0.05488f
C2232 a_14175_23252# VDPWR 0.19777f
C2233 single_9b_cdac_1.SW[6] a_34814_17740# 0.18991f
C2234 single_9b_cdac_0.cdac_sw_9b_0.cdac_sw_3_1.nooverlap_clk_0.sky130_fd_sc_hs__inv_1_1.A single_9b_cdac_0.cdac_sw_9b_0.cdac_sw_3_1.nooverlap_clk_0.sky130_fd_sc_hs__nand2_1_0.Y 0.12223f
C2235 a_14143_19748# a_14143_19962# 0.02772f
C2236 single_9b_cdac_0.cdac_sw_9b_0.cdac_sw_3_7.nooverlap_clk_0.x4.A single_9b_cdac_0.cdac_sw_9b_0.cdac_sw_3_7.nooverlap_clk_0.sky130_fd_sc_hs__nand2_1_0.Y 0.01751f
C2237 a_6539_25978# a_6705_25978# 0.61646f
C2238 a_13511_19266# VDPWR 0.14211f
C2239 a_13899_24340# single_9b_cdac_0.SW[1] 0.11137f
C2240 sar9b_0.net3 a_5945_26191# 0.02903f
C2241 a_11691_25978# a_12772_26350# 0.10236f
C2242 VDPWR a_33936_26999# 1.81495f
C2243 single_9b_cdac_0.SW[5] single_9b_cdac_0.cdac_sw_9b_0.cdac_sw_3_6.nooverlap_clk_0.CLKB0 0.0187f
C2244 single_9b_cdac_1.cdac_sw_9b_0.cdac_sw_3_7.nooverlap_clk_0.CLK0 single_9b_cdac_1.cdac_sw_9b_0.cdac_sw_3_7.tg_sw_3_3.SWP 0.19266f
C2245 a_13053_22714# sar9b_0.net1 0.27267f
C2246 sar9b_0.net4 a_9727_23226# 0.0257f
C2247 sar9b_0.clk_div_0.COUNT\[0\] a_6149_23770# 0.04703f
C2248 single_9b_cdac_0.cdac_sw_9b_0.cdac_sw_3_6.nooverlap_clk_0.x3.Y VDPWR 0.3196f
C2249 a_21684_3438# th_dif_sw_0.th_sw_1.CK 0.12114f
C2250 VDPWR a_14897_9355# 0.01057f
C2251 a_10311_24890# a_10732_25250# 0.09313f
C2252 sar9b_0.net3 a_12772_26350# 0.23966f
C2253 VDPWR a_7919_23802# 0.69806f
C2254 single_9b_cdac_1.cdac_sw_9b_0.cdac_sw_3_3.tg_sw_3_3.SWP a_43540_16877# 0.04592f
C2255 single_9b_cdac_0.SW[2] single_9b_cdac_0.SW[0] 0.01314f
C2256 sar9b_0.net11 a_8379_24340# 0.20513f
C2257 single_9b_cdac_0.cdac_sw_9b_0.S[5] single_9b_cdac_0.cdac_sw_9b_0.S[7] 1.05598f
C2258 a_5601_26516# a_6516_26516# 0.11842f
C2259 single_9b_cdac_1.cdac_sw_9b_0.S[4] single_9b_cdac_1.cdac_sw_9b_0.S[3] 14.2241f
C2260 uo_out[6] sar9b_0.net39 0.02894f
C2261 ui_in[2] ui_in[1] 0.03102f
C2262 a_11121_18900# a_11689_19142# 0.17589f
C2263 a_10955_18900# a_11471_18900# 0.11082f
C2264 single_9b_cdac_0.cdac_sw_9b_0.S[1] single_9b_cdac_1.CF[2] 0.01515f
C2265 VDPWR a_13623_25972# 0.21137f
C2266 sar9b_0.net39 sar9b_0.net1 0.44098f
C2267 single_9b_cdac_1.SW[7] single_9b_cdac_1.SW[4] 0.05281f
C2268 a_13053_26516# a_13403_26516# 0.2298f
C2269 sar9b_0.clk_div_0.COUNT\[1\] a_7203_22682# 0.01073f
C2270 uo_out[6] clk 0.19899f
C2271 single_9b_cdac_0.SW[5] sar9b_0.net32 0.03505f
C2272 ui_in[0] uio_out[1] 0.99066f
C2273 a_11857_25978# a_12207_26350# 0.21013f
C2274 a_9503_20506# sar9b_0.clk_div_0.COUNT\[3\] 0.12819f
C2275 single_9b_cdac_1.SW[7] single_9b_cdac_1.SW[2] 0.21936f
C2276 single_9b_cdac_0.cdac_sw_9b_0.S[6] single_9b_cdac_0.cdac_sw_9b_0.S[8] 1.18098f
C2277 sar9b_0._15_ sar9b_0.net35 0.11482f
C2278 a_11121_21076# a_11471_21076# 0.2298f
C2279 single_9b_cdac_1.SW[0] th_dif_sw_0.VCN 0.11809f
C2280 sar9b_0.net2 sar9b_0.net6 0.19049f
C2281 single_9b_cdac_1.cdac_sw_9b_0.cdac_sw_3_1.nooverlap_clk_0.x6.A single_9b_cdac_1.cdac_sw_9b_0.cdac_sw_3_1.nooverlap_clk_0.x1.A 0.03729f
C2282 a_12887_22164# a_14143_22138# 0.04357f
C2283 sar9b_0.net15 a_7345_21594# 0.02165f
C2284 sar9b_0.net37 a_6219_22316# 0.02558f
C2285 a_9097_22164# a_9555_22530# 0.03462f
C2286 a_13621_24858# sar9b_0.net32 0.01732f
C2287 single_9b_cdac_0.cdac_sw_9b_0.cdac_sw_3_8.nooverlap_clk_0.sky130_fd_sc_hs__inv_8_0.A single_9b_cdac_0.cdac_sw_9b_0.cdac_sw_3_8.nooverlap_clk_0.x1.A 0.45521f
C2288 single_9b_cdac_1.SW[6] sar9b_0.net41 0.01211f
C2289 single_9b_cdac_1.CF[6] sar9b_0.net12 0.07211f
C2290 a_11935_25402# sar9b_0.net15 0.36009f
C2291 sar9b_0.net15 a_11303_25794# 0.0122f
C2292 single_9b_cdac_1.cdac_sw_9b_0.cdac_sw_3_2.nooverlap_clk_0.x8.A single_9b_cdac_1.cdac_sw_9b_0.cdac_sw_3_2.nooverlap_clk_0.sky130_fd_sc_hs__inv_1_1.A 0.08121f
C2293 single_9b_cdac_1.SW[6] single_9b_cdac_1.cdac_sw_9b_0.cdac_sw_3_6.tg_sw_3_3.SWN 0.14966f
C2294 single_9b_cdac_1.cdac_sw_9b_0.cdac_sw_3_0.nooverlap_clk_0.sky130_fd_sc_hs__inv_8_0.A single_9b_cdac_1.cdac_sw_9b_0.cdac_sw_3_0.nooverlap_clk_0.x8.A 0.04988f
C2295 dw_17224_1400# th_dif_sw_0.th_sw_1.CKB 0.24442f
C2296 single_9b_cdac_0.cdac_sw_9b_0.cdac_sw_3_4.tg_sw_3_3.SWP single_9b_cdac_0.SW[3] 0.17268f
C2297 single_9b_cdac_0.cdac_sw_9b_0.cdac_sw_3_2.nooverlap_clk_0.sky130_fd_sc_hs__nand2_1_0.Y single_9b_cdac_0.cdac_sw_9b_0.cdac_sw_3_2.nooverlap_clk_0.x1.A 0.01003f
C2298 a_13053_22164# a_13511_22530# 0.03462f
C2299 tdc_0.RDY a_16185_13034# 0.06167f
C2300 th_dif_sw_0.th_sw_0.th_sw_main_0.VGS th_dif_sw_0.th_sw_1.CKB 0.3545f
C2301 a_6171_22714# a_7203_22682# 0.04721f
C2302 single_9b_cdac_1.SW[0] single_9b_cdac_1.CF[0] 1.83507f
C2303 single_9b_cdac_1.cdac_sw_9b_0.cdac_sw_3_8.nooverlap_clk_0.x1.A single_9b_cdac_1.cdac_sw_9b_0.cdac_sw_3_8.nooverlap_clk_0.sky130_fd_sc_hs__inv_1_1.A 0.10429f
C2304 a_13308_21076# single_9b_cdac_1.SW[8] 0.01079f
C2305 single_9b_cdac_1.cdac_sw_9b_0.cdac_sw_3_0.nooverlap_clk_0.x8.A single_9b_cdac_1.cdac_sw_9b_0.cdac_sw_3_0.nooverlap_clk_0.x4.A 0.0303f
C2306 a_8911_19444# VDPWR 0.13239f
C2307 sar9b_0.net3 a_10196_26516# 0.26767f
C2308 sar9b_0.net35 a_8471_23252# 0.03287f
C2309 a_10311_23252# sar9b_0.net2 0.5037f
C2310 single_9b_cdac_1.cdac_sw_9b_0.S[5] VDPWR 4.15352f
C2311 single_9b_cdac_1.cdac_sw_9b_0.cdac_sw_3_3.nooverlap_clk_0.sky130_fd_sc_hs__nand2_1_0.Y single_9b_cdac_1.cdac_sw_9b_0.cdac_sw_3_3.nooverlap_clk_0.x8.A 0.26942f
C2312 single_9b_cdac_1.SW[8] a_12887_21076# 0.03434f
C2313 a_12112_26338# VDPWR 0.0973f
C2314 sar9b_0.net22 sar9b_0.net40 0.06292f
C2315 a_13403_21076# VDPWR 0.19712f
C2316 a_10477_24890# sar9b_0.net11 0.56172f
C2317 a_11045_24858# a_11392_25262# 0.05116f
C2318 sar9b_0.net10 sar9b_0.net9 0.16534f
C2319 single_9b_cdac_1.SW[8] single_9b_cdac_1.cdac_sw_9b_0.S[8] 0.22497f
C2320 single_9b_cdac_1.CF[8] single_9b_cdac_0.cdac_sw_9b_0.cdac_sw_3_8.tg_sw_3_3.SWP 0.10499f
C2321 single_9b_cdac_1.SW[0] single_9b_cdac_1.cdac_sw_9b_0.cdac_sw_3_6.nooverlap_clk_0.CLKB0 0.05632f
C2322 ua[2] ua[4] 0.06538f
C2323 single_9b_cdac_0.cdac_sw_9b_0.cdac_sw_3_7.tg_sw_3_3.SWP single_9b_cdac_0.cdac_sw_9b_0.S[7] 1.56115f
C2324 single_9b_cdac_1.cdac_sw_9b_0.cdac_sw_3_4.nooverlap_clk_0.x8.A single_9b_cdac_1.cdac_sw_9b_0.cdac_sw_3_4.nooverlap_clk_0.sky130_fd_sc_hs__nand2_1_0.Y 0.26942f
C2325 a_6061_19988# sar9b_0.clknet_1_0__leaf_CLK 0.2389f
C2326 a_12887_18900# a_13053_18900# 0.74936f
C2327 a_11852_22164# a_10937_22164# 0.12532f
C2328 a_11192_22164# a_10771_22164# 0.08341f
C2329 sar9b_0.net1 a_13308_22164# 0.15825f
C2330 single_9b_cdac_0.SW[1] single_9b_cdac_0.cdac_sw_9b_0.cdac_sw_3_1.tg_sw_3_3.SWP 0.17156f
C2331 a_13403_23086# a_13308_23074# 0.04983f
C2332 VDPWR single_9b_cdac_0.cdac_sw_9b_0.cdac_sw_3_6.nooverlap_clk_0.x10.A 0.95338f
C2333 a_8895_26350# VDPWR 0.21206f
C2334 a_8931_22164# sar9b_0.net15 0.29754f
C2335 sar9b_0.net15 a_13968_26516# 0.24495f
C2336 a_11691_25978# sar9b_0.net13 0.02112f
C2337 sar9b_0._13_ sar9b_0._12_ 0.46283f
C2338 clk a_8783_23796# 0.0109f
C2339 single_9b_cdac_0.cdac_sw_9b_0.S[4] single_9b_cdac_0.cdac_sw_9b_0.S[3] 14.2241f
C2340 single_9b_cdac_0.SW[3] single_9b_cdac_1.CF[5] 0.02002f
C2341 a_12683_18356# a_12575_18734# 0.05722f
C2342 sar9b_0.net15 a_11505_22406# 0.17945f
C2343 sar9b_0.net17 sar9b_0.net3 0.15787f
C2344 th_dif_sw_0.th_sw_1.th_sw_main_0.VGS th_dif_sw_0.VCP 0.14643f
C2345 sar9b_0.net3 sar9b_0.net13 0.41198f
C2346 a_6726_27060# a_6163_27034# 0.04983f
C2347 sar9b_0.net41 a_12312_20910# 0.01116f
C2348 a_9503_20506# a_9335_20532# 0.31086f
C2349 a_6315_21050# sar9b_0.net3 0.01144f
C2350 single_9b_cdac_0.SW[7] single_9b_cdac_0.cdac_sw_9b_0.cdac_sw_3_7.nooverlap_clk_0.CLK0 0.24371f
C2351 single_9b_cdac_0.cdac_sw_9b_0.S[8] single_9b_cdac_1.CF[3] 0.01297f
C2352 sar9b_0.net15 a_8951_22950# 0.67806f
C2353 sar9b_0.net37 a_6319_25428# 0.02999f
C2354 a_5803_25428# a_7059_25402# 0.04357f
C2355 single_9b_cdac_1.CF[7] single_9b_cdac_1.cdac_sw_9b_0.cdac_sw_3_7.nooverlap_clk_0.sky130_fd_sc_hs__inv_1_1.A 0.01887f
C2356 sar9b_0.net15 a_13529_23770# 0.1848f
C2357 a_8637_20538# sar9b_0.net4 0.03348f
C2358 a_9115_26516# a_10196_26516# 0.10232f
C2359 ua[0] single_9b_cdac_0.cdac_sw_9b_0.cdac_sw_3_1.nooverlap_clk_0.CLKB0 0.1236f
C2360 sar9b_0.net7 sar9b_0.net43 0.13948f
C2361 sar9b_0.net11 sar9b_0.net38 0.02775f
C2362 single_9b_cdac_0.cdac_sw_9b_0.cdac_sw_3_7.nooverlap_clk_0.x3.Y single_9b_cdac_1.CF[7] 0.12898f
C2363 sar9b_0.net3 a_11376_26516# 0.0167f
C2364 a_11287_22164# a_11383_22164# 0.01379f
C2365 single_9b_cdac_0.cdac_sw_9b_0.cdac_sw_3_0.nooverlap_clk_0.sky130_fd_sc_hs__inv_1_1.A single_9b_cdac_0.cdac_sw_9b_0.cdac_sw_3_0.nooverlap_clk_0.x1.A 0.10429f
C2366 sar9b_0.net15 a_14175_18356# 0.01912f
C2367 a_10371_21050# sar9b_0.net8 0.06321f
C2368 sar9b_0.net28 a_14143_22138# 0.0101f
C2369 single_9b_cdac_0.cdac_sw_9b_0.cdac_sw_3_0.nooverlap_clk_0.x8.A single_9b_cdac_1.CF[2] 0.31534f
C2370 a_10166_3438# a_10254_2858# 0.99758f
C2371 sar9b_0.net15 a_13876_24174# 0.23693f
C2372 single_9b_cdac_0.cdac_sw_9b_0.S[4] single_9b_cdac_0.cdac_sw_9b_0.S[5] 18.9631f
C2373 single_9b_cdac_1.SW[7] VDPWR 2.10117f
C2374 a_9252_22708# a_8912_22824# 0.03462f
C2375 a_13308_23074# sar9b_0.net9 0.01364f
C2376 VDPWR a_10012_22164# 0.3002f
C2377 single_9b_cdac_0.cdac_sw_9b_0.S[1] th_dif_sw_0.VCN 0.10984p
C2378 sar9b_0._09_ sar9b_0._12_ 0.08974f
C2379 single_9b_cdac_0.cdac_sw_9b_0.cdac_sw_3_5.nooverlap_clk_0.sky130_fd_sc_hs__nand2_1_0.Y VDPWR 0.62555f
C2380 sar9b_0.net29 a_14143_22138# 0.10514f
C2381 a_8379_25978# sar9b_0.net20 0.11947f
C2382 a_14143_25402# a_14451_25972# 0.01215f
C2383 sar9b_0.net15 a_10955_21076# 0.70153f
C2384 VDPWR single_9b_cdac_0.cdac_sw_9b_0.cdac_sw_3_8.nooverlap_clk_0.CLKB0 2.81428f
C2385 a_11397_20538# a_11855_20532# 0.02761f
C2386 ui_in[0] sar9b_0.net3 0.02122f
C2387 sar9b_0.net40 a_10311_23252# 0.03063f
C2388 single_9b_cdac_0.SW[2] sar9b_0.net30 0.03962f
C2389 single_9b_cdac_1.cdac_sw_9b_0.cdac_sw_3_4.nooverlap_clk_0.CLK0 single_9b_cdac_1.cdac_sw_9b_0.cdac_sw_3_4.tg_sw_3_3.SWN 0.17533f
C2390 single_9b_cdac_0.SW[0] a_13529_23770# 0.01388f
C2391 a_13621_22682# a_13968_23086# 0.05116f
C2392 single_9b_cdac_1.cdac_sw_9b_0.S[0] VDPWR 4.15031f
C2393 a_63626_17740# single_9b_cdac_1.SW[0] 0.18991f
C2394 sar9b_0.clk_div_0.COUNT\[1\] a_6631_24590# 0.07398f
C2395 sar9b_0.net15 single_9b_cdac_1.SW[1] 0.1248f
C2396 single_9b_cdac_1.cdac_sw_9b_0.cdac_sw_3_1.nooverlap_clk_0.sky130_fd_sc_hs__nand2_1_0.Y a_60565_15501# 0.01076f
C2397 single_9b_cdac_0.cdac_sw_9b_0.cdac_sw_3_0.nooverlap_clk_0.sky130_fd_sc_hs__inv_1_1.A VDPWR 0.38733f
C2398 sar9b_0.net12 sar9b_0.FINAL 0.06057f
C2399 a_8471_23252# a_9205_23494# 0.07009f
C2400 single_9b_cdac_0.SW[0] a_13876_24174# 0.01506f
C2401 a_12225_18362# sar9b_0.net1 0.0379f
C2402 th_dif_sw_0.VCN th_dif_sw_0.th_sw_1.CK 1.01731f
C2403 a_14451_18356# a_14143_18874# 0.01246f
C2404 single_9b_cdac_0.SW[7] th_dif_sw_0.VCN 0.09475f
C2405 a_6451_21326# sar9b_0._09_ 0.06842f
C2406 a_10371_21050# VDPWR 0.3705f
C2407 single_9b_cdac_1.SW[8] sar9b_0.net15 0.04087f
C2408 a_64331_29917# single_9b_cdac_0.cdac_sw_9b_0.cdac_sw_3_2.nooverlap_clk_0.x4.A 0.01076f
C2409 a_10477_24890# sar9b_0.net42 0.03511f
C2410 single_9b_cdac_1.cdac_sw_9b_0.cdac_sw_3_0.nooverlap_clk_0.CLK0 single_9b_cdac_1.CF[2] 0.42016f
C2411 single_9b_cdac_0.cdac_sw_9b_0.cdac_sw_3_2.nooverlap_clk_0.x8.A single_9b_cdac_0.cdac_sw_9b_0.cdac_sw_3_2.nooverlap_clk_0.x6.A 0.11216f
C2412 single_9b_cdac_1.CF[5] single_9b_cdac_1.CF[2] 0.04546f
C2413 single_9b_cdac_1.SW[0] single_9b_cdac_1.cdac_sw_9b_0.cdac_sw_3_8.nooverlap_clk_0.CLKB0 0.05632f
C2414 single_9b_cdac_0.cdac_sw_9b_0.cdac_sw_3_5.nooverlap_clk_0.CLKB0 single_9b_cdac_0.cdac_sw_9b_0.cdac_sw_3_3.nooverlap_clk_0.CLKB0 0.02632f
C2415 a_14143_25188# sar9b_0.net31 0.0249f
C2416 sar9b_0.net11 a_8800_24340# 0.16512f
C2417 sar9b_0.net15 sar9b_0.net13 0.73105f
C2418 a_8379_25978# sar9b_0.net35 0.03015f
C2419 single_9b_cdac_1.cdac_sw_9b_0.cdac_sw_3_3.nooverlap_clk_0.x4.A single_9b_cdac_1.cdac_sw_9b_0.cdac_sw_3_3.nooverlap_clk_0.sky130_fd_sc_hs__nand2_1_0.Y 0.01751f
C2420 single_9b_cdac_0.cdac_sw_9b_0.S[4] single_9b_cdac_0.SW[4] 0.22983f
C2421 a_13621_21318# a_13403_21076# 0.20964f
C2422 sar9b_0.net42 sar9b_0.net5 0.01576f
C2423 a_8910_20532# a_8825_20532# 0.03733f
C2424 a_6315_21050# sar9b_0.net15 0.14489f
C2425 a_12487_20836# a_12312_20910# 0.23366f
C2426 a_12427_17812# sar9b_0.net2 0.19347f
C2427 ua[0] single_9b_cdac_1.cdac_sw_9b_0.cdac_sw_3_4.tg_sw_3_3.SWP 1.15113f
C2428 single_9b_cdac_1.cdac_sw_9b_0.cdac_sw_3_5.tg_sw_3_3.SWP single_9b_cdac_1.cdac_sw_9b_0.cdac_sw_3_3.tg_sw_3_3.SWP 0.02666f
C2429 single_9b_cdac_1.cdac_sw_9b_0.cdac_sw_3_8.nooverlap_clk_0.x10.A single_9b_cdac_1.cdac_sw_9b_0.cdac_sw_3_8.nooverlap_clk_0.x8.A 0.42509f
C2430 a_8085_27066# a_8653_27034# 0.17589f
C2431 single_9b_cdac_1.SW[0] single_9b_cdac_1.CF[3] 0.2246f
C2432 a_12887_24890# sar9b_0.net15 0.33029f
C2433 ua[0] single_9b_cdac_0.cdac_sw_9b_0.S[2] 1.2071f
C2434 a_11231_20538# sar9b_0.net8 0.22602f
C2435 sar9b_0.net15 a_13968_25262# 0.22495f
C2436 sar9b_0.net37 a_6058_23618# 0.01091f
C2437 single_9b_cdac_0.cdac_sw_9b_0.cdac_sw_3_0.nooverlap_clk_0.CLKB0 single_9b_cdac_0.cdac_sw_9b_0.cdac_sw_3_0.tg_sw_3_3.SWP 1.71649f
C2438 sar9b_0.net39 a_13053_26516# 0.03104f
C2439 sar9b_0.FINAL a_8435_27438# 0.01056f
C2440 VDPWR a_11471_18900# 0.22881f
C2441 sar9b_0.net2 a_8637_23252# 0.23713f
C2442 sar9b_0._14_ VDPWR 0.68215f
C2443 ua[0] single_9b_cdac_1.SW[6] 0.13161f
C2444 single_9b_cdac_0.SW[4] a_43540_26999# 0.28324f
C2445 sar9b_0.net28 sar9b_0.net29 0.42724f
C2446 sar9b_0._14_ a_7735_21076# 0.07921f
C2447 a_8895_26350# a_9003_25972# 0.05722f
C2448 dw_12589_1395# a_10166_3438# 26.7687f
C2449 single_9b_cdac_0.cdac_sw_9b_0.cdac_sw_3_1.nooverlap_clk_0.x8.A single_9b_cdac_0.cdac_sw_9b_0.cdac_sw_3_1.nooverlap_clk_0.sky130_fd_sc_hs__inv_8_0.A 0.04988f
C2450 single_9b_cdac_0.cdac_sw_9b_0.S[1] single_9b_cdac_0.cdac_sw_9b_0.S[6] 0.26325f
C2451 sar9b_0.net15 a_13968_19988# 0.24256f
C2452 single_9b_cdac_1.cdac_sw_9b_0.cdac_sw_3_5.nooverlap_clk_0.x6.A VDPWR 0.38397f
C2453 sar9b_0.net15 a_13053_25428# 0.08036f
C2454 single_9b_cdac_0.cdac_sw_9b_0.cdac_sw_3_5.nooverlap_clk_0.CLKB0 single_9b_cdac_0.cdac_sw_9b_0.cdac_sw_3_6.nooverlap_clk_0.CLKB0 0.02632f
C2455 single_9b_cdac_1.cdac_sw_9b_0.cdac_sw_3_5.nooverlap_clk_0.x1.A VDPWR 0.75853f
C2456 single_9b_cdac_0.cdac_sw_9b_0.S[4] single_9b_cdac_0.cdac_sw_9b_0.cdac_sw_3_3.nooverlap_clk_0.CLK0 0.28813f
C2457 a_11392_25262# VDPWR 0.28788f
C2458 sar9b_0.net43 sar9b_0.net9 0.0305f
C2459 sar9b_0.net3 sar9b_0.net18 0.15234f
C2460 sar9b_0.net42 sar9b_0.net38 0.1091f
C2461 single_9b_cdac_0.SW[6] a_33936_26999# 0.28324f
C2462 sar9b_0.clk_div_0.COUNT\[1\] sar9b_0.clknet_0_CLK 0.73999f
C2463 single_9b_cdac_1.cdac_sw_9b_0.cdac_sw_3_4.nooverlap_clk_0.x10.A single_9b_cdac_1.cdac_sw_9b_0.cdac_sw_3_4.nooverlap_clk_0.x1.A 0.05472f
C2464 a_10016_20256# sar9b_0.net41 0.04632f
C2465 th_dif_sw_0.th_sw_1.th_sw_main_0.VGS th_dif_sw_0.th_sw_1.CKB 0.3545f
C2466 a_11567_23226# sar9b_0.net15 0.29873f
C2467 VDPWR a_13621_19142# 0.20633f
C2468 m2_23774_26966# single_9b_cdac_0.cdac_sw_9b_0.S[8] 0.58106f
C2469 sar9b_0.net42 a_11855_20532# 0.02685f
C2470 single_9b_cdac_1.CF[8] single_9b_cdac_1.cdac_sw_9b_0.S[7] 0.01879f
C2471 sar9b_0.net11 a_13621_24858# 0.01582f
C2472 a_8545_25978# a_9635_26276# 0.04242f
C2473 a_9113_25946# a_8895_26350# 0.20964f
C2474 single_9b_cdac_1.cdac_sw_9b_0.S[5] single_9b_cdac_1.cdac_sw_9b_0.S[6] 18.1238f
C2475 a_11045_24858# a_10935_24884# 0.09774f
C2476 a_8287_19450# VDPWR 0.46483f
C2477 sar9b_0.net18 sar9b_0.net19 0.01987f
C2478 VDPWR a_6587_21852# 0.12235f
C2479 a_11121_26516# a_12036_26516# 0.11876f
C2480 single_9b_cdac_0.cdac_sw_9b_0.cdac_sw_3_4.nooverlap_clk_0.x8.A single_9b_cdac_0.cdac_sw_9b_0.cdac_sw_3_4.nooverlap_clk_0.sky130_fd_sc_hs__inv_8_0.A 0.04988f
C2481 a_11231_20538# VDPWR 0.48064f
C2482 single_9b_cdac_1.CF[5] single_9b_cdac_0.cdac_sw_9b_0.cdac_sw_3_5.nooverlap_clk_0.CLK0 0.42014f
C2483 VDPWR sar9b_0.net12 2.0969f
C2484 sar9b_0.clk_div_0.COUNT\[0\] a_7035_22708# 0.06389f
C2485 a_6674_21050# sar9b_0._08_ 0.26589f
C2486 a_13623_24340# VDPWR 0.23337f
C2487 sar9b_0.net23 sar9b_0.net3 0.08683f
C2488 single_9b_cdac_1.CF[8] single_9b_cdac_0.cdac_sw_9b_0.cdac_sw_3_8.nooverlap_clk_0.sky130_fd_sc_hs__inv_1_1.A 0.01887f
C2489 a_10955_26516# sar9b_0.FINAL 0.89766f
C2490 sar9b_0.net15 a_10055_20130# 0.43869f
C2491 a_13403_19822# sar9b_0.net5 0.02047f
C2492 a_14451_18356# single_9b_cdac_1.SW[0] 0.11567f
C2493 a_8800_26338# VDPWR 0.08237f
C2494 sar9b_0.net22 sar9b_0.net39 0.04052f
C2495 sar9b_0.net24 VDPWR 0.49173f
C2496 a_13968_23086# VDPWR 0.29239f
C2497 uio_in[0] ui_in[7] 0.03102f
C2498 single_9b_cdac_0.cdac_sw_9b_0.cdac_sw_3_4.tg_sw_3_3.SWP single_9b_cdac_0.cdac_sw_9b_0.cdac_sw_3_4.nooverlap_clk_0.CLKB0 1.71649f
C2499 a_11649_27279# uo_out[3] 0.1107f
C2500 a_13403_19988# sar9b_0.net6 0.02716f
C2501 single_9b_cdac_1.cdac_sw_9b_0.cdac_sw_3_2.nooverlap_clk_0.sky130_fd_sc_hs__inv_8_0.A single_9b_cdac_1.cdac_sw_9b_0.cdac_sw_3_2.nooverlap_clk_0.x8.A 0.04988f
C2502 single_9b_cdac_1.cdac_sw_9b_0.cdac_sw_3_7.nooverlap_clk_0.sky130_fd_sc_hs__inv_1_1.A VDPWR 0.38716f
C2503 a_13623_23252# sar9b_0.net11 0.03462f
C2504 sar9b_0._02_ sar9b_0.clknet_1_1__leaf_CLK 0.12248f
C2505 single_9b_cdac_0.cdac_sw_9b_0.cdac_sw_3_7.nooverlap_clk_0.x3.Y VDPWR 0.3196f
C2506 a_10311_24890# a_11045_24858# 0.07009f
C2507 sar9b_0.net42 a_13623_20532# 0.02716f
C2508 a_12887_19988# a_14143_19962# 0.04357f
C2509 a_13053_19988# a_13403_19988# 0.21262f
C2510 a_16159_13315# VDPWR 0.22342f
C2511 sar9b_0.net37 a_13308_19988# 0.01645f
C2512 single_9b_cdac_0.cdac_sw_9b_0.cdac_sw_3_2.nooverlap_clk_0.x10.A single_9b_cdac_1.CF[0] 0.02149f
C2513 a_13511_19266# a_13053_18900# 0.03462f
C2514 th_dif_sw_0.VCP single_9b_cdac_1.cdac_sw_9b_0.S[1] 0.10984p
C2515 ua[0] single_9b_cdac_0.SW[3] 0.16155f
C2516 VDPWR a_8435_27438# 0.19683f
C2517 single_9b_cdac_1.CF[5] th_dif_sw_0.VCN 0.09453f
C2518 VDPWR single_9b_cdac_0.cdac_sw_9b_0.cdac_sw_3_2.nooverlap_clk_0.x3.Y 0.3196f
C2519 sar9b_0.net1 a_12772_26350# 0.02702f
C2520 a_13899_23252# sar9b_0.net12 0.07147f
C2521 a_13621_19418# single_9b_cdac_1.SW[2] 0.01447f
C2522 a_9687_19042# a_9774_19266# 0.07009f
C2523 dw_12589_1395# a_10254_2858# 1.98316f
C2524 single_9b_cdac_1.cdac_sw_9b_0.cdac_sw_3_5.nooverlap_clk_0.CLK0 single_9b_cdac_1.cdac_sw_9b_0.cdac_sw_3_3.nooverlap_clk_0.CLK0 0.02632f
C2525 a_14143_25402# a_12887_25428# 0.04357f
C2526 a_13403_25428# a_13053_25428# 0.2163f
C2527 single_9b_cdac_0.cdac_sw_9b_0.cdac_sw_3_8.nooverlap_clk_0.x8.A single_9b_cdac_0.cdac_sw_9b_0.cdac_sw_3_8.nooverlap_clk_0.sky130_fd_sc_hs__inv_1_1.A 0.08121f
C2528 single_9b_cdac_0.cdac_sw_9b_0.cdac_sw_3_1.nooverlap_clk_0.CLKB0 single_9b_cdac_0.cdac_sw_9b_0.cdac_sw_3_1.tg_sw_3_3.SWP 1.71649f
C2529 single_9b_cdac_1.cdac_sw_9b_0.cdac_sw_3_5.nooverlap_clk_0.CLK0 single_9b_cdac_1.cdac_sw_9b_0.cdac_sw_3_5.nooverlap_clk_0.CLKB0 2.7611f
C2530 single_9b_cdac_1.cdac_sw_9b_0.cdac_sw_3_4.nooverlap_clk_0.CLK0 single_9b_cdac_1.SW[3] 0.24223f
C2531 single_9b_cdac_1.CF[5] single_9b_cdac_1.CF[0] 0.02907f
C2532 a_9460_24340# sar9b_0.net15 0.22849f
C2533 a_10311_23252# a_11045_23494# 0.05348f
C2534 sar9b_0.net15 a_11376_21076# 0.01936f
C2535 single_9b_cdac_0.cdac_sw_9b_0.cdac_sw_3_7.nooverlap_clk_0.CLK0 single_9b_cdac_0.cdac_sw_9b_0.cdac_sw_3_7.tg_sw_3_3.SWN 0.17533f
C2536 a_21684_3438# th_dif_sw_0.th_sw_1.CKB 0.03405f
C2537 a_7725_23028# sar9b_0._12_ 0.01083f
C2538 single_9b_cdac_1.cdac_sw_9b_0.cdac_sw_3_6.nooverlap_clk_0.x4.A single_9b_cdac_1.CF[6] 0.0313f
C2539 sar9b_0.net37 a_10211_20225# 0.02956f
C2540 sar9b_0.net39 sar9b_0.net6 0.35232f
C2541 sar9b_0.net15 a_9648_19168# 0.08095f
C2542 a_13511_26882# a_13621_26758# 0.09774f
C2543 a_13308_26516# a_13403_26516# 0.04983f
C2544 VDPWR single_9b_cdac_0.cdac_sw_9b_0.cdac_sw_3_8.tg_sw_3_3.SWP 3.27803f
C2545 th_dif_sw_0.CK a_9132_7271# 0.69795f
C2546 a_9665_22406# a_9555_22530# 0.09774f
C2547 a_10187_22138# a_10012_22164# 0.23366f
C2548 a_9447_22164# a_9352_22164# 0.04983f
C2549 single_9b_cdac_1.cdac_sw_9b_0.S[6] single_9b_cdac_1.cdac_sw_9b_0.S[0] 0.30195f
C2550 VDPWR a_8825_20532# 0.07709f
C2551 sar9b_0._13_ sar9b_0.clknet_1_1__leaf_CLK 0.15234f
C2552 single_9b_cdac_0.SW[5] single_9b_cdac_0.SW[8] 0.06063f
C2553 a_13071_20532# sar9b_0.net1 0.02191f
C2554 sar9b_0.net10 a_10012_22164# 0.04662f
C2555 single_9b_cdac_1.cdac_sw_9b_0.cdac_sw_3_0.nooverlap_clk_0.sky130_fd_sc_hs__inv_1_1.A single_9b_cdac_1.cdac_sw_9b_0.cdac_sw_3_0.nooverlap_clk_0.sky130_fd_sc_hs__nand2_1_0.Y 0.12223f
C2556 sar9b_0.net40 sar9b_0.net2 0.2561f
C2557 VDPWR a_10955_26516# 0.44019f
C2558 single_9b_cdac_0.cdac_sw_9b_0.cdac_sw_3_6.nooverlap_clk_0.x3.Y single_9b_cdac_0.cdac_sw_9b_0.cdac_sw_3_6.nooverlap_clk_0.x1.A 0.07579f
C2559 tdc_0.OUTN th_dif_sw_0.CKB 2.32117f
C2560 sar9b_0.clk_div_0.COUNT\[1\] sar9b_0.net2 0.01022f
C2561 sar9b_0.net17 a_5601_26516# 0.03944f
C2562 single_9b_cdac_0.cdac_sw_9b_0.cdac_sw_3_5.nooverlap_clk_0.x6.A single_9b_cdac_0.cdac_sw_9b_0.cdac_sw_3_5.nooverlap_clk_0.x1.A 0.03729f
C2563 a_24332_26999# single_9b_cdac_0.cdac_sw_9b_0.cdac_sw_3_8.nooverlap_clk_0.CLKB0 0.23864f
C2564 single_9b_cdac_1.SW[0] single_9b_cdac_1.cdac_sw_9b_0.cdac_sw_3_6.tg_sw_3_3.SWP 0.08409f
C2565 sar9b_0.net20 sar9b_0.net35 0.12555f
C2566 uo_out[3] uo_out[2] 3.10526f
C2567 th_dif_sw_0.VCN th_dif_sw_0.VCP 0.69759f
C2568 single_9b_cdac_1.CF[7] single_9b_cdac_1.cdac_sw_9b_0.cdac_sw_3_7.nooverlap_clk_0.sky130_fd_sc_hs__nand2_1_0.Y 0.17948f
C2569 a_5895_19988# VDPWR 0.64269f
C2570 VDPWR single_9b_cdac_1.cdac_sw_9b_0.cdac_sw_3_2.tg_sw_3_3.SWN 2.82172f
C2571 a_6337_22714# a_6525_22708# 0.09799f
C2572 sar9b_0.clknet_1_0__leaf_CLK sar9b_0.net15 0.20268f
C2573 sar9b_0.net41 a_9727_23226# 0.06534f
C2574 a_13308_21076# sar9b_0.net5 0.01035f
C2575 a_7145_23226# sar9b_0._13_ 0.11461f
C2576 single_9b_cdac_0.cdac_sw_9b_0.cdac_sw_3_2.nooverlap_clk_0.sky130_fd_sc_hs__nand2_1_0.Y single_9b_cdac_0.cdac_sw_9b_0.cdac_sw_3_2.nooverlap_clk_0.x8.A 0.26942f
C2577 single_9b_cdac_0.SW[7] sar9b_0.net33 0.01717f
C2578 sar9b_0.net27 single_9b_cdac_1.SW[5] 0.06204f
C2579 sar9b_0.net25 sar9b_0.net15 0.24521f
C2580 sar9b_0.net27 single_9b_cdac_1.SW[3] 0.04594f
C2581 a_12887_21076# sar9b_0.net5 0.02935f
C2582 single_9b_cdac_1.cdac_sw_9b_0.cdac_sw_3_6.nooverlap_clk_0.CLKB0 single_9b_cdac_1.cdac_sw_9b_0.cdac_sw_3_6.tg_sw_3_3.SWN 0.22879f
C2583 a_12887_19450# a_13308_19810# 0.09149f
C2584 a_14871_9671# th_dif_sw_0.VCP 0.07081f
C2585 sar9b_0.net2 a_10771_22164# 0.03328f
C2586 ua[0] single_9b_cdac_1.cdac_sw_9b_0.cdac_sw_3_1.tg_sw_3_3.SWN 3.10215f
C2587 single_9b_cdac_1.cdac_sw_9b_0.cdac_sw_3_3.nooverlap_clk_0.x8.A single_9b_cdac_1.cdac_sw_9b_0.cdac_sw_3_3.nooverlap_clk_0.sky130_fd_sc_hs__inv_1_1.A 0.08121f
C2588 a_10679_25428# a_11935_25402# 0.04359f
C2589 sar9b_0.clk_div_0.COUNT\[0\] sar9b_0._03_ 0.10525f
C2590 a_10845_25428# a_11195_25428# 0.21963f
C2591 ua[0] single_9b_cdac_1.CF[2] 3.58697f
C2592 sar9b_0.net41 a_9281_26516# 0.65684f
C2593 single_9b_cdac_0.cdac_sw_9b_0.cdac_sw_3_6.nooverlap_clk_0.x6.A single_9b_cdac_0.cdac_sw_9b_0.cdac_sw_3_6.nooverlap_clk_0.x4.A 0.12431f
C2594 a_5619_23252# a_6058_23618# 0.27314f
C2595 single_9b_cdac_1.SW[8] sar9b_0.net1 0.17736f
C2596 sar9b_0.net15 a_9552_23252# 0.22945f
C2597 a_10845_25428# a_11100_25428# 0.06121f
C2598 single_9b_cdac_1.cdac_sw_9b_0.cdac_sw_3_5.tg_sw_3_3.SWP single_9b_cdac_1.SW[5] 0.1717f
C2599 sar9b_0.net2 a_8431_22682# 0.03009f
C2600 sar9b_0.net37 sar9b_0.net26 0.14978f
C2601 sar9b_0.net15 a_11471_24174# 0.17031f
C2602 single_9b_cdac_1.SW[0] single_9b_cdac_1.CF[1] 0.23282f
C2603 sar9b_0._06_ VDPWR 0.47204f
C2604 single_9b_cdac_1.cdac_sw_9b_0.cdac_sw_3_1.nooverlap_clk_0.sky130_fd_sc_hs__nand2_1_0.Y single_9b_cdac_1.cdac_sw_9b_0.cdac_sw_3_1.nooverlap_clk_0.x8.A 0.26942f
C2605 sar9b_0.net13 sar9b_0.net1 0.87141f
C2606 sar9b_0._12_ sar9b_0.clknet_0_CLK 0.10011f
C2607 VDPWR a_10935_24884# 0.13326f
C2608 a_12887_24890# sar9b_0.net1 0.18533f
C2609 a_13621_19418# VDPWR 0.20427f
C2610 a_9849_21318# a_10196_21076# 0.05116f
C2611 a_9281_21076# a_9536_21076# 0.06121f
C2612 VDPWR single_9b_cdac_1.cdac_sw_9b_0.cdac_sw_3_0.nooverlap_clk_0.sky130_fd_sc_hs__inv_1_1.A 0.38733f
C2613 sar9b_0.net15 a_12575_18734# 0.15228f
C2614 single_9b_cdac_0.cdac_sw_9b_0.S[4] single_9b_cdac_0.cdac_sw_9b_0.cdac_sw_3_3.nooverlap_clk_0.CLKB0 0.36044f
C2615 a_7059_25402# sar9b_0.net3 0.29416f
C2616 single_9b_cdac_0.cdac_sw_9b_0.cdac_sw_3_4.tg_sw_3_3.SWP single_9b_cdac_1.CF[3] 0.105f
C2617 single_9b_cdac_0.cdac_sw_9b_0.cdac_sw_3_1.nooverlap_clk_0.x10.A single_9b_cdac_1.CF[1] 0.02149f
C2618 sar9b_0.net15 a_9115_21076# 0.29611f
C2619 VDPWR single_9b_cdac_0.cdac_sw_9b_0.cdac_sw_3_2.nooverlap_clk_0.CLK0 2.71729f
C2620 single_9b_cdac_1.CF[0] a_13347_21620# 0.11069f
C2621 single_9b_cdac_1.cdac_sw_9b_0.cdac_sw_3_2.tg_sw_3_3.SWP single_9b_cdac_1.CF[0] 0.10499f
C2622 single_9b_cdac_0.cdac_sw_9b_0.cdac_sw_3_6.nooverlap_clk_0.x1.A single_9b_cdac_0.cdac_sw_9b_0.cdac_sw_3_6.nooverlap_clk_0.x10.A 0.05472f
C2623 a_14175_21620# sar9b_0.net28 0.02125f
C2624 a_12887_19450# a_13053_19450# 0.88589f
C2625 a_12112_26338# sar9b_0.net43 0.17016f
C2626 sar9b_0.net15 a_8379_24340# 0.2961f
C2627 a_12887_22164# sar9b_0.net39 0.03904f
C2628 a_5895_19988# a_6249_19988# 0.02959f
C2629 single_9b_cdac_1.CF[4] a_14143_22138# 0.01288f
C2630 a_7059_25402# sar9b_0.net19 0.06218f
C2631 a_13053_25428# sar9b_0.net1 0.23085f
C2632 single_9b_cdac_1.cdac_sw_9b_0.cdac_sw_3_4.tg_sw_3_3.SWP single_9b_cdac_1.cdac_sw_9b_0.S[3] 1.55978f
C2633 a_10311_19450# sar9b_0.net15 0.4593f
C2634 ua[0] single_9b_cdac_1.cdac_sw_9b_0.S[1] 1.19426f
C2635 single_9b_cdac_1.cdac_sw_9b_0.cdac_sw_3_3.nooverlap_clk_0.CLKB0 single_9b_cdac_1.SW[4] 0.36316f
C2636 ua[0] single_9b_cdac_0.cdac_sw_9b_0.cdac_sw_3_7.nooverlap_clk_0.CLK0 0.12077f
C2637 clk a_8545_24340# 0.02796f
C2638 uo_out[0] clk 1.21145f
C2639 uo_out[6] ui_in[0] 0.06786f
C2640 a_43540_26999# single_9b_cdac_0.cdac_sw_9b_0.cdac_sw_3_3.nooverlap_clk_0.CLKB0 0.23864f
C2641 a_13419_23796# VDPWR 0.1421f
C2642 a_6691_26490# sar9b_0.net35 0.04747f
C2643 a_7055_26350# sar9b_0.net38 0.03372f
C2644 a_7795_26276# a_6539_25978# 0.04348f
C2645 sar9b_0._14_ sar9b_0.clk_div_0.COUNT\[3\] 0.10478f
C2646 a_10732_23252# VDPWR 0.08425f
C2647 single_9b_cdac_1.cdac_sw_9b_0.cdac_sw_3_7.nooverlap_clk_0.x8.A single_9b_cdac_1.cdac_sw_9b_0.cdac_sw_3_7.nooverlap_clk_0.x6.A 0.11216f
C2648 a_13968_19822# a_13968_19988# 0.01207f
C2649 sar9b_0.net38 a_7273_25946# 0.04305f
C2650 single_9b_cdac_1.cdac_sw_9b_0.cdac_sw_3_7.nooverlap_clk_0.x8.A single_9b_cdac_1.cdac_sw_9b_0.cdac_sw_3_7.nooverlap_clk_0.x1.A 0.42784f
C2651 sar9b_0.net3 sar9b_0.net38 0.47396f
C2652 a_10311_24890# VDPWR 0.46197f
C2653 ua[0] single_9b_cdac_0.cdac_sw_9b_0.cdac_sw_3_5.nooverlap_clk_0.CLK0 0.12077f
C2654 a_16159_13315# tdc_0.phase_detector_0.pd_out_0.A 0.10129f
C2655 single_9b_cdac_0.cdac_sw_9b_0.S[0] single_9b_cdac_0.cdac_sw_9b_0.S[2] 0.70317f
C2656 sar9b_0.net10 sar9b_0.net12 0.66526f
C2657 sar9b_0.net15 a_10406_19266# 0.02373f
C2658 sar9b_0.net42 single_9b_cdac_1.SW[5] 0.05716f
C2659 VDPWR a_9132_7271# 1.60705f
C2660 sar9b_0.net38 sar9b_0.net19 0.02433f
C2661 VDPWR a_8526_23770# 0.18195f
C2662 single_9b_cdac_1.CF[8] single_9b_cdac_0.cdac_sw_9b_0.cdac_sw_3_8.nooverlap_clk_0.CLK0 0.42014f
C2663 single_9b_cdac_1.CF[5] single_9b_cdac_1.CF[3] 0.0586f
C2664 sar9b_0.net42 single_9b_cdac_1.SW[3] 0.02521f
C2665 single_9b_cdac_0.SW[1] single_9b_cdac_0.cdac_sw_9b_0.cdac_sw_3_1.nooverlap_clk_0.CLKB0 0.363f
C2666 sar9b_0.net40 a_10771_22164# 0.09743f
C2667 a_12225_18362# sar9b_0.net6 0.01707f
C2668 single_9b_cdac_0.SW[2] a_54032_26990# 0.18991f
C2669 sar9b_0.net7 a_12211_18874# 0.11896f
C2670 a_10477_24890# sar9b_0.net15 0.03222f
C2671 a_10955_18900# a_12036_18900# 0.10236f
C2672 a_11689_19142# a_11471_18900# 0.20964f
C2673 a_11121_18900# a_12211_18874# 0.04242f
C2674 a_13053_26516# a_13968_26516# 0.12532f
C2675 a_11857_25978# a_12772_26350# 0.12532f
C2676 a_8545_24340# a_8895_24340# 0.2298f
C2677 sar9b_0.FINAL a_7417_27279# 0.06452f
C2678 a_11121_21076# a_12036_21076# 0.12532f
C2679 th_dif_sw_0.VCN th_dif_sw_0.th_sw_1.CKB 0.21849f
C2680 a_12887_22164# a_13308_22164# 0.0894f
C2681 sar9b_0.net15 sar9b_0.net5 0.32277f
C2682 a_14143_25188# sar9b_0.net32 0.13015f
C2683 a_10166_3438# th_dif_sw_0.th_sw_1.th_sw_main_0.VGS 1.16212f
C2684 ua[0] th_dif_sw_0.VCN 0.82867f
C2685 single_9b_cdac_1.cdac_sw_9b_0.S[7] VDPWR 4.16094f
C2686 single_9b_cdac_1.cdac_sw_9b_0.cdac_sw_3_2.nooverlap_clk_0.x1.A single_9b_cdac_1.cdac_sw_9b_0.cdac_sw_3_2.nooverlap_clk_0.sky130_fd_sc_hs__inv_1_1.A 0.10429f
C2687 single_9b_cdac_1.SW[0] single_9b_cdac_1.cdac_sw_9b_0.cdac_sw_3_8.tg_sw_3_3.SWN 0.12586f
C2688 single_9b_cdac_1.cdac_sw_9b_0.cdac_sw_3_0.nooverlap_clk_0.sky130_fd_sc_hs__inv_8_0.A single_9b_cdac_1.cdac_sw_9b_0.cdac_sw_3_0.nooverlap_clk_0.x1.A 0.45521f
C2689 single_9b_cdac_1.CF[7] single_9b_cdac_1.cdac_sw_9b_0.cdac_sw_3_7.nooverlap_clk_0.x10.A 0.02149f
C2690 a_10477_19450# sar9b_0.net4 0.35213f
C2691 clk a_8637_23252# 0.03626f
C2692 a_13403_22164# a_13511_22530# 0.05722f
C2693 sar9b_0.net39 a_13308_26516# 0.0141f
C2694 a_33936_26999# single_9b_cdac_0.cdac_sw_9b_0.cdac_sw_3_6.nooverlap_clk_0.CLKB0 0.23864f
C2695 single_9b_cdac_1.cdac_sw_9b_0.cdac_sw_3_0.nooverlap_clk_0.x1.A single_9b_cdac_1.cdac_sw_9b_0.cdac_sw_3_0.nooverlap_clk_0.x4.A 0.28523f
C2696 sar9b_0.net3 a_9739_26882# 0.01383f
C2697 VDPWR single_9b_cdac_0.cdac_sw_9b_0.cdac_sw_3_8.nooverlap_clk_0.sky130_fd_sc_hs__inv_1_1.A 0.38716f
C2698 a_11045_23494# sar9b_0.net2 0.01875f
C2699 single_9b_cdac_1.cdac_sw_9b_0.cdac_sw_3_3.nooverlap_clk_0.sky130_fd_sc_hs__nand2_1_0.Y single_9b_cdac_1.cdac_sw_9b_0.cdac_sw_3_3.nooverlap_clk_0.x1.A 0.01003f
C2700 sar9b_0._12_ sar9b_0.net2 0.01926f
C2701 single_9b_cdac_1.CF[4] sar9b_0.net29 0.13564f
C2702 ua[0] single_9b_cdac_1.CF[0] 3.29077f
C2703 a_13968_21076# VDPWR 0.28306f
C2704 a_11397_20538# sar9b_0.net7 0.68846f
C2705 a_11567_25188# a_11392_25262# 0.23366f
C2706 a_10827_25262# sar9b_0.net11 0.02994f
C2707 ua[0] single_9b_cdac_0.cdac_sw_9b_0.cdac_sw_3_4.nooverlap_clk_0.CLKB0 0.12344f
C2708 single_9b_cdac_0.SW[5] single_9b_cdac_0.cdac_sw_9b_0.cdac_sw_3_5.tg_sw_3_3.SWP 0.17355f
C2709 a_9097_22164# sar9b_0.net41 0.01229f
C2710 sar9b_0.net7 sar9b_0.net27 0.01255f
C2711 single_9b_cdac_1.CF[8] single_9b_cdac_1.SW[0] 0.22444f
C2712 single_9b_cdac_1.cdac_sw_9b_0.cdac_sw_3_7.nooverlap_clk_0.sky130_fd_sc_hs__nand2_1_0.Y VDPWR 0.62555f
C2713 sar9b_0.net4 a_10955_18900# 0.29424f
C2714 single_9b_cdac_0.cdac_sw_9b_0.cdac_sw_3_0.tg_sw_3_3.SWN single_9b_cdac_0.SW[2] 0.1507f
C2715 a_10679_25428# sar9b_0.net13 0.61913f
C2716 single_9b_cdac_1.SW[7] a_14451_20532# 0.11122f
C2717 sar9b_0.net15 sar9b_0.net38 1.18945f
C2718 a_10016_20256# a_10774_20354# 0.05562f
C2719 single_9b_cdac_1.cdac_sw_9b_0.S[8] m2_23774_17236# 0.58106f
C2720 a_7919_23802# a_8085_23802# 0.97386f
C2721 single_9b_cdac_1.cdac_sw_9b_0.cdac_sw_3_6.nooverlap_clk_0.x4.A VDPWR 0.62443f
C2722 single_9b_cdac_0.cdac_sw_9b_0.cdac_sw_3_8.tg_sw_3_3.SWP a_24332_26999# 0.04592f
C2723 sar9b_0.net15 a_11855_20532# 0.0153f
C2724 single_9b_cdac_1.cdac_sw_9b_0.cdac_sw_3_4.nooverlap_clk_0.x1.A single_9b_cdac_1.cdac_sw_9b_0.cdac_sw_3_4.nooverlap_clk_0.sky130_fd_sc_hs__nand2_1_0.Y 0.01003f
C2725 a_6343_20354# sar9b_0.clknet_1_0__leaf_CLK 0.03807f
C2726 ua[0] single_9b_cdac_1.cdac_sw_9b_0.cdac_sw_3_6.nooverlap_clk_0.CLKB0 0.1236f
C2727 a_13053_18900# a_13621_19142# 0.17456f
C2728 a_12887_18900# a_13403_18900# 0.11378f
C2729 a_12059_18362# sar9b_0.net35 0.0346f
C2730 a_11121_23802# a_11579_23796# 0.03462f
C2731 single_9b_cdac_1.cdac_sw_9b_0.cdac_sw_3_1.nooverlap_clk_0.x8.A single_9b_cdac_1.cdac_sw_9b_0.cdac_sw_3_1.nooverlap_clk_0.x1.A 0.42784f
C2732 a_11395_22530# a_10937_22164# 0.02757f
C2733 single_9b_cdac_1.cdac_sw_9b_0.cdac_sw_3_3.nooverlap_clk_0.CLKB0 VDPWR 2.81428f
C2734 a_14143_19748# sar9b_0.net26 0.06384f
C2735 a_6315_21050# sar9b_0._09_ 0.12527f
C2736 sar9b_0._07_ sar9b_0._10_ 0.05401f
C2737 a_9460_26350# VDPWR 0.29816f
C2738 a_8543_27060# a_8085_27066# 0.03462f
C2739 a_6701_20506# sar9b_0._08_ 0.01698f
C2740 single_9b_cdac_0.cdac_sw_9b_0.cdac_sw_3_0.nooverlap_clk_0.CLK0 VDPWR 2.71729f
C2741 clk sar9b_0.net2 0.05358f
C2742 sar9b_0._11_ VDPWR 0.38089f
C2743 single_9b_cdac_1.CF[4] single_9b_cdac_1.cdac_sw_9b_0.cdac_sw_3_3.nooverlap_clk_0.CLK0 0.42014f
C2744 VDPWR a_6705_25978# 0.47105f
C2745 a_5690_27192# VDPWR 0.32935f
C2746 a_6726_27060# sar9b_0.net35 0.16052f
C2747 single_9b_cdac_0.cdac_sw_9b_0.cdac_sw_3_5.nooverlap_clk_0.x8.A single_9b_cdac_0.cdac_sw_9b_0.cdac_sw_3_5.nooverlap_clk_0.x4.A 0.0303f
C2748 sar9b_0.net41 a_13347_20532# 0.03774f
C2749 a_7059_21228# sar9b_0.net3 0.12315f
C2750 single_9b_cdac_1.cdac_sw_9b_0.cdac_sw_3_5.nooverlap_clk_0.x10.A single_9b_cdac_1.cdac_sw_9b_0.cdac_sw_3_5.tg_sw_3_3.SWN 0.69086f
C2751 sar9b_0.clk_div_0.COUNT\[3\] a_8825_20532# 0.02084f
C2752 sar9b_0.net15 a_9107_22682# 0.17653f
C2753 a_13623_25972# sar9b_0.net32 0.03275f
C2754 a_5803_25428# a_6224_25428# 0.08341f
C2755 sar9b_0.net15 a_14051_24100# 0.27822f
C2756 single_9b_cdac_1.SW[0] single_9b_cdac_1.CF[6] 0.22459f
C2757 a_8910_20532# sar9b_0.net4 0.01924f
C2758 sar9b_0.net41 a_9536_26516# 0.17086f
C2759 uio_out[1] a_5435_26516# 0.0327f
C2760 VDPWR a_7417_27279# 0.25881f
C2761 single_9b_cdac_0.cdac_sw_9b_0.cdac_sw_3_1.nooverlap_clk_0.CLK0 single_9b_cdac_0.cdac_sw_9b_0.cdac_sw_3_2.nooverlap_clk_0.CLK0 0.02632f
C2762 a_5856_26516# a_5601_26516# 0.06121f
C2763 single_9b_cdac_0.SW[7] single_9b_cdac_0.cdac_sw_9b_0.cdac_sw_3_7.nooverlap_clk_0.CLKB0 0.36542f
C2764 sar9b_0.net13 a_11857_25978# 0.01981f
C2765 a_9536_21076# sar9b_0.net8 0.17009f
C2766 dw_17224_1400# th_dif_sw_0.th_sw_0.th_sw_main_0.VGS 1.26208f
C2767 ua[0] single_9b_cdac_0.cdac_sw_9b_0.S[6] 1.7014f
C2768 single_9b_cdac_0.cdac_sw_9b_0.cdac_sw_3_1.tg_sw_3_3.SWP single_9b_cdac_1.CF[2] 0.19321f
C2769 th_dif_sw_0.th_sw_1.th_sw_main_0.VGS a_10254_2858# 1.3306f
C2770 single_9b_cdac_1.cdac_sw_9b_0.cdac_sw_3_5.nooverlap_clk_0.x4.A single_9b_cdac_1.cdac_sw_9b_0.cdac_sw_3_5.nooverlap_clk_0.x3.Y 0.07517f
C2771 single_9b_cdac_0.cdac_sw_9b_0.cdac_sw_3_7.tg_sw_3_3.SWP single_9b_cdac_0.cdac_sw_9b_0.cdac_sw_3_8.tg_sw_3_3.SWP 0.02666f
C2772 a_9252_22708# a_9038_22708# 0.09774f
C2773 VDPWR a_9555_22530# 0.14228f
C2774 tdc_0.OUTN a_16555_12412# 0.01287f
C2775 single_9b_cdac_1.cdac_sw_9b_0.cdac_sw_3_7.nooverlap_clk_0.x1.A single_9b_cdac_1.cdac_sw_9b_0.cdac_sw_3_7.nooverlap_clk_0.x3.Y 0.07579f
C2776 a_11747_20910# a_11855_20532# 0.05722f
C2777 sar9b_0.net37 single_9b_cdac_1.SW[4] 0.07237f
C2778 single_9b_cdac_0.SW[0] a_14051_24100# 0.02233f
C2779 single_9b_cdac_0.cdac_sw_9b_0.cdac_sw_3_7.nooverlap_clk_0.sky130_fd_sc_hs__nand2_1_0.Y a_31753_29911# 0.01076f
C2780 a_12937_27279# sar9b_0.net24 0.22899f
C2781 single_9b_cdac_1.cdac_sw_9b_0.cdac_sw_3_2.nooverlap_clk_0.CLKB0 single_9b_cdac_1.CF[0] 0.26707f
C2782 sar9b_0.net37 single_9b_cdac_1.SW[2] 0.05592f
C2783 single_9b_cdac_0.cdac_sw_9b_0.cdac_sw_3_4.nooverlap_clk_0.x10.A single_9b_cdac_1.CF[3] 0.02149f
C2784 a_14143_23012# a_13968_23086# 0.23366f
C2785 sar9b_0._12_ sar9b_0.clk_div_0.COUNT\[1\] 0.84342f
C2786 sar9b_0.net7 sar9b_0.net42 0.06755f
C2787 single_9b_cdac_1.CF[7] single_9b_cdac_1.SW[0] 0.22459f
C2788 sar9b_0.net12 sar9b_0.net43 0.02631f
C2789 a_8471_23252# a_9727_23226# 0.04357f
C2790 a_8637_23252# a_8987_23252# 0.2298f
C2791 sar9b_0.net37 sar9b_0.FINAL 0.14232f
C2792 VDPWR a_11287_22164# 0.20139f
C2793 sar9b_0._06_ sar9b_0.clk_div_0.COUNT\[3\] 0.36179f
C2794 single_9b_cdac_1.cdac_sw_9b_0.cdac_sw_3_3.nooverlap_clk_0.CLKB0 single_9b_cdac_1.cdac_sw_9b_0.cdac_sw_3_4.nooverlap_clk_0.CLKB0 0.02618f
C2795 a_9536_21076# VDPWR 0.08243f
C2796 a_9370_19152# a_9687_19042# 0.10236f
C2797 sar9b_0.net27 sar9b_0.net9 0.02232f
C2798 sar9b_0.net40 sar9b_0.net39 0.58727f
C2799 a_14143_25402# sar9b_0.net33 0.09799f
C2800 a_10827_25262# sar9b_0.net42 0.01453f
C2801 sar9b_0.net40 clk 0.01949f
C2802 clk sar9b_0.clk_div_0.COUNT\[1\] 0.02973f
C2803 a_13379_27398# sar9b_0.net25 0.05157f
C2804 single_9b_cdac_0.SW[5] sar9b_0.net15 0.0487f
C2805 single_9b_cdac_1.cdac_sw_9b_0.cdac_sw_3_6.nooverlap_clk_0.x3.Y single_9b_cdac_1.CF[6] 0.12898f
C2806 single_9b_cdac_0.SW[1] single_9b_cdac_0.SW[3] 0.02023f
C2807 a_5863_19662# a_6417_19822# 0.06222f
C2808 a_13621_21318# a_13968_21076# 0.05116f
C2809 sar9b_0.clknet_1_1__leaf_CLK sar9b_0.clknet_0_CLK 0.18014f
C2810 a_12887_19988# a_13347_20532# 0.01023f
C2811 single_9b_cdac_0.cdac_sw_9b_0.cdac_sw_3_2.nooverlap_clk_0.x4.A single_9b_cdac_0.cdac_sw_9b_0.cdac_sw_3_2.nooverlap_clk_0.x3.Y 0.07517f
C2812 single_9b_cdac_1.SW[1] single_9b_cdac_1.cdac_sw_9b_0.cdac_sw_3_1.tg_sw_3_3.SWP 0.17209f
C2813 ua[0] single_9b_cdac_1.cdac_sw_9b_0.cdac_sw_3_8.nooverlap_clk_0.CLKB0 0.15943f
C2814 single_9b_cdac_1.cdac_sw_9b_0.cdac_sw_3_8.nooverlap_clk_0.x10.A single_9b_cdac_1.cdac_sw_9b_0.cdac_sw_3_8.nooverlap_clk_0.x1.A 0.05472f
C2815 a_8653_27034# a_8435_27438# 0.20964f
C2816 a_8085_27066# a_9175_27364# 0.04229f
C2817 single_9b_cdac_1.cdac_sw_9b_0.cdac_sw_3_6.tg_sw_3_3.SWP single_9b_cdac_1.cdac_sw_9b_0.cdac_sw_3_6.tg_sw_3_3.SWN 3.10626f
C2818 a_13621_24858# sar9b_0.net15 0.17802f
C2819 single_9b_cdac_1.cdac_sw_9b_0.S[2] single_9b_cdac_1.cdac_sw_9b_0.S[5] 0.24472f
C2820 sar9b_0.clknet_0_CLK a_7345_21594# 1.67454f
C2821 a_11965_20506# sar9b_0.net8 0.02194f
C2822 single_9b_cdac_1.CF[5] single_9b_cdac_1.CF[1] 0.04205f
C2823 a_11567_19748# sar9b_0.net15 0.29166f
C2824 sar9b_0.net37 sar9b_0.net8 0.13831f
C2825 single_9b_cdac_0.cdac_sw_9b_0.cdac_sw_3_6.nooverlap_clk_0.sky130_fd_sc_hs__inv_1_1.A single_9b_cdac_0.cdac_sw_9b_0.cdac_sw_3_6.nooverlap_clk_0.sky130_fd_sc_hs__nand2_1_0.Y 0.12223f
C2826 sar9b_0.net4 sar9b_0.net8 0.45003f
C2827 ua[0] single_9b_cdac_1.CF[3] 3.58922f
C2828 VDPWR a_12036_18900# 0.31862f
C2829 single_9b_cdac_1.CF[8] single_9b_cdac_0.SW[7] 0.21593f
C2830 VDPWR a_9252_22708# 0.1421f
C2831 sar9b_0.net2 a_8987_23252# 0.03644f
C2832 a_8471_20538# sar9b_0.clknet_0_CLK 0.01343f
C2833 sar9b_0.net2 a_11121_23802# 0.31049f
C2834 a_10955_23802# a_11689_23770# 0.07009f
C2835 ua[2] ua[3] 0.06385f
C2836 single_9b_cdac_1.cdac_sw_9b_0.cdac_sw_3_7.nooverlap_clk_0.x10.A VDPWR 0.95338f
C2837 single_9b_cdac_1.SW[0] single_9b_cdac_1.SW[4] 0.022f
C2838 dw_12589_1395# th_dif_sw_0.th_sw_1.th_sw_main_0.VGS 1.26214f
C2839 single_9b_cdac_1.cdac_sw_9b_0.S[3] single_9b_cdac_1.cdac_sw_9b_0.S[1] 0.3195f
C2840 single_9b_cdac_0.cdac_sw_9b_0.cdac_sw_3_6.nooverlap_clk_0.x8.A single_9b_cdac_0.cdac_sw_9b_0.cdac_sw_3_6.nooverlap_clk_0.x10.A 0.42509f
C2841 single_9b_cdac_1.SW[0] single_9b_cdac_1.SW[2] 0.05963f
C2842 single_9b_cdac_1.cdac_sw_9b_0.S[4] single_9b_cdac_1.cdac_sw_9b_0.S[1] 0.31852f
C2843 sar9b_0.net15 a_13511_20354# 0.01224f
C2844 a_6007_27302# sar9b_0.FINAL 0.30096f
C2845 single_9b_cdac_1.cdac_sw_9b_0.S[6] single_9b_cdac_1.cdac_sw_9b_0.S[7] 14.3479f
C2846 single_9b_cdac_1.cdac_sw_9b_0.cdac_sw_3_5.nooverlap_clk_0.sky130_fd_sc_hs__inv_8_0.A single_9b_cdac_1.cdac_sw_9b_0.cdac_sw_3_5.nooverlap_clk_0.x8.A 0.04988f
C2847 a_12795_23802# sar9b_0.net39 0.02519f
C2848 single_9b_cdac_0.cdac_sw_9b_0.cdac_sw_3_2.nooverlap_clk_0.x1.A single_9b_cdac_0.cdac_sw_9b_0.cdac_sw_3_2.nooverlap_clk_0.sky130_fd_sc_hs__inv_8_0.A 0.45521f
C2849 single_9b_cdac_1.SW[8] sar9b_0.net6 0.0344f
C2850 a_10211_20225# sar9b_0.net41 0.04124f
C2851 single_9b_cdac_1.CF[6] single_9b_cdac_0.cdac_sw_9b_0.cdac_sw_3_6.nooverlap_clk_0.sky130_fd_sc_hs__nand2_1_0.Y 0.17948f
C2852 sar9b_0._04_ sar9b_0.clk_div_0.COUNT\[0\] 0.03315f
C2853 sar9b_0.net35 a_8634_22840# 0.01662f
C2854 a_12225_18362# sar9b_0.net2 0.73834f
C2855 a_6337_22714# a_6778_22682# 0.11897f
C2856 a_13623_23252# sar9b_0.net15 0.02282f
C2857 sar9b_0.net3 a_5435_26516# 0.29652f
C2858 VDPWR single_9b_cdac_0.cdac_sw_9b_0.S[8] 4.1658f
C2859 VDPWR a_14143_18874# 0.35633f
C2860 single_9b_cdac_0.cdac_sw_9b_0.cdac_sw_3_0.nooverlap_clk_0.x1.A single_9b_cdac_0.cdac_sw_9b_0.cdac_sw_3_0.nooverlap_clk_0.sky130_fd_sc_hs__nand2_1_0.Y 0.01003f
C2861 single_9b_cdac_0.cdac_sw_9b_0.cdac_sw_3_0.nooverlap_clk_0.CLK0 single_9b_cdac_0.cdac_sw_9b_0.cdac_sw_3_1.nooverlap_clk_0.CLK0 0.02778f
C2862 a_10254_2858# w_12795_1601# 0.14391f
C2863 single_9b_cdac_0.SW[2] sar9b_0.net29 0.05526f
C2864 a_9113_25946# a_9460_26350# 0.05116f
C2865 sar9b_0.net1 sar9b_0.net5 0.31668f
C2866 a_9021_19418# VDPWR 0.2113f
C2867 VDPWR sar9b_0._08_ 0.90309f
C2868 a_11121_26516# a_11579_26882# 0.02761f
C2869 a_11965_20506# VDPWR 0.21393f
C2870 single_9b_cdac_0.cdac_sw_9b_0.cdac_sw_3_3.nooverlap_clk_0.x8.A VDPWR 0.84059f
C2871 sar9b_0.net37 VDPWR 7.31357f
C2872 a_8545_25978# sar9b_0.net3 0.02223f
C2873 sar9b_0.net15 a_10142_20354# 0.16798f
C2874 sar9b_0.net4 VDPWR 5.50657f
C2875 a_13899_21620# single_9b_cdac_1.CF[2] 0.11036f
C2876 a_12961_23802# a_13216_24162# 0.06044f
C2877 single_9b_cdac_0.cdac_sw_9b_0.cdac_sw_3_8.nooverlap_clk_0.x4.A single_9b_cdac_0.cdac_sw_9b_0.cdac_sw_3_8.nooverlap_clk_0.x1.A 0.28523f
C2878 VDPWR single_9b_cdac_0.cdac_sw_9b_0.cdac_sw_3_8.nooverlap_clk_0.CLK0 2.71729f
C2879 sar9b_0.net26 single_9b_cdac_1.CF[5] 0.04287f
C2880 sar9b_0.net42 sar9b_0.net9 0.02098f
C2881 sar9b_0._13_ a_6679_22316# 0.04124f
C2882 single_9b_cdac_1.cdac_sw_9b_0.cdac_sw_3_2.nooverlap_clk_0.sky130_fd_sc_hs__inv_8_0.A single_9b_cdac_1.cdac_sw_9b_0.cdac_sw_3_2.nooverlap_clk_0.x1.A 0.45521f
C2883 single_9b_cdac_0.SW[1] single_9b_cdac_1.CF[2] 0.03797f
C2884 single_9b_cdac_0.cdac_sw_9b_0.cdac_sw_3_6.tg_sw_3_3.SWN single_9b_cdac_0.cdac_sw_9b_0.cdac_sw_3_7.tg_sw_3_3.SWN 0.02638f
C2885 VDPWR single_9b_cdac_0.cdac_sw_9b_0.cdac_sw_3_0.nooverlap_clk_0.sky130_fd_sc_hs__nand2_1_0.Y 0.62573f
C2886 single_9b_cdac_0.cdac_sw_9b_0.cdac_sw_3_0.nooverlap_clk_0.sky130_fd_sc_hs__inv_8_0.A single_9b_cdac_0.cdac_sw_9b_0.cdac_sw_3_0.nooverlap_clk_0.x8.A 0.04988f
C2887 a_10311_24890# a_11567_25188# 0.04357f
C2888 sar9b_0.net42 a_14175_20532# 0.07554f
C2889 sar9b_0.net38 sar9b_0.net1 0.47212f
C2890 tdc_0.phase_detector_0.pd_out_0.B VDPWR 1.26944f
C2891 a_12887_19988# a_13308_19988# 0.09016f
C2892 a_13053_19988# a_13968_19988# 0.11876f
C2893 a_13968_25428# a_13968_25262# 0.01207f
C2894 single_9b_cdac_1.cdac_sw_9b_0.S[2] single_9b_cdac_1.cdac_sw_9b_0.S[0] 0.70317f
C2895 single_9b_cdac_1.cdac_sw_9b_0.cdac_sw_3_3.nooverlap_clk_0.sky130_fd_sc_hs__nand2_1_0.Y VDPWR 0.62553f
C2896 a_13511_19266# a_13403_18900# 0.05722f
C2897 single_9b_cdac_0.cdac_sw_9b_0.cdac_sw_3_5.nooverlap_clk_0.CLKB0 single_9b_cdac_0.cdac_sw_9b_0.cdac_sw_3_5.tg_sw_3_3.SWP 1.71649f
C2898 VDPWR a_9000_27438# 0.29083f
C2899 single_9b_cdac_0.cdac_sw_9b_0.S[0] th_dif_sw_0.VCN 0.21769p
C2900 sar9b_0.net11 a_7919_23802# 0.03915f
C2901 single_9b_cdac_1.CF[7] single_9b_cdac_0.SW[7] 1.81115f
C2902 single_9b_cdac_0.cdac_sw_9b_0.cdac_sw_3_0.tg_sw_3_3.SWN single_9b_cdac_0.cdac_sw_9b_0.cdac_sw_3_0.nooverlap_clk_0.CLKB0 0.22875f
C2903 uo_out[5] sar9b_0.net39 0.02643f
C2904 a_14143_19748# single_9b_cdac_1.SW[2] 0.02201f
C2905 sar9b_0.net15 single_9b_cdac_1.SW[5] 0.09529f
C2906 single_9b_cdac_1.cdac_sw_9b_0.cdac_sw_3_2.nooverlap_clk_0.x10.A single_9b_cdac_1.cdac_sw_9b_0.cdac_sw_3_2.tg_sw_3_3.SWN 0.69086f
C2907 uo_out[5] clk 0.21693f
C2908 sar9b_0.net15 single_9b_cdac_1.SW[3] 0.10927f
C2909 a_11689_21318# a_10955_21076# 0.07009f
C2910 sar9b_0.net25 a_13053_26516# 0.03766f
C2911 sar9b_0.FINAL a_12887_26516# 0.02462f
C2912 single_9b_cdac_1.cdac_sw_9b_0.cdac_sw_3_0.nooverlap_clk_0.CLKB0 single_9b_cdac_1.cdac_sw_9b_0.cdac_sw_3_0.nooverlap_clk_0.sky130_fd_sc_hs__inv_8_0.A 0.6919f
C2913 single_9b_cdac_1.cdac_sw_9b_0.cdac_sw_3_2.tg_sw_3_3.SWP single_9b_cdac_1.CF[1] 0.19147f
C2914 a_13968_25428# a_13053_25428# 0.11876f
C2915 a_13308_25428# a_12887_25428# 0.08264f
C2916 VDPWR a_6007_27302# 0.42798f
C2917 sar9b_0.net8 a_13053_22164# 0.01754f
C2918 a_5793_21326# sar9b_0._10_ 0.01662f
C2919 a_6679_22316# sar9b_0._09_ 0.08858f
C2920 a_10477_23252# a_10827_23252# 0.21877f
C2921 a_10311_23252# a_11567_23226# 0.04348f
C2922 single_9b_cdac_1.SW[0] VDPWR 2.52741f
C2923 single_9b_cdac_1.cdac_sw_9b_0.cdac_sw_3_5.nooverlap_clk_0.x4.A single_9b_cdac_1.CF[5] 0.0313f
C2924 dw_12589_1395# w_12795_1601# 9.86148f
C2925 th_dif_sw_0.CK th_dif_sw_0.th_sw_1.CK 0.01565f
C2926 single_9b_cdac_1.cdac_sw_9b_0.cdac_sw_3_4.nooverlap_clk_0.x10.A single_9b_cdac_1.cdac_sw_9b_0.cdac_sw_3_4.tg_sw_3_3.SWN 0.69086f
C2927 a_7363_23502# sar9b_0.clk_div_0.COUNT\[0\] 0.08493f
C2928 a_13403_25428# a_13499_25428# 0.01379f
C2929 single_9b_cdac_1.CF[8] single_9b_cdac_1.CF[5] 0.016f
C2930 single_9b_cdac_0.cdac_sw_9b_0.cdac_sw_3_7.nooverlap_clk_0.CLKB0 single_9b_cdac_0.cdac_sw_9b_0.cdac_sw_3_7.tg_sw_3_3.SWN 0.22875f
C2931 a_9843_19137# a_10153_18900# 0.01379f
C2932 sar9b_0.net22 sar9b_0.net23 0.23982f
C2933 sar9b_0._07_ sar9b_0.net3 0.42319f
C2934 sar9b_0.net7 a_12887_21076# 0.2525f
C2935 single_9b_cdac_0.cdac_sw_9b_0.cdac_sw_3_2.nooverlap_clk_0.CLKB0 single_9b_cdac_0.cdac_sw_9b_0.cdac_sw_3_2.nooverlap_clk_0.sky130_fd_sc_hs__inv_8_0.A 0.6919f
C2936 single_9b_cdac_1.cdac_sw_9b_0.cdac_sw_3_0.tg_sw_3_3.SWP single_9b_cdac_1.cdac_sw_9b_0.cdac_sw_3_0.nooverlap_clk_0.CLKB0 1.71649f
C2937 single_9b_cdac_0.cdac_sw_9b_0.cdac_sw_3_1.nooverlap_clk_0.x10.A VDPWR 0.95338f
C2938 single_9b_cdac_0.SW[5] single_9b_cdac_0.cdac_sw_9b_0.cdac_sw_3_6.tg_sw_3_3.SWP 0.02506f
C2939 single_9b_cdac_0.cdac_sw_9b_0.cdac_sw_3_1.nooverlap_clk_0.x8.A single_9b_cdac_0.cdac_sw_9b_0.cdac_sw_3_1.nooverlap_clk_0.sky130_fd_sc_hs__nand2_1_0.Y 0.26942f
C2940 a_14175_25972# VDPWR 0.19322f
C2941 single_9b_cdac_0.SW[5] sar9b_0.net30 0.07344f
C2942 a_6502_20124# VDPWR 0.17654f
C2943 single_9b_cdac_1.cdac_sw_9b_0.cdac_sw_3_0.nooverlap_clk_0.x10.A single_9b_cdac_1.CF[2] 0.02149f
C2944 a_13053_22714# sar9b_0.net39 0.03629f
C2945 ua[0] single_9b_cdac_1.cdac_sw_9b_0.cdac_sw_3_6.tg_sw_3_3.SWP 1.15121f
C2946 VDPWR a_13053_22164# 0.57186f
C2947 a_8453_19450# a_8911_19444# 0.02737f
C2948 a_5895_19988# sar9b_0._00_ 0.03444f
C2949 a_8931_22164# sar9b_0.net2 0.15831f
C2950 single_9b_cdac_0.cdac_sw_9b_0.cdac_sw_3_1.nooverlap_clk_0.CLK0 a_58824_26990# 0.14695f
C2951 single_9b_cdac_1.CF[4] clk 0.08196f
C2952 uio_in[5] uio_in[4] 0.03102f
C2953 sar9b_0.net10 a_11287_22164# 0.03585f
C2954 sar9b_0.net28 a_13876_24174# 0.01766f
C2955 single_9b_cdac_1.CF[6] single_9b_cdac_1.CF[5] 8.06063f
C2956 tdc_0.RDY tdc_0.OUTN 0.06064f
C2957 single_9b_cdac_0.cdac_sw_9b_0.S[0] single_9b_cdac_0.cdac_sw_9b_0.S[6] 0.30195f
C2958 single_9b_cdac_1.cdac_sw_9b_0.cdac_sw_3_3.nooverlap_clk_0.x1.A single_9b_cdac_1.cdac_sw_9b_0.cdac_sw_3_3.nooverlap_clk_0.sky130_fd_sc_hs__inv_1_1.A 0.10429f
C2959 sar9b_0.net15 a_9447_22164# 0.15481f
C2960 a_10845_25428# a_11760_25428# 0.12532f
C2961 single_9b_cdac_1.cdac_sw_9b_0.cdac_sw_3_4.nooverlap_clk_0.x8.A single_9b_cdac_1.cdac_sw_9b_0.cdac_sw_3_4.nooverlap_clk_0.x6.A 0.11216f
C2962 clk sar9b_0.net39 0.02478f
C2963 sar9b_0.net15 a_9095_23618# 0.0122f
C2964 a_11413_25670# a_11303_25794# 0.09774f
C2965 a_11195_25428# a_11100_25428# 0.04983f
C2966 a_6651_23520# sar9b_0.clknet_1_1__leaf_CLK 0.09962f
C2967 single_9b_cdac_1.cdac_sw_9b_0.cdac_sw_3_4.nooverlap_clk_0.x8.A single_9b_cdac_1.cdac_sw_9b_0.cdac_sw_3_4.nooverlap_clk_0.x1.A 0.42784f
C2968 sar9b_0.net37 sar9b_0.net36 0.14048f
C2969 single_9b_cdac_0.SW[1] th_dif_sw_0.VCN 0.09453f
C2970 sar9b_0.net15 a_12036_24174# 0.22949f
C2971 a_9281_26516# a_9849_26758# 0.17523f
C2972 sar9b_0.net4 sar9b_0.net36 0.02917f
C2973 ua[0] single_9b_cdac_0.cdac_sw_9b_0.cdac_sw_3_6.tg_sw_3_3.SWN 3.10218f
C2974 single_9b_cdac_1.cdac_sw_9b_0.cdac_sw_3_5.tg_sw_3_3.SWP single_9b_cdac_1.cdac_sw_9b_0.S[5] 1.56012f
C2975 uo_out[0] ui_in[0] 0.0743f
C2976 single_9b_cdac_0.cdac_sw_9b_0.S[3] single_9b_cdac_0.cdac_sw_9b_0.S[8] 0.31498f
C2977 single_9b_cdac_1.cdac_sw_9b_0.cdac_sw_3_5.nooverlap_clk_0.x3.Y VDPWR 0.3196f
C2978 VDPWR a_12887_26516# 0.48354f
C2979 sar9b_0.clk_div_0.COUNT\[1\] sar9b_0.clknet_1_1__leaf_CLK 0.05311f
C2980 dw_17224_1400# a_21684_3438# 0.05509f
C2981 single_9b_cdac_1.cdac_sw_9b_0.cdac_sw_3_1.nooverlap_clk_0.sky130_fd_sc_hs__nand2_1_0.Y single_9b_cdac_1.cdac_sw_9b_0.cdac_sw_3_1.nooverlap_clk_0.x1.A 0.01003f
C2982 single_9b_cdac_1.cdac_sw_9b_0.cdac_sw_3_6.nooverlap_clk_0.x3.Y VDPWR 0.3196f
C2983 ua[0] single_9b_cdac_1.CF[1] 3.57763f
C2984 th_dif_sw_0.th_sw_0.th_sw_main_0.VGS a_21684_3438# 1.63339f
C2985 a_9281_21076# sar9b_0.net41 0.03671f
C2986 th_dif_sw_0.CKB a_21368_4076# 0.01195f
C2987 a_14143_19748# VDPWR 0.3632f
C2988 single_9b_cdac_1.cdac_sw_9b_0.cdac_sw_3_4.nooverlap_clk_0.CLKB0 single_9b_cdac_1.SW[0] 0.05632f
C2989 a_10371_21050# a_10196_21076# 0.23366f
C2990 a_9631_21076# a_9536_21076# 0.04983f
C2991 a_9849_21318# a_9739_21442# 0.09774f
C2992 single_9b_cdac_1.CF[2] a_13968_22164# 0.01311f
C2993 single_9b_cdac_1.cdac_sw_9b_0.cdac_sw_3_8.nooverlap_clk_0.sky130_fd_sc_hs__inv_1_1.A single_9b_cdac_1.cdac_sw_9b_0.cdac_sw_3_8.nooverlap_clk_0.sky130_fd_sc_hs__nand2_1_0.Y 0.12223f
C2994 sar9b_0.net15 a_13140_18734# 0.2243f
C2995 single_9b_cdac_1.cdac_sw_9b_0.cdac_sw_3_6.tg_sw_3_3.SWN single_9b_cdac_1.CF[6] 0.12358f
C2996 a_6651_23520# a_7145_23226# 0.01733f
C2997 a_13403_25262# a_13499_25262# 0.01379f
C2998 a_10955_21076# sar9b_0.net2 0.19166f
C2999 single_9b_cdac_1.CF[8] single_9b_cdac_0.cdac_sw_9b_0.cdac_sw_3_7.tg_sw_3_3.SWN 0.03488f
C3000 sar9b_0._07_ sar9b_0.net15 0.4007f
C3001 single_9b_cdac_1.CF[7] single_9b_cdac_0.cdac_sw_9b_0.cdac_sw_3_7.nooverlap_clk_0.sky130_fd_sc_hs__inv_1_1.A 0.01887f
C3002 sar9b_0.net15 a_9849_21318# 0.16659f
C3003 a_49221_26990# single_9b_cdac_0.SW[3] 0.18991f
C3004 a_7163_25972# a_6705_25978# 0.03462f
C3005 single_9b_cdac_1.CF[7] single_9b_cdac_1.CF[5] 0.02324f
C3006 a_6171_22714# sar9b_0.clknet_1_1__leaf_CLK 0.27771f
C3007 single_9b_cdac_0.cdac_sw_9b_0.cdac_sw_3_1.nooverlap_clk_0.x1.A single_9b_cdac_0.cdac_sw_9b_0.cdac_sw_3_1.nooverlap_clk_0.x3.Y 0.07579f
C3008 single_9b_cdac_1.SW[8] sar9b_0.net28 0.03222f
C3009 uo_out[4] sar9b_0.net3 0.06887f
C3010 a_13053_19450# a_13621_19418# 0.18639f
C3011 a_12887_19450# a_13403_19822# 0.11535f
C3012 single_9b_cdac_0.cdac_sw_9b_0.S[1] VDPWR 4.15038f
C3013 a_9535_19962# a_10016_20256# 0.04242f
C3014 single_9b_cdac_0.cdac_sw_9b_0.S[5] single_9b_cdac_0.cdac_sw_9b_0.S[8] 0.93291f
C3015 a_11045_19418# sar9b_0.net15 0.16364f
C3016 a_12211_21050# sar9b_0.net39 0.06106f
C3017 clk a_8895_24340# 0.01816f
C3018 sar9b_0.net28 sar9b_0.net13 0.02894f
C3019 a_5619_23252# VDPWR 0.75231f
C3020 a_7325_26681# sar9b_0.net35 0.02921f
C3021 a_7620_26350# sar9b_0.net38 0.05897f
C3022 single_9b_cdac_0.cdac_sw_9b_0.cdac_sw_3_3.nooverlap_clk_0.x8.A single_9b_cdac_0.cdac_sw_9b_0.cdac_sw_3_3.nooverlap_clk_0.x10.A 0.42509f
C3023 single_9b_cdac_1.cdac_sw_9b_0.cdac_sw_3_7.nooverlap_clk_0.x1.A single_9b_cdac_1.cdac_sw_9b_0.cdac_sw_3_7.nooverlap_clk_0.x6.A 0.03729f
C3024 single_9b_cdac_0.cdac_sw_9b_0.S[8] a_24332_26999# 0.59531f
C3025 a_14451_25972# a_14143_26490# 0.01246f
C3026 sar9b_0.net39 a_13308_22164# 0.01024f
C3027 single_9b_cdac_0.cdac_sw_9b_0.cdac_sw_3_8.nooverlap_clk_0.x6.A single_9b_cdac_0.cdac_sw_9b_0.cdac_sw_3_8.nooverlap_clk_0.x1.A 0.03729f
C3028 VDPWR single_9b_cdac_0.cdac_sw_9b_0.cdac_sw_3_6.nooverlap_clk_0.sky130_fd_sc_hs__nand2_1_0.Y 0.62555f
C3029 ua[0] single_9b_cdac_0.cdac_sw_9b_0.cdac_sw_3_7.nooverlap_clk_0.CLKB0 0.1236f
C3030 uio_out[0] a_6007_27302# 0.03228f
C3031 a_62748_26999# VDPWR 1.81495f
C3032 sar9b_0.net29 sar9b_0.net13 0.03566f
C3033 tdc_0.phase_detector_0.pd_out_0.B tdc_0.phase_detector_0.pd_out_0.A 2.29405f
C3034 single_9b_cdac_1.cdac_sw_9b_0.cdac_sw_3_1.tg_sw_3_3.SWP single_9b_cdac_1.cdac_sw_9b_0.cdac_sw_3_1.nooverlap_clk_0.CLKB0 1.71649f
C3035 sar9b_0.net4 a_10187_22138# 0.02732f
C3036 sar9b_0.net7 sar9b_0.net15 0.47498f
C3037 sar9b_0.net15 a_11121_18900# 0.05872f
C3038 single_9b_cdac_1.cdac_sw_9b_0.cdac_sw_3_6.nooverlap_clk_0.sky130_fd_sc_hs__nand2_1_0.Y single_9b_cdac_1.cdac_sw_9b_0.cdac_sw_3_6.nooverlap_clk_0.x8.A 0.26942f
C3039 single_9b_cdac_1.SW[0] sar9b_0.net36 0.10704f
C3040 single_9b_cdac_1.CF[7] single_9b_cdac_1.cdac_sw_9b_0.cdac_sw_3_6.tg_sw_3_3.SWN 0.03484f
C3041 sar9b_0.net4 sar9b_0.net10 0.09333f
C3042 sar9b_0.net3 a_8085_27066# 0.05838f
C3043 VDPWR th_dif_sw_0.th_sw_1.CK 2.01535f
C3044 a_7795_26276# sar9b_0.FINAL 0.02877f
C3045 VDPWR a_8951_23770# 0.40816f
C3046 sar9b_0.net2 sar9b_0.net13 0.08351f
C3047 single_9b_cdac_0.SW[7] VDPWR 2.18374f
C3048 clk a_16357_9613# 0.01204f
C3049 ua[2] ua[1] 2.07911f
C3050 a_13621_22682# single_9b_cdac_1.CF[5] 0.01299f
C3051 sar9b_0.clk_div_0.COUNT\[2\] a_7035_22708# 0.03413f
C3052 a_6691_26490# a_7325_26681# 0.01774f
C3053 a_13053_21076# sar9b_0.net8 0.02915f
C3054 a_10827_25262# sar9b_0.net15 0.15446f
C3055 a_11689_19142# a_12036_18900# 0.05116f
C3056 single_9b_cdac_1.cdac_sw_9b_0.cdac_sw_3_0.nooverlap_clk_0.CLK0 single_9b_cdac_1.SW[2] 0.24301f
C3057 a_5435_26516# a_5601_26516# 0.66041f
C3058 single_9b_cdac_1.CF[5] single_9b_cdac_1.SW[4] 0.01482f
C3059 a_8545_24340# a_9460_24340# 0.12532f
C3060 single_9b_cdac_0.cdac_sw_9b_0.cdac_sw_3_3.nooverlap_clk_0.x1.A VDPWR 0.75849f
C3061 single_9b_cdac_1.CF[5] single_9b_cdac_1.SW[2] 0.01297f
C3062 single_9b_cdac_1.cdac_sw_9b_0.cdac_sw_3_8.tg_sw_3_3.SWP a_24332_16877# 0.04592f
C3063 a_11121_21076# a_11579_21442# 0.03462f
C3064 sar9b_0.net15 a_12887_18900# 0.59763f
C3065 clk th_dif_sw_0.CKB 0.11297f
C3066 sar9b_0.net4 sar9b_0.clk_div_0.COUNT\[3\] 0.02483f
C3067 single_9b_cdac_0.cdac_sw_9b_0.cdac_sw_3_0.nooverlap_clk_0.x8.A single_9b_cdac_0.cdac_sw_9b_0.cdac_sw_3_0.nooverlap_clk_0.x1.A 0.42784f
C3068 a_14175_27060# VDPWR 0.20686f
C3069 a_6483_23618# a_5785_23252# 0.19489f
C3070 single_9b_cdac_1.cdac_sw_9b_0.cdac_sw_3_0.nooverlap_clk_0.x8.A single_9b_cdac_1.cdac_sw_9b_0.cdac_sw_3_0.nooverlap_clk_0.x1.A 0.42784f
C3071 single_9b_cdac_1.CF[4] single_9b_cdac_0.cdac_sw_9b_0.cdac_sw_3_3.tg_sw_3_3.SWP 0.10499f
C3072 clk a_8987_23252# 0.01751f
C3073 a_10771_22164# a_11505_22406# 0.05348f
C3074 single_9b_cdac_1.cdac_sw_9b_0.cdac_sw_3_1.tg_sw_3_3.SWP single_9b_cdac_1.cdac_sw_9b_0.cdac_sw_3_1.nooverlap_clk_0.CLK0 0.19266f
C3075 single_9b_cdac_1.cdac_sw_9b_0.cdac_sw_3_0.tg_sw_3_3.SWN single_9b_cdac_1.cdac_sw_9b_0.cdac_sw_3_0.nooverlap_clk_0.CLKB0 0.22879f
C3076 dw_17224_1400# w_17430_1606# 9.71413f
C3077 single_9b_cdac_1.cdac_sw_9b_0.cdac_sw_3_7.tg_sw_3_3.SWP a_29134_16877# 0.04592f
C3078 sar9b_0.net41 single_9b_cdac_1.SW[4] 0.02175f
C3079 ua[0] single_9b_cdac_1.cdac_sw_9b_0.cdac_sw_3_8.tg_sw_3_3.SWN 3.14416f
C3080 single_9b_cdac_1.CF[7] single_9b_cdac_0.cdac_sw_9b_0.cdac_sw_3_7.tg_sw_3_3.SWN 0.12358f
C3081 sar9b_0.net41 single_9b_cdac_1.SW[2] 0.02055f
C3082 th_dif_sw_0.th_sw_0.th_sw_main_0.VGS w_17430_1606# 0.3776f
C3083 th_dif_sw_0.CK th_dif_sw_0.VCP 0.0144f
C3084 VDPWR single_9b_cdac_1.cdac_sw_9b_0.cdac_sw_3_2.nooverlap_clk_0.x6.A 0.38397f
C3085 a_11392_25262# sar9b_0.net11 0.07531f
C3086 a_13511_21442# VDPWR 0.13708f
C3087 a_11747_20910# sar9b_0.net7 0.04068f
C3088 sar9b_0.net15 a_13403_23086# 0.17181f
C3089 single_9b_cdac_1.cdac_sw_9b_0.cdac_sw_3_3.tg_sw_3_3.SWN single_9b_cdac_1.cdac_sw_9b_0.cdac_sw_3_5.tg_sw_3_3.SWN 0.02638f
C3090 a_8431_22682# a_8951_22950# 0.04357f
C3091 a_12795_23802# a_13529_23770# 0.07009f
C3092 a_13053_21076# VDPWR 0.39138f
C3093 single_9b_cdac_1.cdac_sw_9b_0.S[4] a_44418_17740# 0.22513f
C3094 sar9b_0.clknet_1_0__leaf_CLK sar9b_0.clknet_0_CLK 0.34197f
C3095 a_11413_25670# sar9b_0.net13 0.04399f
C3096 single_9b_cdac_0.cdac_sw_9b_0.cdac_sw_3_0.nooverlap_clk_0.x8.A VDPWR 0.84082f
C3097 single_9b_cdac_1.CF[4] single_9b_cdac_0.SW[2] 0.01997f
C3098 ua[0] single_9b_cdac_1.CF[8] 5.00726f
C3099 sar9b_0.net41 sar9b_0.FINAL 0.04817f
C3100 a_10142_20354# a_10356_20354# 0.09774f
C3101 a_10211_20225# a_10774_20354# 0.04983f
C3102 a_10055_20130# sar9b_0.net2 0.29565f
C3103 a_8085_23802# a_8526_23770# 0.12497f
C3104 a_7919_23802# a_8358_23796# 0.27314f
C3105 a_6759_20354# sar9b_0.clknet_1_0__leaf_CLK 0.05122f
C3106 a_12887_18900# a_13968_18900# 0.10236f
C3107 a_13053_18900# a_14143_18874# 0.04242f
C3108 a_13621_19142# a_13403_18900# 0.20964f
C3109 a_12793_18330# sar9b_0.net35 0.01913f
C3110 VDPWR single_9b_cdac_0.cdac_sw_9b_0.cdac_sw_3_3.nooverlap_clk_0.sky130_fd_sc_hs__nand2_1_0.Y 0.62553f
C3111 a_11471_24174# a_11579_23796# 0.05722f
C3112 sar9b_0.net40 single_9b_cdac_1.SW[8] 0.05037f
C3113 sar9b_0.net11 sar9b_0.net12 0.14649f
C3114 a_12795_23802# a_13876_24174# 0.10236f
C3115 single_9b_cdac_0.SW[8] single_9b_cdac_0.cdac_sw_9b_0.cdac_sw_3_8.nooverlap_clk_0.CLKB0 0.36652f
C3116 a_7059_21228# sar9b_0._09_ 0.18218f
C3117 single_9b_cdac_0.cdac_sw_9b_0.cdac_sw_3_4.tg_sw_3_3.SWP VDPWR 3.27794f
C3118 a_8543_27060# a_8435_27438# 0.05722f
C3119 sar9b_0.net5 sar9b_0.net6 1.03367f
C3120 single_9b_cdac_0.cdac_sw_9b_0.cdac_sw_3_2.nooverlap_clk_0.x8.A single_9b_cdac_0.cdac_sw_9b_0.cdac_sw_3_2.nooverlap_clk_0.sky130_fd_sc_hs__inv_8_0.A 0.04988f
C3121 single_9b_cdac_0.SW[2] clk 0.08297f
C3122 a_12027_22138# sar9b_0.net9 0.05903f
C3123 a_7795_26276# VDPWR 0.36938f
C3124 a_8340_27426# a_7919_27066# 0.08671f
C3125 sar9b_0.net40 sar9b_0.net13 0.01273f
C3126 a_8287_19450# a_8453_19450# 0.57906f
C3127 a_53154_26999# single_9b_cdac_0.cdac_sw_9b_0.S[2] 0.59531f
C3128 a_13053_19988# sar9b_0.net5 0.02302f
C3129 single_9b_cdac_1.cdac_sw_9b_0.cdac_sw_3_1.nooverlap_clk_0.x6.A VDPWR 0.38397f
C3130 single_9b_cdac_0.SW[1] single_9b_cdac_1.CF[3] 0.01995f
C3131 a_7925_23502# sar9b_0.clk_div_0.COUNT\[1\] 0.01181f
C3132 a_6308_27060# a_6163_27034# 0.05722f
C3133 single_9b_cdac_0.cdac_sw_9b_0.cdac_sw_3_5.nooverlap_clk_0.x8.A single_9b_cdac_0.cdac_sw_9b_0.cdac_sw_3_5.nooverlap_clk_0.x6.A 0.11216f
C3134 sar9b_0.net41 a_13899_20532# 0.06899f
C3135 VDPWR single_9b_cdac_0.cdac_sw_9b_0.cdac_sw_3_2.nooverlap_clk_0.x10.A 0.95338f
C3136 a_11231_20538# a_11397_20538# 0.67009f
C3137 th_dif_sw_0.th_sw_0.th_sw_main_0.VGS th_dif_sw_0.VCN 0.14643f
C3138 a_14871_9671# a_15265_9613# 0.12812f
C3139 sar9b_0.net27 sar9b_0.net12 0.02812f
C3140 sar9b_0.net15 sar9b_0.net9 0.23398f
C3141 a_13621_24858# a_13511_24884# 0.09774f
C3142 sar9b_0.net26 a_13899_24340# 0.03586f
C3143 a_13623_24340# sar9b_0.net27 0.03054f
C3144 sar9b_0.net41 sar9b_0.net8 0.24303f
C3145 a_5619_23252# sar9b_0.net36 0.02736f
C3146 a_6059_26882# a_6169_26758# 0.09774f
C3147 a_5856_26516# a_5951_26516# 0.04983f
C3148 sar9b_0._12_ a_7345_21594# 0.02295f
C3149 a_14451_27060# a_14143_26490# 0.01215f
C3150 single_9b_cdac_0.cdac_sw_9b_0.S[1] single_9b_cdac_0.cdac_sw_9b_0.cdac_sw_3_1.nooverlap_clk_0.CLK0 0.26427f
C3151 ua[0] single_9b_cdac_1.CF[6] 3.57763f
C3152 single_9b_cdac_1.CF[8] single_9b_cdac_0.cdac_sw_9b_0.cdac_sw_3_8.nooverlap_clk_0.sky130_fd_sc_hs__inv_8_0.A 0.06019f
C3153 sar9b_0._01_ VDPWR 0.49004f
C3154 uo_out[3] VDPWR 0.80234f
C3155 sar9b_0.net15 a_14175_20532# 0.03166f
C3156 single_9b_cdac_1.cdac_sw_9b_0.cdac_sw_3_0.nooverlap_clk_0.CLK0 VDPWR 2.71729f
C3157 single_9b_cdac_0.cdac_sw_9b_0.S[1] single_9b_cdac_0.cdac_sw_9b_0.S[3] 0.3195f
C3158 sar9b_0.net38 sar9b_0.net6 0.06559f
C3159 sar9b_0._13_ a_6337_22714# 0.04248f
C3160 sar9b_0.net27 a_13968_23086# 0.01626f
C3161 VDPWR single_9b_cdac_0.cdac_sw_9b_0.cdac_sw_3_7.nooverlap_clk_0.sky130_fd_sc_hs__inv_1_1.A 0.38716f
C3162 a_9368_19822# sar9b_0.net38 0.03244f
C3163 VDPWR single_9b_cdac_1.CF[5] 2.30351f
C3164 a_8545_24340# a_8379_24340# 0.88635f
C3165 a_14175_25972# single_9b_cdac_0.SW[6] 0.112f
C3166 sar9b_0.net31 a_14175_25972# 0.23657f
C3167 a_11376_21076# sar9b_0.net2 0.16583f
C3168 a_13053_19988# sar9b_0.net38 0.02384f
C3169 a_6943_22316# sar9b_0.clk_div_0.COUNT\[0\] 0.02975f
C3170 VDPWR a_6610_22708# 0.23978f
C3171 single_9b_cdac_0.cdac_sw_9b_0.cdac_sw_3_1.tg_sw_3_3.SWP single_9b_cdac_1.CF[1] 0.10499f
C3172 a_12887_19988# single_9b_cdac_1.SW[4] 0.01627f
C3173 sar9b_0.FINAL a_11121_26516# 0.59602f
C3174 a_12795_23802# sar9b_0.net13 0.03021f
C3175 sar9b_0.net7 a_11652_20898# 0.17013f
C3176 a_12887_19988# single_9b_cdac_1.SW[2] 0.02046f
C3177 a_9648_19168# sar9b_0.net2 0.23362f
C3178 th_dif_sw_0.th_sw_1.th_sw_main_0.VGS w_12795_1601# 0.38264f
C3179 clk a_7345_21594# 0.31322f
C3180 sar9b_0.net15 a_10935_19444# 0.01221f
C3181 single_9b_cdac_1.CF[0] single_9b_cdac_1.cdac_sw_9b_0.cdac_sw_3_2.nooverlap_clk_0.sky130_fd_sc_hs__nand2_1_0.Y 0.17948f
C3182 tdc_0.OUTP sar9b_0.net1 0.05712f
C3183 a_7735_17812# VDPWR 0.33418f
C3184 a_44418_26990# single_9b_cdac_0.SW[4] 0.18991f
C3185 single_9b_cdac_1.cdac_sw_9b_0.cdac_sw_3_3.nooverlap_clk_0.sky130_fd_sc_hs__inv_1_1.A VDPWR 0.38715f
C3186 single_9b_cdac_1.cdac_sw_9b_0.cdac_sw_3_6.tg_sw_3_3.SWP single_9b_cdac_1.cdac_sw_9b_0.cdac_sw_3_7.tg_sw_3_3.SWP 0.02666f
C3187 single_9b_cdac_1.SW[8] single_9b_cdac_1.cdac_sw_9b_0.cdac_sw_3_8.tg_sw_3_3.SWP 0.17126f
C3188 VDPWR sar9b_0.net41 1.58728f
C3189 a_8637_23252# a_9552_23252# 0.12532f
C3190 a_8471_23252# a_8892_23252# 0.08594f
C3191 single_9b_cdac_0.cdac_sw_9b_0.S[1] single_9b_cdac_0.cdac_sw_9b_0.S[5] 0.26958f
C3192 a_8637_20538# sar9b_0.net35 0.03697f
C3193 VDPWR a_11852_22164# 0.33613f
C3194 ua[0] single_9b_cdac_1.CF[7] 3.57763f
C3195 a_13140_18734# sar9b_0.net1 0.01694f
C3196 single_9b_cdac_1.cdac_sw_9b_0.cdac_sw_3_6.tg_sw_3_3.SWN VDPWR 2.82172f
C3197 a_14175_24340# single_9b_cdac_0.SW[1] 0.12158f
C3198 a_9648_19168# a_9843_19137# 0.2298f
C3199 a_9370_19152# a_9774_19266# 0.05116f
C3200 a_12480_18722# sar9b_0.net6 0.01318f
C3201 single_9b_cdac_1.cdac_sw_9b_0.S[2] single_9b_cdac_1.cdac_sw_9b_0.S[7] 0.245f
C3202 single_9b_cdac_1.cdac_sw_9b_0.cdac_sw_3_1.nooverlap_clk_0.sky130_fd_sc_hs__inv_8_0.A single_9b_cdac_1.cdac_sw_9b_0.cdac_sw_3_1.nooverlap_clk_0.x8.A 0.04988f
C3203 a_16159_13315# a_16185_13034# 0.19021f
C3204 single_9b_cdac_0.cdac_sw_9b_0.cdac_sw_3_8.nooverlap_clk_0.sky130_fd_sc_hs__inv_8_0.A single_9b_cdac_0.cdac_sw_9b_0.cdac_sw_3_8.nooverlap_clk_0.x8.A 0.04988f
C3205 a_10637_27279# VDPWR 0.27422f
C3206 a_13899_23252# single_9b_cdac_1.CF[5] 0.11689f
C3207 a_6070_19721# a_6417_19822# 0.03733f
C3208 a_13403_21076# a_13308_21076# 0.04983f
C3209 a_13621_21318# a_13511_21442# 0.09774f
C3210 a_14143_21050# a_13968_21076# 0.23366f
C3211 th_dif_sw_0.CK th_dif_sw_0.th_sw_1.CKB 0.09539f
C3212 sar9b_0.net8 a_13347_21620# 0.02714f
C3213 VDPWR th_dif_sw_0.VCP 6.87158f
C3214 sar9b_0._01_ a_6249_19988# 0.09723f
C3215 single_9b_cdac_0.cdac_sw_9b_0.cdac_sw_3_3.nooverlap_clk_0.CLK0 a_44418_26990# 0.14695f
C3216 a_13621_21318# a_13053_21076# 0.18493f
C3217 a_13403_21076# a_12887_21076# 0.10748f
C3218 a_8653_27034# a_9000_27438# 0.05116f
C3219 sar9b_0.clk_div_0.COUNT\[2\] sar9b_0.clk_div_0.COUNT\[0\] 0.29886f
C3220 a_14143_25188# sar9b_0.net15 0.27364f
C3221 a_12487_20836# sar9b_0.net8 0.11265f
C3222 single_9b_cdac_0.cdac_sw_9b_0.S[0] single_9b_cdac_1.CF[1] 0.01492f
C3223 single_9b_cdac_1.cdac_sw_9b_0.cdac_sw_3_2.nooverlap_clk_0.CLK0 single_9b_cdac_1.cdac_sw_9b_0.cdac_sw_3_1.nooverlap_clk_0.CLK0 0.02632f
C3224 a_11231_20538# sar9b_0.net42 0.03405f
C3225 single_9b_cdac_1.cdac_sw_9b_0.S[5] single_9b_cdac_1.cdac_sw_9b_0.S[8] 0.93291f
C3226 sar9b_0.net42 sar9b_0.net12 0.21611f
C3227 a_6930_20241# a_6701_20506# 0.02797f
C3228 a_12887_19450# sar9b_0.net15 0.30863f
C3229 a_8931_22164# clk 0.04166f
C3230 VDPWR a_13899_25972# 0.19735f
C3231 sar9b_0.net2 a_9552_23252# 0.04303f
C3232 tdc_0.phase_detector_0.INN tdc_0.phase_detector_0.pd_out_0.B 0.0434f
C3233 sar9b_0.net7 sar9b_0.net1 0.05012f
C3234 a_10955_23802# a_12211_24100# 0.04357f
C3235 a_11691_25978# a_12112_26338# 0.09016f
C3236 single_9b_cdac_0.cdac_sw_9b_0.cdac_sw_3_1.nooverlap_clk_0.x10.A single_9b_cdac_0.cdac_sw_9b_0.cdac_sw_3_1.tg_sw_3_3.SWN 0.69086f
C3237 a_21368_4076# a_18214_3039# 0.99758f
C3238 single_9b_cdac_1.cdac_sw_9b_0.cdac_sw_3_1.nooverlap_clk_0.x8.A single_9b_cdac_1.CF[1] 0.31534f
C3239 a_12059_18362# a_12793_18330# 0.05338f
C3240 sar9b_0._03_ a_8273_23796# 0.11958f
C3241 single_9b_cdac_0.cdac_sw_9b_0.cdac_sw_3_3.nooverlap_clk_0.x1.A single_9b_cdac_0.cdac_sw_9b_0.cdac_sw_3_3.nooverlap_clk_0.x10.A 0.05472f
C3242 VDPWR single_9b_cdac_0.cdac_sw_9b_0.cdac_sw_3_7.tg_sw_3_3.SWN 2.82223f
C3243 a_6163_27034# sar9b_0.FINAL 0.0298f
C3244 single_9b_cdac_1.cdac_sw_9b_0.cdac_sw_3_5.nooverlap_clk_0.sky130_fd_sc_hs__inv_8_0.A single_9b_cdac_1.cdac_sw_9b_0.cdac_sw_3_5.nooverlap_clk_0.x1.A 0.45521f
C3245 ua[0] single_9b_cdac_1.SW[4] 0.13619f
C3246 clk a_8951_22950# 0.02928f
C3247 ua[0] single_9b_cdac_1.SW[2] 0.14772f
C3248 single_9b_cdac_1.cdac_sw_9b_0.cdac_sw_3_5.tg_sw_3_3.SWN single_9b_cdac_1.SW[5] 0.14972f
C3249 VDPWR a_11121_26516# 0.30766f
C3250 sar9b_0.net13 a_12211_26490# 0.06882f
C3251 single_9b_cdac_1.CF[3] a_13968_22164# 0.01603f
C3252 sar9b_0.net35 a_8912_22824# 0.02147f
C3253 a_6337_22714# a_7203_22682# 0.03405f
C3254 a_12575_18734# sar9b_0.net2 0.04294f
C3255 a_43540_16877# single_9b_cdac_1.cdac_sw_9b_0.cdac_sw_3_3.nooverlap_clk_0.CLKB0 0.23864f
C3256 VDPWR a_13308_18900# 0.08228f
C3257 a_8545_24340# sar9b_0.net38 0.03836f
C3258 sar9b_0.net15 a_13511_19266# 0.01498f
C3259 a_9635_26276# a_9460_26350# 0.23366f
C3260 sar9b_0.net11 a_10935_24884# 0.0266f
C3261 a_12887_18900# sar9b_0.net1 0.03725f
C3262 VDPWR a_13347_21620# 0.18735f
C3263 single_9b_cdac_1.cdac_sw_9b_0.cdac_sw_3_2.tg_sw_3_3.SWP VDPWR 3.27833f
C3264 a_9543_19748# VDPWR 0.34146f
C3265 single_9b_cdac_0.cdac_sw_9b_0.S[2] th_dif_sw_0.VCN 54.8374f
C3266 single_9b_cdac_0.cdac_sw_9b_0.cdac_sw_3_4.tg_sw_3_3.SWP single_9b_cdac_0.cdac_sw_9b_0.S[3] 1.55981f
C3267 a_11471_26516# a_11579_26882# 0.05722f
C3268 single_9b_cdac_0.SW[7] sar9b_0.net31 0.04435f
C3269 single_9b_cdac_0.SW[7] single_9b_cdac_0.SW[6] 6.32277f
C3270 a_12487_20836# VDPWR 0.33249f
C3271 sar9b_0._00_ sar9b_0._08_ 0.15759f
C3272 VDPWR a_12887_19988# 0.45017f
C3273 a_10311_19450# sar9b_0.net2 0.02962f
C3274 single_9b_cdac_0.cdac_sw_9b_0.cdac_sw_3_5.nooverlap_clk_0.sky130_fd_sc_hs__inv_8_0.A single_9b_cdac_0.cdac_sw_9b_0.cdac_sw_3_5.nooverlap_clk_0.x1.A 0.45521f
C3275 single_9b_cdac_1.SW[6] th_dif_sw_0.VCN 0.09453f
C3276 a_8895_26350# sar9b_0.net3 0.15244f
C3277 a_6169_26758# sar9b_0.FINAL 0.04941f
C3278 single_9b_cdac_1.CF[4] single_9b_cdac_1.SW[1] 0.22097f
C3279 sar9b_0._01_ sar9b_0.net36 0.07258f
C3280 sar9b_0._00_ sar9b_0.net37 0.38621f
C3281 a_11567_19748# sar9b_0.net6 0.06945f
C3282 a_13311_24174# a_13216_24162# 0.04983f
C3283 single_9b_cdac_0.SW[7] single_9b_cdac_0.SW[4] 0.07046f
C3284 uo_out[5] ui_in[0] 0.06786f
C3285 sar9b_0.net12 a_13308_25250# 0.01217f
C3286 single_9b_cdac_0.SW[7] single_9b_cdac_0.cdac_sw_9b_0.cdac_sw_3_7.tg_sw_3_3.SWP 0.17509f
C3287 single_9b_cdac_0.cdac_sw_9b_0.cdac_sw_3_5.nooverlap_clk_0.sky130_fd_sc_hs__inv_1_1.A single_9b_cdac_0.cdac_sw_9b_0.cdac_sw_3_5.nooverlap_clk_0.sky130_fd_sc_hs__nand2_1_0.Y 0.12223f
C3288 single_9b_cdac_0.cdac_sw_9b_0.cdac_sw_3_8.nooverlap_clk_0.x6.A single_9b_cdac_0.cdac_sw_9b_0.cdac_sw_3_8.nooverlap_clk_0.x4.A 0.12431f
C3289 a_5487_27034# a_5690_27192# 0.23366f
C3290 single_9b_cdac_0.SW[8] single_9b_cdac_0.cdac_sw_9b_0.cdac_sw_3_8.tg_sw_3_3.SWP 0.17661f
C3291 sar9b_0._13_ sar9b_0._07_ 0.06172f
C3292 sar9b_0.net15 a_13623_25972# 0.02254f
C3293 a_14143_25402# VDPWR 0.34971f
C3294 clk single_9b_cdac_1.SW[1] 0.28339f
C3295 a_13968_25428# single_9b_cdac_0.SW[5] 0.02373f
C3296 a_13899_21620# single_9b_cdac_1.CF[1] 0.12158f
C3297 VDPWR single_9b_cdac_0.cdac_sw_9b_0.cdac_sw_3_4.nooverlap_clk_0.x10.A 0.95338f
C3298 single_9b_cdac_1.SW[6] single_9b_cdac_1.CF[0] 0.74384f
C3299 sar9b_0.net2 a_10406_19266# 0.15615f
C3300 single_9b_cdac_1.CF[4] single_9b_cdac_1.cdac_sw_9b_0.cdac_sw_3_3.nooverlap_clk_0.x10.A 0.02149f
C3301 a_10311_24890# sar9b_0.net11 0.05078f
C3302 single_9b_cdac_1.cdac_sw_9b_0.cdac_sw_3_0.tg_sw_3_3.SWN single_9b_cdac_1.cdac_sw_9b_0.cdac_sw_3_4.tg_sw_3_3.SWN 0.02519f
C3303 a_13053_19988# a_13511_20354# 0.02761f
C3304 single_9b_cdac_1.SW[8] sar9b_0.net39 0.07089f
C3305 single_9b_cdac_1.cdac_sw_9b_0.S[8] single_9b_cdac_1.cdac_sw_9b_0.S[0] 0.23119f
C3306 single_9b_cdac_0.cdac_sw_9b_0.cdac_sw_3_1.tg_sw_3_3.SWN single_9b_cdac_0.cdac_sw_9b_0.S[1] 0.84424f
C3307 single_9b_cdac_1.SW[8] clk 0.08236f
C3308 sar9b_0._11_ a_7817_23252# 0.0517f
C3309 a_34814_17740# single_9b_cdac_1.cdac_sw_9b_0.S[6] 0.22352f
C3310 a_10955_26516# sar9b_0.net42 0.16518f
C3311 single_9b_cdac_0.SW[1] single_9b_cdac_1.CF[1] 2.07974f
C3312 single_9b_cdac_1.SW[6] single_9b_cdac_1.cdac_sw_9b_0.cdac_sw_3_6.nooverlap_clk_0.CLKB0 0.363f
C3313 uo_out[6] a_8085_27066# 0.04127f
C3314 sar9b_0.net11 a_8526_23770# 0.03028f
C3315 sar9b_0.net39 sar9b_0.net13 0.02627f
C3316 a_8911_19444# sar9b_0.net15 0.01316f
C3317 a_9843_19137# a_10406_19266# 0.04983f
C3318 a_9687_19042# a_10955_18900# 0.09666f
C3319 a_9774_19266# a_9988_19266# 0.09774f
C3320 a_12211_21050# a_10955_21076# 0.04357f
C3321 sar9b_0.net25 a_13403_26516# 0.01395f
C3322 sar9b_0.net38 a_8637_23252# 0.03581f
C3323 a_13511_25794# a_13053_25428# 0.02935f
C3324 VDPWR a_6163_27034# 0.1987f
C3325 a_8545_24340# a_8800_24340# 0.06418f
C3326 sar9b_0.net2 sar9b_0.net5 0.07133f
C3327 a_13403_21076# sar9b_0.net15 0.19019f
C3328 a_6315_21050# a_6451_21326# 0.07178f
C3329 a_12887_24890# sar9b_0.net39 0.03595f
C3330 single_9b_cdac_1.cdac_sw_9b_0.cdac_sw_3_1.tg_sw_3_3.SWN single_9b_cdac_1.CF[2] 0.03543f
C3331 sar9b_0._07_ sar9b_0._09_ 0.51335f
C3332 a_10477_23252# a_11392_23252# 0.11876f
C3333 sar9b_0.net1 sar9b_0.net9 0.48527f
C3334 single_9b_cdac_0.cdac_sw_9b_0.cdac_sw_3_3.nooverlap_clk_0.x4.A single_9b_cdac_0.cdac_sw_9b_0.cdac_sw_3_3.nooverlap_clk_0.x3.Y 0.07517f
C3335 single_9b_cdac_0.cdac_sw_9b_0.cdac_sw_3_5.tg_sw_3_3.SWN single_9b_cdac_1.CF[5] 0.12358f
C3336 VDPWR th_dif_sw_0.th_sw_1.CKB 3.04581f
C3337 a_5895_19988# a_6061_19988# 0.56739f
C3338 single_9b_cdac_0.cdac_sw_9b_0.cdac_sw_3_6.nooverlap_clk_0.x1.A single_9b_cdac_0.cdac_sw_9b_0.cdac_sw_3_6.nooverlap_clk_0.sky130_fd_sc_hs__nand2_1_0.Y 0.01003f
C3339 single_9b_cdac_0.cdac_sw_9b_0.S[6] single_9b_cdac_0.cdac_sw_9b_0.S[2] 0.24885f
C3340 single_9b_cdac_1.CF[8] single_9b_cdac_1.cdac_sw_9b_0.cdac_sw_3_7.tg_sw_3_3.SWP 0.19147f
C3341 single_9b_cdac_1.cdac_sw_9b_0.cdac_sw_3_8.nooverlap_clk_0.x8.A single_9b_cdac_1.cdac_sw_9b_0.cdac_sw_3_8.nooverlap_clk_0.x6.A 0.11216f
C3342 a_9447_22164# a_9543_22164# 0.01379f
C3343 ua[0] VDPWR 93.8545f
C3344 a_10955_18900# a_11376_18900# 0.09016f
C3345 single_9b_cdac_1.cdac_sw_9b_0.cdac_sw_3_8.nooverlap_clk_0.x8.A single_9b_cdac_1.cdac_sw_9b_0.cdac_sw_3_8.nooverlap_clk_0.x1.A 0.42784f
C3346 a_6679_22316# sar9b_0.clk_div_0.COUNT\[1\] 0.13118f
C3347 a_14451_18356# a_14451_17812# 0.01224f
C3348 a_6417_19822# VDPWR 0.07768f
C3349 a_13053_25428# sar9b_0.net39 0.03242f
C3350 single_9b_cdac_0.SW[3] th_dif_sw_0.VCN 0.09453f
C3351 VDPWR a_6169_26758# 0.21521f
C3352 ui_in[0] clk 0.23226f
C3353 VDPWR a_6149_23770# 1.33279f
C3354 a_11121_21076# VDPWR 0.62692f
C3355 sar9b_0.net2 sar9b_0.net38 0.05356f
C3356 single_9b_cdac_1.cdac_sw_9b_0.cdac_sw_3_6.tg_sw_3_3.SWN single_9b_cdac_1.cdac_sw_9b_0.S[6] 0.84423f
C3357 a_6930_20241# VDPWR 0.48025f
C3358 sar9b_0.net26 single_9b_cdac_0.SW[1] 0.11829f
C3359 VDPWR a_13403_22164# 0.20052f
C3360 sar9b_0.net41 a_10187_22138# 0.01742f
C3361 sar9b_0.net28 a_14051_24100# 0.02627f
C3362 single_9b_cdac_1.SW[0] single_9b_cdac_1.cdac_sw_9b_0.cdac_sw_3_6.nooverlap_clk_0.CLK0 0.03931f
C3363 a_6219_22316# sar9b_0._04_ 0.10004f
C3364 a_6679_22316# a_6171_22714# 0.01017f
C3365 a_8803_19822# a_8911_19444# 0.05722f
C3366 single_9b_cdac_1.SW[3] sar9b_0.net6 0.09138f
C3367 a_6502_20124# sar9b_0._00_ 0.02325f
C3368 single_9b_cdac_0.SW[3] single_9b_cdac_0.cdac_sw_9b_0.cdac_sw_3_4.nooverlap_clk_0.CLKB0 0.36301f
C3369 single_9b_cdac_1.cdac_sw_9b_0.cdac_sw_3_1.tg_sw_3_3.SWN single_9b_cdac_1.cdac_sw_9b_0.S[1] 0.84423f
C3370 single_9b_cdac_1.SW[7] a_30012_17740# 0.18991f
C3371 single_9b_cdac_1.CF[2] single_9b_cdac_1.cdac_sw_9b_0.S[1] 0.01515f
C3372 single_9b_cdac_0.cdac_sw_9b_0.cdac_sw_3_8.nooverlap_clk_0.x10.A single_9b_cdac_0.cdac_sw_9b_0.cdac_sw_3_8.nooverlap_clk_0.sky130_fd_sc_hs__inv_8_0.A 0.05105f
C3373 sar9b_0.net41 sar9b_0.net10 0.11038f
C3374 single_9b_cdac_1.cdac_sw_9b_0.cdac_sw_3_3.nooverlap_clk_0.x4.A single_9b_cdac_1.cdac_sw_9b_0.cdac_sw_3_3.nooverlap_clk_0.x3.Y 0.07517f
C3375 single_9b_cdac_1.CF[7] single_9b_cdac_1.cdac_sw_9b_0.cdac_sw_3_7.nooverlap_clk_0.CLK0 0.42014f
C3376 sar9b_0.net10 a_11852_22164# 0.04909f
C3377 a_13053_19988# single_9b_cdac_1.SW[3] 0.02678f
C3378 a_10732_19810# sar9b_0.net4 0.01845f
C3379 single_9b_cdac_1.cdac_sw_9b_0.S[6] th_dif_sw_0.VCP 3.14598f
C3380 sar9b_0._14_ sar9b_0.net3 0.04954f
C3381 a_14051_24100# sar9b_0.net29 0.03302f
C3382 tdc_0.OUTN tdc_0.OUTP 1.47806f
C3383 single_9b_cdac_1.CF[8] single_9b_cdac_1.cdac_sw_9b_0.cdac_sw_3_8.nooverlap_clk_0.x4.A 0.0313f
C3384 a_13403_19822# a_13499_19822# 0.01379f
C3385 a_13968_21076# sar9b_0.net27 0.01809f
C3386 a_5483_19676# a_5863_19662# 0.04875f
C3387 single_9b_cdac_0.cdac_sw_9b_0.cdac_sw_3_8.nooverlap_clk_0.sky130_fd_sc_hs__inv_8_0.A VDPWR 0.96901f
C3388 single_9b_cdac_1.CF[4] single_9b_cdac_0.cdac_sw_9b_0.cdac_sw_3_3.tg_sw_3_3.SWN 0.12358f
C3389 single_9b_cdac_1.SW[7] sar9b_0.net15 0.02367f
C3390 sar9b_0.net15 a_10012_22164# 0.25481f
C3391 single_9b_cdac_1.cdac_sw_9b_0.cdac_sw_3_4.nooverlap_clk_0.x1.A single_9b_cdac_1.cdac_sw_9b_0.cdac_sw_3_4.nooverlap_clk_0.x6.A 0.03729f
C3392 sar9b_0.net40 a_10477_24890# 0.0309f
C3393 a_5969_25428# a_6319_25428# 0.22556f
C3394 single_9b_cdac_1.CF[5] single_9b_cdac_0.SW[4] 0.06951f
C3395 a_9281_26516# a_10371_26490# 0.04209f
C3396 sar9b_0._15_ VDPWR 0.50547f
C3397 single_9b_cdac_1.CF[7] single_9b_cdac_1.cdac_sw_9b_0.cdac_sw_3_7.nooverlap_clk_0.x8.A 0.31534f
C3398 a_12480_18722# sar9b_0.net2 0.17365f
C3399 a_13623_21620# single_9b_cdac_1.CF[0] 0.1173f
C3400 sar9b_0._15_ a_7735_21076# 0.21087f
C3401 a_10311_24890# sar9b_0.net42 0.03092f
C3402 sar9b_0.net14 a_14175_27060# 0.20398f
C3403 single_9b_cdac_1.cdac_sw_9b_0.cdac_sw_3_4.tg_sw_3_3.SWP single_9b_cdac_1.CF[3] 0.105f
C3404 a_33936_26999# single_9b_cdac_0.cdac_sw_9b_0.cdac_sw_3_6.tg_sw_3_3.SWP 0.04592f
C3405 single_9b_cdac_0.cdac_sw_9b_0.S[2] single_9b_cdac_1.CF[3] 0.01472f
C3406 single_9b_cdac_1.cdac_sw_9b_0.cdac_sw_3_3.tg_sw_3_3.SWP single_9b_cdac_1.cdac_sw_9b_0.cdac_sw_3_3.nooverlap_clk_0.CLK0 0.19266f
C3407 a_10774_20354# sar9b_0.net8 0.01429f
C3408 sar9b_0.net3 a_6587_21852# 0.06483f
C3409 a_12887_19450# sar9b_0.net1 0.19959f
C3410 VDPWR a_8471_23252# 0.46286f
C3411 ua[0] single_9b_cdac_1.cdac_sw_9b_0.cdac_sw_3_4.nooverlap_clk_0.CLKB0 0.12344f
C3412 single_9b_cdac_1.cdac_sw_9b_0.cdac_sw_3_2.nooverlap_clk_0.CLKB0 VDPWR 2.81139f
C3413 single_9b_cdac_0.cdac_sw_9b_0.cdac_sw_3_5.nooverlap_clk_0.sky130_fd_sc_hs__nand2_1_0.Y single_9b_cdac_0.cdac_sw_9b_0.cdac_sw_3_5.nooverlap_clk_0.x1.A 0.01003f
C3414 single_9b_cdac_1.CF[7] single_9b_cdac_1.cdac_sw_9b_0.cdac_sw_3_7.tg_sw_3_3.SWP 0.10499f
C3415 a_11121_23802# sar9b_0.net13 0.02858f
C3416 sar9b_0.net15 a_10371_21050# 0.33016f
C3417 single_9b_cdac_0.SW[1] single_9b_cdac_1.CF[8] 0.01728f
C3418 a_13621_19418# a_13403_19822# 0.20964f
C3419 a_13053_19450# a_14143_19748# 0.04242f
C3420 a_12887_19450# a_13968_19822# 0.10236f
C3421 a_9738_20240# a_10055_20130# 0.10236f
C3422 single_9b_cdac_1.CF[2] th_dif_sw_0.VCN 0.09453f
C3423 a_13899_24340# VDPWR 0.19583f
C3424 sar9b_0.net24 sar9b_0.net3 0.03832f
C3425 sar9b_0.net40 sar9b_0.net38 0.05494f
C3426 sar9b_0._05_ sar9b_0.clknet_0_CLK 0.01902f
C3427 single_9b_cdac_1.cdac_sw_9b_0.cdac_sw_3_3.tg_sw_3_3.SWN single_9b_cdac_1.cdac_sw_9b_0.cdac_sw_3_3.nooverlap_clk_0.CLK0 0.17533f
C3428 sar9b_0.clk_div_0.COUNT\[1\] sar9b_0.net38 0.01164f
C3429 single_9b_cdac_0.SW[6] a_13899_25972# 0.11025f
C3430 sar9b_0.net31 a_13899_25972# 0.0337f
C3431 uio_out[0] a_6163_27034# 0.01696f
C3432 th_dif_sw_0.CK a_10166_3438# 0.01131f
C3433 sar9b_0.net23 sar9b_0.net39 0.22006f
C3434 single_9b_cdac_1.cdac_sw_9b_0.cdac_sw_3_3.tg_sw_3_3.SWN single_9b_cdac_1.cdac_sw_9b_0.cdac_sw_3_5.nooverlap_clk_0.CLKB0 0.01175f
C3435 single_9b_cdac_0.cdac_sw_9b_0.cdac_sw_3_3.nooverlap_clk_0.x6.A VDPWR 0.38397f
C3436 single_9b_cdac_1.CF[0] single_9b_cdac_1.CF[2] 0.04067f
C3437 a_13857_27279# VDPWR 0.20848f
C3438 sar9b_0.net15 a_11471_18900# 0.16754f
C3439 single_9b_cdac_1.cdac_sw_9b_0.cdac_sw_3_6.nooverlap_clk_0.sky130_fd_sc_hs__nand2_1_0.Y single_9b_cdac_1.cdac_sw_9b_0.cdac_sw_3_6.nooverlap_clk_0.x1.A 0.01003f
C3440 ua[1] a_21368_4076# 0.65711f
C3441 sar9b_0._14_ sar9b_0.net15 0.06546f
C3442 single_9b_cdac_0.SW[6] single_9b_cdac_0.cdac_sw_9b_0.cdac_sw_3_7.tg_sw_3_3.SWN 0.05279f
C3443 sar9b_0.net3 a_8435_27438# 0.18821f
C3444 a_10774_20354# VDPWR 0.07848f
C3445 VDPWR a_10955_23802# 0.50292f
C3446 a_8379_25978# sar9b_0.FINAL 0.26662f
C3447 a_6226_23364# sar9b_0.clknet_1_1__leaf_CLK 0.04744f
C3448 single_9b_cdac_1.cdac_sw_9b_0.S[4] single_9b_cdac_1.SW[4] 0.22983f
C3449 single_9b_cdac_0.cdac_sw_9b_0.cdac_sw_3_5.nooverlap_clk_0.x6.A single_9b_cdac_0.cdac_sw_9b_0.cdac_sw_3_5.nooverlap_clk_0.x4.A 0.12431f
C3450 a_14143_23012# single_9b_cdac_1.CF[5] 0.01961f
C3451 single_9b_cdac_1.cdac_sw_9b_0.cdac_sw_3_7.tg_sw_3_3.SWN single_9b_cdac_1.cdac_sw_9b_0.cdac_sw_3_7.nooverlap_clk_0.CLKB0 0.22879f
C3452 single_9b_cdac_0.SW[1] single_9b_cdac_1.CF[6] 0.02407f
C3453 single_9b_cdac_0.cdac_sw_9b_0.cdac_sw_3_7.nooverlap_clk_0.x3.Y single_9b_cdac_0.cdac_sw_9b_0.cdac_sw_3_7.nooverlap_clk_0.x1.A 0.07579f
C3454 a_11392_25262# sar9b_0.net15 0.26121f
C3455 a_5487_27034# a_6007_27302# 0.04357f
C3456 a_12211_18874# a_12036_18900# 0.23366f
C3457 single_9b_cdac_0.cdac_sw_9b_0.cdac_sw_3_7.tg_sw_3_3.SWP single_9b_cdac_0.cdac_sw_9b_0.cdac_sw_3_7.tg_sw_3_3.SWN 3.10626f
C3458 a_5435_26516# a_5951_26516# 0.11208f
C3459 single_9b_cdac_0.SW[2] single_9b_cdac_0.cdac_sw_9b_0.cdac_sw_3_0.nooverlap_clk_0.CLKB0 0.363f
C3460 a_12947_26276# sar9b_0.net33 0.01473f
C3461 ua[0] single_9b_cdac_0.cdac_sw_9b_0.cdac_sw_3_1.nooverlap_clk_0.CLK0 0.12077f
C3462 uio_out[0] a_6169_26758# 0.02189f
C3463 single_9b_cdac_0.cdac_sw_9b_0.cdac_sw_3_4.nooverlap_clk_0.x1.A single_9b_cdac_0.cdac_sw_9b_0.cdac_sw_3_4.nooverlap_clk_0.x10.A 0.05472f
C3464 a_11471_21076# a_11579_21442# 0.05722f
C3465 sar9b_0.net15 a_13621_19142# 0.22296f
C3466 sar9b_0.net25 sar9b_0.net39 0.34768f
C3467 a_16331_9671# clk 0.37638f
C3468 VDPWR a_9687_19042# 0.45658f
C3469 ua[0] single_9b_cdac_0.cdac_sw_9b_0.S[3] 1.58351f
C3470 sar9b_0.net40 a_13623_20532# 0.05224f
C3471 a_8287_19450# sar9b_0.net15 1.05006f
C3472 a_38738_16877# VDPWR 1.81495f
C3473 sar9b_0.net15 a_6587_21852# 0.14857f
C3474 a_11231_20538# sar9b_0.net15 0.34061f
C3475 a_9167_18874# a_9648_19168# 0.04242f
C3476 sar9b_0.net15 sar9b_0.net12 0.54754f
C3477 a_26951_15501# single_9b_cdac_1.cdac_sw_9b_0.cdac_sw_3_8.nooverlap_clk_0.sky130_fd_sc_hs__nand2_1_0.Y 0.01076f
C3478 a_13623_24340# sar9b_0.net15 0.02679f
C3479 a_13403_22164# a_13499_22164# 0.01379f
C3480 single_9b_cdac_0.SW[3] single_9b_cdac_1.CF[3] 1.96064f
C3481 a_6679_22316# sar9b_0._12_ 0.03698f
C3482 single_9b_cdac_1.cdac_sw_9b_0.cdac_sw_3_4.nooverlap_clk_0.x4.A single_9b_cdac_1.cdac_sw_9b_0.cdac_sw_3_4.nooverlap_clk_0.sky130_fd_sc_hs__nand2_1_0.Y 0.01751f
C3483 sar9b_0.net3 a_10955_26516# 0.3386f
C3484 sar9b_0.net7 sar9b_0.net6 0.74588f
C3485 sar9b_0.net35 a_8892_23252# 0.01036f
C3486 a_14143_25402# sar9b_0.net31 0.02434f
C3487 a_14143_25402# single_9b_cdac_0.SW[6] 0.01834f
C3488 a_11121_18900# sar9b_0.net6 0.74275f
C3489 ua[0] single_9b_cdac_1.cdac_sw_9b_0.S[6] 1.70987f
C3490 single_9b_cdac_0.SW[1] single_9b_cdac_1.CF[7] 0.02111f
C3491 VDPWR a_11376_18900# 0.08458f
C3492 sar9b_0.net24 sar9b_0.net15 0.01797f
C3493 sar9b_0.net15 a_13968_23086# 0.23665f
C3494 single_9b_cdac_0.cdac_sw_9b_0.cdac_sw_3_1.nooverlap_clk_0.CLKB0 single_9b_cdac_1.CF[1] 0.26707f
C3495 ua[0] single_9b_cdac_0.cdac_sw_9b_0.cdac_sw_3_5.tg_sw_3_3.SWN 3.10218f
C3496 a_8634_22840# a_8912_22824# 0.12532f
C3497 single_9b_cdac_1.SW[8] a_24332_16877# 0.28324f
C3498 single_9b_cdac_0.cdac_sw_9b_0.cdac_sw_3_8.nooverlap_clk_0.x3.Y single_9b_cdac_0.cdac_sw_9b_0.cdac_sw_3_8.nooverlap_clk_0.x1.A 0.07579f
C3499 a_12961_23802# a_13311_24174# 0.2298f
C3500 a_12795_23802# a_14051_24100# 0.04357f
C3501 single_9b_cdac_1.CF[8] single_9b_cdac_0.cdac_sw_9b_0.cdac_sw_3_8.nooverlap_clk_0.x1.A 0.06503f
C3502 ua[0] single_9b_cdac_0.cdac_sw_9b_0.S[5] 1.56452f
C3503 a_10845_25428# VDPWR 0.5939f
C3504 a_11935_25402# sar9b_0.net13 0.07754f
C3505 single_9b_cdac_1.cdac_sw_9b_0.cdac_sw_3_1.nooverlap_clk_0.sky130_fd_sc_hs__nand2_1_0.Y single_9b_cdac_1.CF[1] 0.17948f
C3506 single_9b_cdac_0.cdac_sw_9b_0.cdac_sw_3_1.tg_sw_3_3.SWP VDPWR 3.27803f
C3507 single_9b_cdac_0.cdac_sw_9b_0.cdac_sw_3_3.tg_sw_3_3.SWP single_9b_cdac_0.cdac_sw_9b_0.cdac_sw_3_3.tg_sw_3_3.SWN 3.10626f
C3508 a_7919_23802# a_8783_23796# 0.03224f
C3509 a_8085_23802# a_8951_23770# 0.03405f
C3510 a_8526_23770# a_8358_23796# 0.23992f
C3511 uo_out[7] a_7417_27279# 0.12305f
C3512 a_14451_21620# single_9b_cdac_1.CF[3] 0.11212f
C3513 a_9849_26758# sar9b_0.FINAL 0.02208f
C3514 single_9b_cdac_0.cdac_sw_9b_0.cdac_sw_3_6.nooverlap_clk_0.CLK0 single_9b_cdac_0.SW[5] 0.01402f
C3515 single_9b_cdac_1.cdac_sw_9b_0.cdac_sw_3_7.nooverlap_clk_0.CLK0 VDPWR 2.71729f
C3516 a_13053_18900# a_13308_18900# 0.06418f
C3517 a_13621_19142# a_13968_18900# 0.05116f
C3518 a_13623_24340# single_9b_cdac_0.SW[0] 0.11038f
C3519 a_13315_18660# sar9b_0.net35 0.07771f
C3520 single_9b_cdac_1.cdac_sw_9b_0.cdac_sw_3_3.nooverlap_clk_0.CLKB0 single_9b_cdac_1.cdac_sw_9b_0.cdac_sw_3_3.nooverlap_clk_0.sky130_fd_sc_hs__inv_8_0.A 0.6919f
C3521 a_5973_23252# a_5619_23252# 0.06222f
C3522 single_9b_cdac_1.CF[7] single_9b_cdac_1.cdac_sw_9b_0.cdac_sw_3_7.nooverlap_clk_0.x3.Y 0.12898f
C3523 a_13529_23770# a_13876_24174# 0.05116f
C3524 a_35519_15495# single_9b_cdac_1.cdac_sw_9b_0.cdac_sw_3_6.nooverlap_clk_0.x4.A 0.01076f
C3525 clk a_8379_24340# 0.02531f
C3526 single_9b_cdac_1.cdac_sw_9b_0.cdac_sw_3_2.nooverlap_clk_0.x6.A single_9b_cdac_1.cdac_sw_9b_0.cdac_sw_3_2.nooverlap_clk_0.x4.A 0.12431f
C3527 single_9b_cdac_1.cdac_sw_9b_0.S[1] a_57946_16877# 0.59531f
C3528 sar9b_0.net4 sar9b_0.net11 0.14783f
C3529 ui_in[7] ui_in[6] 0.03102f
C3530 a_11192_22164# sar9b_0.net9 0.17474f
C3531 a_8379_25978# VDPWR 0.42691f
C3532 single_9b_cdac_0.SW[7] sar9b_0.net32 0.12724f
C3533 a_8287_19450# a_8803_19822# 0.11082f
C3534 a_8453_19450# a_9021_19418# 0.17072f
C3535 single_9b_cdac_1.cdac_sw_9b_0.cdac_sw_3_7.nooverlap_clk_0.x8.A VDPWR 0.84061f
C3536 sar9b_0.net17 a_5945_26191# 0.22732f
C3537 a_11231_20538# a_11747_20910# 0.10584f
C3538 a_11397_20538# a_11965_20506# 0.17006f
C3539 single_9b_cdac_1.CF[0] th_dif_sw_0.VCN 0.09453f
C3540 a_16331_9671# a_16357_9613# 0.12812f
C3541 a_14871_9671# th_dif_sw_0.VCN 0.11478f
C3542 a_8453_19450# sar9b_0.net4 0.58977f
C3543 a_5785_23252# a_6058_23618# 0.07482f
C3544 ua[0] single_9b_cdac_0.SW[6] 0.22043f
C3545 sar9b_0.net37 sar9b_0.net27 0.08267f
C3546 single_9b_cdac_1.cdac_sw_9b_0.S[3] VDPWR 4.15032f
C3547 a_5803_25428# sar9b_0.net37 0.37597f
C3548 sar9b_0.net42 a_11287_22164# 0.01048f
C3549 single_9b_cdac_0.cdac_sw_9b_0.cdac_sw_3_6.nooverlap_clk_0.x8.A single_9b_cdac_0.cdac_sw_9b_0.cdac_sw_3_6.nooverlap_clk_0.sky130_fd_sc_hs__nand2_1_0.Y 0.26942f
C3550 single_9b_cdac_1.SW[6] single_9b_cdac_1.cdac_sw_9b_0.cdac_sw_3_6.tg_sw_3_3.SWP 0.17155f
C3551 a_9631_26516# a_9739_26882# 0.05722f
C3552 single_9b_cdac_1.cdac_sw_9b_0.S[4] VDPWR 4.15153f
C3553 VDPWR a_13621_26758# 0.20533f
C3554 VDPWR a_12425_25946# 0.20918f
C3555 a_16527_10454# clk 0.20249f
C3556 a_7813_22316# sar9b_0.clknet_0_CLK 0.01535f
C3557 a_10166_3438# VDPWR 0.07486f
C3558 single_9b_cdac_1.cdac_sw_9b_0.cdac_sw_3_4.nooverlap_clk_0.CLK0 single_9b_cdac_1.SW[0] 0.03931f
C3559 sar9b_0._00_ sar9b_0._01_ 0.29979f
C3560 single_9b_cdac_0.cdac_sw_9b_0.cdac_sw_3_8.nooverlap_clk_0.x8.A single_9b_cdac_0.cdac_sw_9b_0.cdac_sw_3_8.nooverlap_clk_0.x1.A 0.42784f
C3561 single_9b_cdac_0.cdac_sw_9b_0.cdac_sw_3_3.nooverlap_clk_0.sky130_fd_sc_hs__inv_8_0.A VDPWR 0.96893f
C3562 ua[0] single_9b_cdac_0.SW[4] 0.17308f
C3563 single_9b_cdac_0.cdac_sw_9b_0.cdac_sw_3_1.nooverlap_clk_0.x1.A single_9b_cdac_1.CF[1] 0.06503f
C3564 single_9b_cdac_0.cdac_sw_9b_0.S[0] VDPWR 4.151f
C3565 single_9b_cdac_1.cdac_sw_9b_0.cdac_sw_3_7.tg_sw_3_3.SWP VDPWR 3.27833f
C3566 ua[0] single_9b_cdac_0.cdac_sw_9b_0.cdac_sw_3_7.tg_sw_3_3.SWP 1.15122f
C3567 a_8895_24340# a_8379_24340# 0.11053f
C3568 single_9b_cdac_0.SW[3] a_14451_24340# 0.11005f
C3569 single_9b_cdac_1.CF[3] single_9b_cdac_1.CF[2] 14.3539f
C3570 VDPWR a_7035_22708# 0.17488f
C3571 a_13621_20230# single_9b_cdac_1.SW[4] 0.01054f
C3572 sar9b_0.FINAL a_11471_26516# 0.0372f
C3573 a_13621_20230# single_9b_cdac_1.SW[2] 0.01557f
C3574 sar9b_0.net39 sar9b_0.net5 0.02969f
C3575 single_9b_cdac_1.cdac_sw_9b_0.cdac_sw_3_6.nooverlap_clk_0.CLK0 a_34814_17740# 0.14695f
C3576 single_9b_cdac_1.cdac_sw_9b_0.cdac_sw_3_1.nooverlap_clk_0.x8.A VDPWR 0.84061f
C3577 single_9b_cdac_1.cdac_sw_9b_0.cdac_sw_3_5.nooverlap_clk_0.CLK0 single_9b_cdac_1.SW[5] 0.24288f
C3578 single_9b_cdac_1.cdac_sw_9b_0.cdac_sw_3_5.nooverlap_clk_0.CLKB0 single_9b_cdac_1.SW[5] 0.36301f
C3579 a_13899_21620# sar9b_0.net8 0.08787f
C3580 sar9b_0._10_ sar9b_0._08_ 0.08819f
C3581 tdc_0.OUTP a_12427_17812# 0.24469f
C3582 a_8637_23252# a_9095_23618# 0.03462f
C3583 tdc_0.RDY th_dif_sw_0.CKB 0.53782f
C3584 ua[0] single_9b_cdac_0.cdac_sw_9b_0.cdac_sw_3_3.nooverlap_clk_0.CLK0 0.12076f
C3585 sar9b_0.net6 sar9b_0.net9 0.14093f
C3586 VDPWR a_11395_22530# 0.13382f
C3587 a_8910_20532# sar9b_0.net35 0.0125f
C3588 single_9b_cdac_1.cdac_sw_9b_0.cdac_sw_3_1.nooverlap_clk_0.x6.A single_9b_cdac_1.cdac_sw_9b_0.cdac_sw_3_1.nooverlap_clk_0.x4.A 0.12431f
C3589 sar9b_0._15_ sar9b_0.clk_div_0.COUNT\[3\] 0.52648f
C3590 VDPWR a_9849_26758# 0.21087f
C3591 single_9b_cdac_1.cdac_sw_9b_0.cdac_sw_3_8.tg_sw_3_3.SWP m2_23774_17236# 0.37833f
C3592 a_11121_23802# a_11471_24174# 0.2298f
C3593 sar9b_0.net37 sar9b_0._10_ 0.10571f
C3594 dw_12589_1395# th_dif_sw_0.CK 0.01653f
C3595 single_9b_cdac_0.cdac_sw_9b_0.S[6] th_dif_sw_0.VCN 3.14598f
C3596 sar9b_0.net20 sar9b_0.FINAL 0.19984f
C3597 tdc_0.phase_detector_0.INP clk 0.18819f
C3598 VDPWR single_9b_cdac_1.cdac_sw_9b_0.cdac_sw_3_8.nooverlap_clk_0.x4.A 0.62443f
C3599 single_9b_cdac_1.SW[8] single_9b_cdac_1.SW[1] 0.21732f
C3600 single_9b_cdac_0.SW[8] single_9b_cdac_0.cdac_sw_9b_0.S[8] 0.22497f
C3601 single_9b_cdac_1.cdac_sw_9b_0.cdac_sw_3_1.nooverlap_clk_0.sky130_fd_sc_hs__inv_8_0.A single_9b_cdac_1.cdac_sw_9b_0.cdac_sw_3_1.nooverlap_clk_0.x1.A 0.45521f
C3602 a_16185_13034# tdc_0.phase_detector_0.pd_out_0.B 0.0174f
C3603 single_9b_cdac_1.cdac_sw_9b_0.S[8] single_9b_cdac_1.cdac_sw_9b_0.S[7] 16.5515f
C3604 a_13308_25428# sar9b_0.FINAL 0.01683f
C3605 single_9b_cdac_0.cdac_sw_9b_0.cdac_sw_3_1.nooverlap_clk_0.x3.Y single_9b_cdac_1.CF[1] 0.12898f
C3606 single_9b_cdac_1.cdac_sw_9b_0.cdac_sw_3_4.nooverlap_clk_0.sky130_fd_sc_hs__inv_1_1.A single_9b_cdac_1.CF[3] 0.01887f
C3607 a_11231_20538# a_11652_20898# 0.08671f
C3608 clk sar9b_0.net38 0.48389f
C3609 a_14143_21050# a_13053_21076# 0.04242f
C3610 a_13968_21076# a_12887_21076# 0.10236f
C3611 a_9175_27364# a_9000_27438# 0.23366f
C3612 ua[0] single_9b_cdac_0.cdac_sw_9b_0.cdac_sw_3_1.tg_sw_3_3.SWN 3.10218f
C3613 a_13621_22682# a_12887_22714# 0.07009f
C3614 sar9b_0.net15 a_10935_24884# 0.0122f
C3615 a_11965_20506# sar9b_0.net42 0.01885f
C3616 single_9b_cdac_0.cdac_sw_9b_0.cdac_sw_3_1.nooverlap_clk_0.x1.A single_9b_cdac_0.cdac_sw_9b_0.cdac_sw_3_1.nooverlap_clk_0.x4.A 0.28523f
C3617 single_9b_cdac_1.cdac_sw_9b_0.cdac_sw_3_5.tg_sw_3_3.SWP single_9b_cdac_1.SW[0] 0.08409f
C3618 single_9b_cdac_1.cdac_sw_9b_0.cdac_sw_3_4.nooverlap_clk_0.CLKB0 single_9b_cdac_1.cdac_sw_9b_0.S[3] 0.36041f
C3619 a_13621_19418# sar9b_0.net15 0.17354f
C3620 sar9b_0.net37 sar9b_0.net42 0.06323f
C3621 a_10477_19450# a_10827_19822# 0.20698f
C3622 a_13899_21620# VDPWR 0.19169f
C3623 single_9b_cdac_1.cdac_sw_9b_0.cdac_sw_3_6.nooverlap_clk_0.CLK0 single_9b_cdac_1.cdac_sw_9b_0.cdac_sw_3_6.tg_sw_3_3.SWN 0.17533f
C3624 single_9b_cdac_0.SW[8] single_9b_cdac_0.cdac_sw_9b_0.cdac_sw_3_8.nooverlap_clk_0.CLK0 0.2453f
C3625 single_9b_cdac_1.CF[4] single_9b_cdac_1.cdac_sw_9b_0.cdac_sw_3_3.tg_sw_3_3.SWP 0.10499f
C3626 a_6907_19444# a_6930_20241# 0.0189f
C3627 sar9b_0.FINAL a_7919_27066# 0.30352f
C3628 sar9b_0.net40 single_9b_cdac_1.SW[3] 0.01365f
C3629 a_10254_2858# VDPWR 0.51112f
C3630 single_9b_cdac_1.cdac_sw_9b_0.cdac_sw_3_1.nooverlap_clk_0.x1.A single_9b_cdac_1.CF[1] 0.06503f
C3631 a_12225_18362# a_12575_18734# 0.20646f
C3632 a_12059_18362# a_13315_18660# 0.04348f
C3633 a_6171_22714# a_6337_22714# 0.96588f
C3634 a_6061_19988# sar9b_0.net37 0.01201f
C3635 sar9b_0.net27 a_13053_22164# 0.03874f
C3636 sar9b_0.net35 sar9b_0.FINAL 0.22258f
C3637 tdc_0.OUTP sar9b_0.net2 0.03595f
C3638 single_9b_cdac_0.cdac_sw_9b_0.cdac_sw_3_1.nooverlap_clk_0.CLK0 single_9b_cdac_0.cdac_sw_9b_0.cdac_sw_3_1.tg_sw_3_3.SWP 0.19266f
C3639 single_9b_cdac_1.SW[6] sar9b_0.net26 0.05619f
C3640 single_9b_cdac_0.SW[1] VDPWR 2.14086f
C3641 a_12887_24890# sar9b_0.net13 0.11371f
C3642 VDPWR a_11471_26516# 0.20724f
C3643 sar9b_0.net15 a_13419_23796# 0.02156f
C3644 a_6516_26516# sar9b_0.net38 0.01182f
C3645 single_9b_cdac_1.cdac_sw_9b_0.cdac_sw_3_5.tg_sw_3_3.SWN single_9b_cdac_1.cdac_sw_9b_0.S[5] 0.84425f
C3646 single_9b_cdac_1.CF[4] single_9b_cdac_1.cdac_sw_9b_0.cdac_sw_3_4.tg_sw_3_3.SWN 0.03478f
C3647 single_9b_cdac_1.CF[4] single_9b_cdac_1.cdac_sw_9b_0.cdac_sw_3_3.tg_sw_3_3.SWN 0.12358f
C3648 a_10311_24890# sar9b_0.net15 0.30177f
C3649 single_9b_cdac_1.cdac_sw_9b_0.cdac_sw_3_3.nooverlap_clk_0.x3.Y single_9b_cdac_1.cdac_sw_9b_0.cdac_sw_3_3.nooverlap_clk_0.x1.A 0.07579f
C3650 a_13623_20532# sar9b_0.net39 0.18916f
C3651 a_12887_24890# a_13968_25262# 0.10236f
C3652 a_12112_26338# a_11857_25978# 0.05639f
C3653 single_9b_cdac_0.cdac_sw_9b_0.cdac_sw_3_2.nooverlap_clk_0.x1.A single_9b_cdac_0.cdac_sw_9b_0.cdac_sw_3_2.nooverlap_clk_0.x3.Y 0.07579f
C3654 a_8379_25978# a_9113_25946# 0.05348f
C3655 sar9b_0.net40 a_8545_25978# 0.73727f
C3656 single_9b_cdac_0.cdac_sw_9b_0.cdac_sw_3_5.nooverlap_clk_0.x10.A VDPWR 0.95338f
C3657 VDPWR a_13621_20230# 0.20334f
C3658 single_9b_cdac_1.cdac_sw_9b_0.cdac_sw_3_7.nooverlap_clk_0.x3.Y VDPWR 0.3196f
C3659 single_9b_cdac_1.CF[3] th_dif_sw_0.VCN 0.09453f
C3660 sar9b_0.clknet_1_0__leaf_CLK a_8471_20538# 0.22605f
C3661 sar9b_0.net12 sar9b_0.net1 1.00866f
C3662 a_11045_19418# sar9b_0.net2 0.01305f
C3663 single_9b_cdac_0.SW[0] single_9b_cdac_0.cdac_sw_9b_0.cdac_sw_3_2.nooverlap_clk_0.CLK0 0.24198f
C3664 a_9460_26350# sar9b_0.net3 0.22656f
C3665 a_6691_26490# sar9b_0.FINAL 0.01378f
C3666 a_7055_26350# a_6705_25978# 0.21963f
C3667 sar9b_0.net3 sar9b_0._11_ 0.22999f
C3668 single_9b_cdac_0.cdac_sw_9b_0.cdac_sw_3_1.nooverlap_clk_0.x4.A single_9b_cdac_0.cdac_sw_9b_0.cdac_sw_3_1.nooverlap_clk_0.x3.Y 0.07517f
C3669 VDPWR sar9b_0.net20 0.20849f
C3670 th_dif_sw_0.VCP a_17125_9355# 0.05474f
C3671 a_6705_25978# a_7273_25946# 0.17589f
C3672 single_9b_cdac_1.cdac_sw_9b_0.cdac_sw_3_4.nooverlap_clk_0.x1.A single_9b_cdac_1.cdac_sw_9b_0.cdac_sw_3_4.nooverlap_clk_0.x3.Y 0.07579f
C3673 sar9b_0.net3 a_6705_25978# 0.25552f
C3674 single_9b_cdac_1.cdac_sw_9b_0.S[2] single_9b_cdac_1.cdac_sw_9b_0.cdac_sw_3_0.nooverlap_clk_0.CLK0 0.26625f
C3675 a_10477_23252# VDPWR 0.49142f
C3676 a_14451_17812# th_dif_sw_0.CK 0.1107f
C3677 a_5690_27192# sar9b_0.net3 0.23643f
C3678 a_12887_22164# sar9b_0.net9 0.22585f
C3679 uo_out[7] a_6007_27302# 0.04752f
C3680 a_13308_25428# VDPWR 0.07762f
C3681 single_9b_cdac_1.CF[0] single_9b_cdac_1.CF[3] 0.03861f
C3682 a_14451_21620# single_9b_cdac_1.CF[1] 0.01378f
C3683 a_30012_17740# single_9b_cdac_1.cdac_sw_9b_0.S[7] 0.22513f
C3684 sar9b_0._03_ VDPWR 1.11729f
C3685 sar9b_0.net7 sar9b_0.net2 0.01913f
C3686 single_9b_cdac_0.cdac_sw_9b_0.cdac_sw_3_4.nooverlap_clk_0.CLKB0 single_9b_cdac_1.CF[3] 0.26707f
C3687 sar9b_0.net2 a_11121_18900# 0.05089f
C3688 a_13623_21620# single_9b_cdac_1.CF[1] 0.11062f
C3689 a_6705_25978# sar9b_0.net19 0.03418f
C3690 a_5884_21326# sar9b_0._08_ 0.18876f
C3691 sar9b_0.net3 a_7417_27279# 0.03941f
C3692 a_13403_19988# a_13511_20354# 0.05722f
C3693 a_5483_19676# sar9b_0.net16 0.0956f
C3694 a_12887_25428# a_13621_25670# 0.07009f
C3695 single_9b_cdac_0.cdac_sw_9b_0.S[0] single_9b_cdac_0.cdac_sw_9b_0.S[3] 0.47668f
C3696 a_13499_18900# a_13403_18900# 0.01379f
C3697 sar9b_0.net32 a_13899_25972# 0.20109f
C3698 uo_out[6] a_8435_27438# 0.01826f
C3699 a_7417_27279# sar9b_0.net19 0.19791f
C3700 single_9b_cdac_1.cdac_sw_9b_0.S[3] single_9b_cdac_1.cdac_sw_9b_0.S[6] 0.61733f
C3701 VDPWR a_7919_27066# 0.42357f
C3702 single_9b_cdac_1.cdac_sw_9b_0.S[4] single_9b_cdac_1.cdac_sw_9b_0.S[6] 1.87907f
C3703 clk single_9b_cdac_0.SW[5] 0.08974f
C3704 dw_12589_1395# VDPWR 1.9037f
C3705 tdc_0.delay_gate_ori_1.sky130_fd_sc_hs__and2_1_0.A clk 0.09743f
C3706 a_11376_21076# a_10955_21076# 0.08638f
C3707 sar9b_0.net2 a_12887_18900# 0.22511f
C3708 single_9b_cdac_1.cdac_sw_9b_0.cdac_sw_3_0.nooverlap_clk_0.x10.A VDPWR 0.95338f
C3709 a_8895_24340# a_8800_24340# 0.04983f
C3710 a_9113_24582# a_9003_24706# 0.09774f
C3711 VDPWR sar9b_0.net35 6.32908f
C3712 sar9b_0.net26 single_9b_cdac_0.SW[3] 0.03774f
C3713 a_6315_21050# a_6534_21076# 0.01048f
C3714 a_13968_21076# sar9b_0.net15 0.26658f
C3715 single_9b_cdac_0.cdac_sw_9b_0.cdac_sw_3_8.nooverlap_clk_0.x10.A single_9b_cdac_0.cdac_sw_9b_0.cdac_sw_3_8.nooverlap_clk_0.x1.A 0.05472f
C3716 a_9635_26276# sar9b_0.net41 0.0139f
C3717 VDPWR a_12887_22714# 0.44123f
C3718 single_9b_cdac_1.cdac_sw_9b_0.cdac_sw_3_6.nooverlap_clk_0.x8.A single_9b_cdac_1.cdac_sw_9b_0.cdac_sw_3_6.nooverlap_clk_0.x4.A 0.0303f
C3719 single_9b_cdac_0.cdac_sw_9b_0.cdac_sw_3_3.nooverlap_clk_0.x10.A single_9b_cdac_0.cdac_sw_9b_0.cdac_sw_3_3.nooverlap_clk_0.sky130_fd_sc_hs__inv_8_0.A 0.05105f
C3720 single_9b_cdac_1.cdac_sw_9b_0.cdac_sw_3_2.nooverlap_clk_0.x8.A single_9b_cdac_1.cdac_sw_9b_0.cdac_sw_3_2.nooverlap_clk_0.x6.A 0.11216f
C3721 sar9b_0.clk_div_0.COUNT\[0\] VDPWR 1.81319f
C3722 a_6061_19988# a_6502_20124# 0.12889f
C3723 a_5895_19988# a_6343_20354# 0.15141f
C3724 single_9b_cdac_0.cdac_sw_9b_0.S[0] single_9b_cdac_0.cdac_sw_9b_0.S[5] 0.33259f
C3725 VDPWR single_9b_cdac_0.cdac_sw_9b_0.cdac_sw_3_8.nooverlap_clk_0.x1.A 0.75853f
C3726 single_9b_cdac_1.cdac_sw_9b_0.cdac_sw_3_8.nooverlap_clk_0.x1.A single_9b_cdac_1.cdac_sw_9b_0.cdac_sw_3_8.nooverlap_clk_0.x6.A 0.03729f
C3727 a_13511_22708# a_13621_22682# 0.09774f
C3728 single_9b_cdac_1.cdac_sw_9b_0.S[2] th_dif_sw_0.VCP 54.8374f
C3729 single_9b_cdac_1.cdac_sw_9b_0.cdac_sw_3_1.tg_sw_3_3.SWN single_9b_cdac_1.CF[1] 0.12358f
C3730 single_9b_cdac_0.cdac_sw_9b_0.cdac_sw_3_4.tg_sw_3_3.SWP single_9b_cdac_0.cdac_sw_9b_0.cdac_sw_3_4.tg_sw_3_3.SWN 3.10626f
C3731 a_11121_18900# a_11579_19266# 0.03462f
C3732 VDPWR a_13216_24162# 0.08325f
C3733 single_9b_cdac_1.CF[1] single_9b_cdac_1.CF[2] 16.513f
C3734 sar9b_0.clkload0.X VDPWR 0.34236f
C3735 single_9b_cdac_1.SW[6] single_9b_cdac_1.CF[6] 2.01497f
C3736 single_9b_cdac_1.cdac_sw_9b_0.cdac_sw_3_3.nooverlap_clk_0.x4.A single_9b_cdac_1.cdac_sw_9b_0.cdac_sw_3_3.nooverlap_clk_0.x8.A 0.0303f
C3737 a_6417_19822# sar9b_0._00_ 0.1303f
C3738 single_9b_cdac_0.cdac_sw_9b_0.cdac_sw_3_0.nooverlap_clk_0.CLK0 single_9b_cdac_0.cdac_sw_9b_0.cdac_sw_3_0.tg_sw_3_3.SWP 0.19266f
C3739 single_9b_cdac_1.SW[0] single_9b_cdac_1.cdac_sw_9b_0.cdac_sw_3_8.nooverlap_clk_0.CLK0 0.03931f
C3740 VDPWR a_6691_26490# 0.33656f
C3741 single_9b_cdac_0.cdac_sw_9b_0.cdac_sw_3_8.nooverlap_clk_0.x3.Y single_9b_cdac_0.cdac_sw_9b_0.cdac_sw_3_8.nooverlap_clk_0.x4.A 0.07517f
C3742 single_9b_cdac_1.CF[8] single_9b_cdac_0.cdac_sw_9b_0.cdac_sw_3_8.nooverlap_clk_0.x4.A 0.0313f
C3743 a_9113_24582# VDPWR 0.21248f
C3744 a_11471_21076# VDPWR 0.22473f
C3745 sar9b_0._14_ sar9b_0._09_ 0.10269f
C3746 ua[0] single_9b_cdac_0.cdac_sw_9b_0.cdac_sw_3_3.nooverlap_clk_0.CLKB0 0.12358f
C3747 a_10016_20256# a_10211_20225# 0.21686f
C3748 a_9535_19962# VDPWR 0.35324f
C3749 single_9b_cdac_1.cdac_sw_9b_0.cdac_sw_3_4.nooverlap_clk_0.x8.A single_9b_cdac_1.cdac_sw_9b_0.cdac_sw_3_4.nooverlap_clk_0.x4.A 0.0303f
C3750 sar9b_0.net28 sar9b_0.net9 0.02635f
C3751 VDPWR a_13968_22164# 0.29205f
C3752 single_9b_cdac_1.cdac_sw_9b_0.cdac_sw_3_6.nooverlap_clk_0.CLKB0 single_9b_cdac_1.cdac_sw_9b_0.cdac_sw_3_6.nooverlap_clk_0.sky130_fd_sc_hs__inv_8_0.A 0.6919f
C3753 single_9b_cdac_0.cdac_sw_9b_0.cdac_sw_3_7.nooverlap_clk_0.x3.Y single_9b_cdac_0.cdac_sw_9b_0.cdac_sw_3_7.nooverlap_clk_0.x4.A 0.07517f
C3754 a_6943_22316# sar9b_0.clk_div_0.COUNT\[2\] 0.12188f
C3755 sar9b_0.net40 sar9b_0.net7 0.04846f
C3756 a_13857_27279# sar9b_0.net14 0.04335f
C3757 a_13403_21076# sar9b_0.net6 0.01152f
C3758 a_13899_23252# a_12887_22714# 0.01008f
C3759 tdc_0.phase_detector_0.INP a_16222_11316# 0.02778f
C3760 ua[0] single_9b_cdac_1.cdac_sw_9b_0.cdac_sw_3_6.nooverlap_clk_0.CLK0 0.12077f
C3761 a_13403_19988# single_9b_cdac_1.SW[3] 0.01517f
C3762 single_9b_cdac_1.CF[8] single_9b_cdac_0.SW[3] 0.01976f
C3763 single_9b_cdac_0.SW[1] single_9b_cdac_0.cdac_sw_9b_0.cdac_sw_3_1.nooverlap_clk_0.CLK0 0.24288f
C3764 a_12480_18722# a_12225_18362# 0.05639f
C3765 VDPWR a_15265_9613# 0.18873f
C3766 a_5579_19676# a_5870_19566# 0.19685f
C3767 a_6726_27060# sar9b_0.FINAL 0.01664f
C3768 single_9b_cdac_1.SW[6] single_9b_cdac_1.CF[7] 0.01471f
C3769 sar9b_0.net15 a_9555_22530# 0.01277f
C3770 tdc_0.delay_gate_ori_1.sky130_fd_sc_hs__and2_1_0.A a_16357_9613# 0.16728f
C3771 sar9b_0.net27 a_13053_21076# 0.0378f
C3772 a_5969_25428# a_6884_25428# 0.12532f
C3773 sar9b_0.net2 sar9b_0.net9 0.27939f
C3774 a_8471_20538# a_9078_20506# 0.14145f
C3775 single_9b_cdac_1.cdac_sw_9b_0.cdac_sw_3_4.nooverlap_clk_0.CLK0 single_9b_cdac_1.cdac_sw_9b_0.cdac_sw_3_0.nooverlap_clk_0.CLK0 0.02513f
C3776 a_9281_26516# a_9536_26516# 0.06121f
C3777 sar9b_0._09_ a_6587_21852# 0.01152f
C3778 ua[0] single_9b_cdac_0.cdac_sw_9b_0.cdac_sw_3_6.nooverlap_clk_0.CLKB0 0.1236f
C3779 single_9b_cdac_1.CF[7] single_9b_cdac_1.cdac_sw_9b_0.cdac_sw_3_7.nooverlap_clk_0.x1.A 0.06503f
C3780 single_9b_cdac_0.cdac_sw_9b_0.cdac_sw_3_1.tg_sw_3_3.SWN single_9b_cdac_0.cdac_sw_9b_0.cdac_sw_3_1.tg_sw_3_3.SWP 3.10626f
C3781 dw_17224_1400# VDPWR 1.89835f
C3782 single_9b_cdac_0.cdac_sw_9b_0.cdac_sw_3_0.nooverlap_clk_0.x6.A single_9b_cdac_0.cdac_sw_9b_0.cdac_sw_3_0.nooverlap_clk_0.x1.A 0.03729f
C3783 sar9b_0.net26 single_9b_cdac_1.CF[2] 0.04035f
C3784 th_dif_sw_0.th_sw_0.th_sw_main_0.VGS VDPWR 0.17946f
C3785 a_10196_21076# sar9b_0.net41 0.02179f
C3786 a_14451_17812# VDPWR 0.24929f
C3787 single_9b_cdac_0.cdac_sw_9b_0.cdac_sw_3_4.nooverlap_clk_0.x4.A single_9b_cdac_1.CF[3] 0.0313f
C3788 sar9b_0.net2 a_11376_24162# 0.15761f
C3789 single_9b_cdac_1.CF[4] single_9b_cdac_1.SW[3] 0.0149f
C3790 single_9b_cdac_0.cdac_sw_9b_0.cdac_sw_3_8.nooverlap_clk_0.x8.A single_9b_cdac_0.cdac_sw_9b_0.cdac_sw_3_8.nooverlap_clk_0.x4.A 0.0303f
C3791 single_9b_cdac_0.SW[7] single_9b_cdac_0.SW[8] 4.04755f
C3792 sar9b_0.net3 sar9b_0._08_ 0.02031f
C3793 a_10827_19822# VDPWR 0.19763f
C3794 sar9b_0.net15 a_11287_22164# 0.1868f
C3795 VDPWR a_9205_23494# 0.21036f
C3796 single_9b_cdac_1.SW[1] single_9b_cdac_1.cdac_sw_9b_0.cdac_sw_3_1.nooverlap_clk_0.CLKB0 0.36334f
C3797 clk single_9b_cdac_1.SW[5] 0.0837f
C3798 sar9b_0.net37 sar9b_0.net3 0.13768f
C3799 single_9b_cdac_1.SW[3] sar9b_0.net39 0.04855f
C3800 single_9b_cdac_0.SW[3] single_9b_cdac_1.CF[6] 0.02012f
C3801 a_7919_23802# sar9b_0.clknet_0_CLK 0.01309f
C3802 a_11471_24174# sar9b_0.net13 0.03616f
C3803 clk single_9b_cdac_1.SW[3] 0.08974f
C3804 VDPWR a_13511_26882# 0.1421f
C3805 VDPWR single_9b_cdac_1.cdac_sw_9b_0.cdac_sw_3_2.nooverlap_clk_0.sky130_fd_sc_hs__nand2_1_0.Y 0.6205f
C3806 sar9b_0.net11 single_9b_cdac_1.CF[5] 0.04801f
C3807 a_13621_19418# a_13968_19822# 0.05116f
C3808 a_9738_20240# a_10142_20354# 0.05116f
C3809 a_6960_26338# sar9b_0.net38 0.1701f
C3810 single_9b_cdac_0.cdac_sw_9b_0.cdac_sw_3_7.nooverlap_clk_0.CLKB0 single_9b_cdac_0.cdac_sw_9b_0.cdac_sw_3_7.nooverlap_clk_0.CLK0 2.7611f
C3811 single_9b_cdac_0.cdac_sw_9b_0.cdac_sw_3_5.nooverlap_clk_0.x10.A single_9b_cdac_0.cdac_sw_9b_0.cdac_sw_3_5.tg_sw_3_3.SWN 0.69086f
C3812 single_9b_cdac_0.cdac_sw_9b_0.cdac_sw_3_0.nooverlap_clk_0.x6.A VDPWR 0.38397f
C3813 single_9b_cdac_1.SW[6] single_9b_cdac_1.SW[4] 0.05466f
C3814 a_12315_25972# a_12425_25946# 0.09774f
C3815 a_5969_25428# sar9b_0.FINAL 0.06497f
C3816 single_9b_cdac_1.SW[6] single_9b_cdac_1.SW[2] 0.21994f
C3817 sar9b_0.net36 sar9b_0.net35 0.59643f
C3818 a_12059_18362# VDPWR 0.45531f
C3819 single_9b_cdac_1.CF[1] th_dif_sw_0.VCN 0.09453f
C3820 uio_out[0] sar9b_0.net35 0.30395f
C3821 single_9b_cdac_1.cdac_sw_9b_0.cdac_sw_3_6.tg_sw_3_3.SWP single_9b_cdac_1.cdac_sw_9b_0.cdac_sw_3_6.nooverlap_clk_0.CLKB0 1.71649f
C3822 sar9b_0.net27 single_9b_cdac_1.CF[5] 0.12808f
C3823 a_13511_22708# VDPWR 0.1421f
C3824 single_9b_cdac_0.cdac_sw_9b_0.cdac_sw_3_1.nooverlap_clk_0.CLKB0 VDPWR 2.81428f
C3825 sar9b_0.net11 sar9b_0.net41 0.02123f
C3826 a_8545_25978# clk 0.02512f
C3827 sar9b_0.net15 a_12036_18900# 0.23045f
C3828 sar9b_0.net15 a_9252_22708# 0.0122f
C3829 ua[1] a_18214_3039# 0.12559f
C3830 sar9b_0.net3 a_9000_27438# 0.25578f
C3831 single_9b_cdac_1.CF[5] single_9b_cdac_0.cdac_sw_9b_0.cdac_sw_3_5.nooverlap_clk_0.x3.Y 0.12898f
C3832 single_9b_cdac_1.cdac_sw_9b_0.cdac_sw_3_1.nooverlap_clk_0.sky130_fd_sc_hs__nand2_1_0.Y VDPWR 0.62555f
C3833 single_9b_cdac_0.SW[2] single_9b_cdac_0.SW[5] 0.04746f
C3834 a_8931_22164# sar9b_0.net38 0.0361f
C3835 single_9b_cdac_0.SW[1] single_9b_cdac_0.SW[6] 0.03132f
C3836 single_9b_cdac_0.SW[1] sar9b_0.net31 0.03295f
C3837 a_34814_26990# single_9b_cdac_0.cdac_sw_9b_0.S[6] 0.22352f
C3838 single_9b_cdac_1.CF[8] single_9b_cdac_1.CF[2] 0.01481f
C3839 single_9b_cdac_1.CF[7] single_9b_cdac_0.SW[3] 0.02029f
C3840 a_6726_27060# VDPWR 0.07761f
C3841 single_9b_cdac_1.cdac_sw_9b_0.cdac_sw_3_5.tg_sw_3_3.SWP single_9b_cdac_1.CF[5] 0.10499f
C3842 single_9b_cdac_1.CF[0] single_9b_cdac_1.CF[1] 18.6907f
C3843 single_9b_cdac_0.cdac_sw_9b_0.cdac_sw_3_5.nooverlap_clk_0.x8.A single_9b_cdac_0.cdac_sw_9b_0.cdac_sw_3_5.nooverlap_clk_0.sky130_fd_sc_hs__inv_8_0.A 0.04988f
C3844 ua[0] single_9b_cdac_1.cdac_sw_9b_0.S[2] 1.21558f
C3845 single_9b_cdac_0.cdac_sw_9b_0.cdac_sw_3_0.nooverlap_clk_0.sky130_fd_sc_hs__inv_8_0.A single_9b_cdac_1.CF[2] 0.06019f
C3846 sar9b_0.FINAL a_5343_25972# 0.01104f
C3847 single_9b_cdac_1.cdac_sw_9b_0.cdac_sw_3_3.nooverlap_clk_0.x3.Y VDPWR 0.3196f
C3848 sar9b_0.net40 sar9b_0.net9 0.3307f
C3849 single_9b_cdac_1.SW[1] single_9b_cdac_1.cdac_sw_9b_0.cdac_sw_3_1.nooverlap_clk_0.CLK0 0.24311f
C3850 sar9b_0.net3 a_6007_27302# 0.66536f
C3851 a_5690_27192# a_5968_27176# 0.12532f
C3852 a_6525_22708# a_6610_22708# 0.03733f
C3853 a_5435_26516# a_6516_26516# 0.10236f
C3854 single_9b_cdac_0.cdac_sw_9b_0.cdac_sw_3_4.nooverlap_clk_0.CLK0 single_9b_cdac_0.cdac_sw_9b_0.cdac_sw_3_0.nooverlap_clk_0.CLK0 0.02513f
C3855 sar9b_0.net27 sar9b_0.net41 0.02857f
C3856 single_9b_cdac_0.SW[1] single_9b_cdac_0.SW[4] 0.01351f
C3857 single_9b_cdac_0.cdac_sw_9b_0.cdac_sw_3_2.nooverlap_clk_0.CLKB0 single_9b_cdac_0.cdac_sw_9b_0.cdac_sw_3_2.nooverlap_clk_0.CLK0 2.7611f
C3858 uio_out[0] a_6691_26490# 0.02453f
C3859 a_14175_23252# sar9b_0.net28 0.02345f
C3860 sar9b_0.net38 a_8951_22950# 0.03116f
C3861 sar9b_0.net15 a_14143_18874# 0.33283f
C3862 sar9b_0.net43 a_12425_25946# 0.03237f
C3863 VDPWR a_9774_19266# 0.21306f
C3864 a_9021_19418# sar9b_0.net15 0.2099f
C3865 sar9b_0.net15 sar9b_0._08_ 0.33232f
C3866 single_9b_cdac_0.cdac_sw_9b_0.cdac_sw_3_1.nooverlap_clk_0.x8.A single_9b_cdac_0.cdac_sw_9b_0.cdac_sw_3_1.nooverlap_clk_0.x10.A 0.42509f
C3867 a_15400_11316# VDPWR 0.52162f
C3868 a_11965_20506# sar9b_0.net15 0.16568f
C3869 single_9b_cdac_1.cdac_sw_9b_0.cdac_sw_3_5.nooverlap_clk_0.sky130_fd_sc_hs__inv_1_1.A single_9b_cdac_1.cdac_sw_9b_0.cdac_sw_3_5.nooverlap_clk_0.sky130_fd_sc_hs__nand2_1_0.Y 0.12223f
C3870 a_7813_22316# sar9b_0._12_ 0.14926f
C3871 a_13071_20532# sar9b_0.net38 0.0376f
C3872 sar9b_0.net37 sar9b_0.net15 0.47977f
C3873 sar9b_0._07_ sar9b_0._12_ 0.0299f
C3874 sar9b_0.net4 sar9b_0.net15 1.59354f
C3875 tdc_0.OUTN a_16159_13315# 0.01845f
C3876 single_9b_cdac_1.SW[8] sar9b_0.net5 0.23222f
C3877 single_9b_cdac_1.cdac_sw_9b_0.cdac_sw_3_5.nooverlap_clk_0.x8.A single_9b_cdac_1.cdac_sw_9b_0.cdac_sw_3_5.nooverlap_clk_0.sky130_fd_sc_hs__inv_1_1.A 0.08121f
C3878 single_9b_cdac_1.CF[6] single_9b_cdac_1.CF[2] 0.02299f
C3879 a_11471_18900# sar9b_0.net6 0.03542f
C3880 a_10771_22164# sar9b_0.net9 0.63977f
C3881 sar9b_0.net10 sar9b_0.net35 0.02845f
C3882 VDPWR a_6859_21710# 0.08511f
C3883 single_9b_cdac_0.cdac_sw_9b_0.cdac_sw_3_1.nooverlap_clk_0.x1.A VDPWR 0.75853f
C3884 single_9b_cdac_0.cdac_sw_9b_0.S[6] single_9b_cdac_0.cdac_sw_9b_0.cdac_sw_3_6.tg_sw_3_3.SWN 0.84424f
C3885 single_9b_cdac_0.cdac_sw_9b_0.cdac_sw_3_4.nooverlap_clk_0.x10.A single_9b_cdac_0.cdac_sw_9b_0.cdac_sw_3_4.tg_sw_3_3.SWN 0.69086f
C3886 a_8634_22840# a_9038_22708# 0.05116f
C3887 a_8951_22950# a_9107_22682# 0.10748f
C3888 single_9b_cdac_1.CF[4] single_9b_cdac_0.cdac_sw_9b_0.cdac_sw_3_3.nooverlap_clk_0.sky130_fd_sc_hs__inv_1_1.A 0.01887f
C3889 a_5711_21076# sar9b_0.net16 0.05713f
C3890 a_5483_19676# VDPWR 0.44007f
C3891 single_9b_cdac_0.cdac_sw_9b_0.cdac_sw_3_4.nooverlap_clk_0.x8.A single_9b_cdac_0.cdac_sw_9b_0.cdac_sw_3_4.nooverlap_clk_0.x10.A 0.42509f
C3892 a_11195_25428# VDPWR 0.20873f
C3893 a_5969_25428# VDPWR 0.62581f
C3894 VDPWR a_11100_25428# 0.084f
C3895 single_9b_cdac_1.cdac_sw_9b_0.cdac_sw_3_4.tg_sw_3_3.SWP VDPWR 3.27832f
C3896 a_24332_16877# m2_23774_17236# 0.01541f
C3897 a_8526_23770# a_8783_23796# 0.03684f
C3898 sar9b_0.net26 single_9b_cdac_1.CF[0] 0.04386f
C3899 a_10371_26490# sar9b_0.FINAL 0.09801f
C3900 a_14143_18874# a_13968_18900# 0.23366f
C3901 a_13403_18900# a_13308_18900# 0.04983f
C3902 single_9b_cdac_0.cdac_sw_9b_0.S[2] VDPWR 4.15039f
C3903 a_14451_25972# VDPWR 0.20996f
C3904 sar9b_0.clk_div_0.COUNT\[3\] sar9b_0.net35 0.03596f
C3905 a_14051_24100# a_13876_24174# 0.23366f
C3906 uo_out[5] uo_out[4] 3.05956f
C3907 a_6483_23618# VDPWR 0.18741f
C3908 a_6061_19988# sar9b_0._01_ 0.19891f
C3909 single_9b_cdac_0.cdac_sw_9b_0.cdac_sw_3_1.tg_sw_3_3.SWN single_9b_cdac_0.SW[1] 0.14962f
C3910 a_13857_27279# uo_out[1] 0.11019f
C3911 single_9b_cdac_1.SW[6] VDPWR 2.01416f
C3912 single_9b_cdac_0.cdac_sw_9b_0.cdac_sw_3_7.nooverlap_clk_0.sky130_fd_sc_hs__inv_1_1.A single_9b_cdac_0.cdac_sw_9b_0.cdac_sw_3_7.nooverlap_clk_0.x8.A 0.08121f
C3913 a_9021_19418# a_8803_19822# 0.20964f
C3914 a_8453_19450# a_9543_19748# 0.0421f
C3915 a_8287_19450# a_9368_19822# 0.10232f
C3916 single_9b_cdac_1.cdac_sw_9b_0.cdac_sw_3_7.nooverlap_clk_0.x6.A VDPWR 0.38397f
C3917 single_9b_cdac_1.CF[7] single_9b_cdac_1.CF[2] 0.02011f
C3918 single_9b_cdac_1.cdac_sw_9b_0.cdac_sw_3_7.nooverlap_clk_0.x1.A VDPWR 0.75853f
C3919 VDPWR a_5343_25972# 0.50855f
C3920 a_11397_20538# a_12487_20836# 0.04242f
C3921 a_11965_20506# a_11747_20910# 0.20964f
C3922 sar9b_0.net8 a_12312_20910# 0.04202f
C3923 a_8803_19822# sar9b_0.net4 0.03961f
C3924 sar9b_0.net27 a_12887_19988# 0.03173f
C3925 sar9b_0.net7 sar9b_0.net39 0.16757f
C3926 single_9b_cdac_0.cdac_sw_9b_0.cdac_sw_3_2.tg_sw_3_3.SWP single_9b_cdac_0.cdac_sw_9b_0.cdac_sw_3_2.nooverlap_clk_0.CLK0 0.19266f
C3927 sar9b_0.net41 sar9b_0.net42 0.26431f
C3928 sar9b_0.net20 a_8613_26681# 0.1969f
C3929 sar9b_0.net15 single_9b_cdac_1.SW[0] 0.37817f
C3930 single_9b_cdac_1.cdac_sw_9b_0.cdac_sw_3_6.nooverlap_clk_0.CLK0 single_9b_cdac_1.cdac_sw_9b_0.cdac_sw_3_7.nooverlap_clk_0.CLK0 0.02632f
C3931 a_9631_26516# a_9727_26516# 0.01379f
C3932 VDPWR a_14143_26490# 0.36889f
C3933 VDPWR a_12947_26276# 0.35612f
C3934 single_9b_cdac_1.CF[8] th_dif_sw_0.VCN 0.09453f
C3935 VDPWR single_9b_cdac_0.cdac_sw_9b_0.cdac_sw_3_1.nooverlap_clk_0.x3.Y 0.3196f
C3936 ua[0] single_9b_cdac_0.cdac_sw_9b_0.cdac_sw_3_4.tg_sw_3_3.SWN 3.1021f
C3937 a_12059_18362# sar9b_0.net36 0.12482f
C3938 single_9b_cdac_1.cdac_sw_9b_0.cdac_sw_3_1.nooverlap_clk_0.x3.Y single_9b_cdac_1.cdac_sw_9b_0.cdac_sw_3_1.nooverlap_clk_0.x1.A 0.07579f
C3939 a_10311_23252# sar9b_0.net12 0.86221f
C3940 tdc_0.delay_gate_ori_0.sky130_fd_sc_hs__and2_1_0.A clk 0.09625f
C3941 sar9b_0._04_ VDPWR 0.61061f
C3942 single_9b_cdac_1.cdac_sw_9b_0.cdac_sw_3_2.nooverlap_clk_0.CLK0 single_9b_cdac_1.cdac_sw_9b_0.S[0] 0.28813f
C3943 th_dif_sw_0.th_sw_1.th_sw_main_0.VGS VDPWR 0.17946f
C3944 VDPWR a_10937_22164# 0.37371f
C3945 a_14175_21620# sar9b_0.net9 0.07358f
C3946 single_9b_cdac_0.cdac_sw_9b_0.cdac_sw_3_8.nooverlap_clk_0.x8.A single_9b_cdac_0.cdac_sw_9b_0.cdac_sw_3_8.nooverlap_clk_0.x6.A 0.11216f
C3947 single_9b_cdac_1.cdac_sw_9b_0.cdac_sw_3_5.nooverlap_clk_0.sky130_fd_sc_hs__inv_8_0.A single_9b_cdac_1.CF[5] 0.06019f
C3948 a_13308_23074# a_12887_22714# 0.09313f
C3949 a_9460_24340# a_8379_24340# 0.10236f
C3950 single_9b_cdac_1.cdac_sw_9b_0.cdac_sw_3_7.nooverlap_clk_0.sky130_fd_sc_hs__inv_8_0.A single_9b_cdac_1.cdac_sw_9b_0.cdac_sw_3_7.nooverlap_clk_0.CLKB0 0.6919f
C3951 single_9b_cdac_1.cdac_sw_9b_0.cdac_sw_3_7.nooverlap_clk_0.x4.A single_9b_cdac_1.cdac_sw_9b_0.cdac_sw_3_7.nooverlap_clk_0.sky130_fd_sc_hs__nand2_1_0.Y 0.01751f
C3952 ua[0] single_9b_cdac_1.cdac_sw_9b_0.cdac_sw_3_4.nooverlap_clk_0.CLK0 0.12069f
C3953 single_9b_cdac_1.cdac_sw_9b_0.cdac_sw_3_4.nooverlap_clk_0.CLK0 a_49221_17740# 0.14695f
C3954 single_9b_cdac_0.cdac_sw_9b_0.cdac_sw_3_2.nooverlap_clk_0.CLK0 a_63626_26990# 0.14695f
C3955 VDPWR a_8634_22840# 0.29985f
C3956 a_14143_19962# single_9b_cdac_1.SW[4] 0.01601f
C3957 VDPWR a_12961_23802# 0.58172f
C3958 single_9b_cdac_1.CF[8] single_9b_cdac_1.CF[0] 0.01464f
C3959 sar9b_0.FINAL a_12036_26516# 0.03611f
C3960 a_14051_24100# sar9b_0.net13 0.01107f
C3961 single_9b_cdac_0.cdac_sw_9b_0.cdac_sw_3_1.nooverlap_clk_0.CLKB0 single_9b_cdac_0.cdac_sw_9b_0.cdac_sw_3_1.nooverlap_clk_0.CLK0 2.7611f
C3962 single_9b_cdac_1.cdac_sw_9b_0.cdac_sw_3_1.nooverlap_clk_0.x1.A VDPWR 0.75853f
C3963 single_9b_cdac_1.CF[7] single_9b_cdac_0.cdac_sw_9b_0.cdac_sw_3_7.nooverlap_clk_0.CLK0 0.42014f
C3964 sar9b_0.net15 a_14175_25972# 0.01321f
C3965 VDPWR single_9b_cdac_0.cdac_sw_9b_0.cdac_sw_3_8.nooverlap_clk_0.x4.A 0.62443f
C3966 a_6337_22714# sar9b_0.clknet_1_1__leaf_CLK 0.20539f
C3967 single_9b_cdac_0.cdac_sw_9b_0.cdac_sw_3_3.nooverlap_clk_0.sky130_fd_sc_hs__inv_8_0.A single_9b_cdac_0.cdac_sw_9b_0.cdac_sw_3_3.nooverlap_clk_0.CLKB0 0.6919f
C3968 sar9b_0.net15 a_13053_22164# 0.05959f
C3969 a_13053_22714# a_13403_23086# 0.2298f
C3970 single_9b_cdac_1.CF[1] single_9b_cdac_1.CF[3] 0.03758f
C3971 a_13621_25670# sar9b_0.net33 0.02356f
C3972 single_9b_cdac_1.cdac_sw_9b_0.cdac_sw_3_5.nooverlap_clk_0.CLK0 single_9b_cdac_1.cdac_sw_9b_0.S[5] 0.27713f
C3973 VDPWR a_12312_20910# 0.28123f
C3974 a_13623_21620# sar9b_0.net8 0.02758f
C3975 single_9b_cdac_1.SW[2] single_9b_cdac_1.CF[2] 1.79549f
C3976 single_9b_cdac_1.cdac_sw_9b_0.cdac_sw_3_4.tg_sw_3_3.SWP single_9b_cdac_1.cdac_sw_9b_0.cdac_sw_3_4.nooverlap_clk_0.CLKB0 1.71649f
C3977 tdc_0.OUTP th_dif_sw_0.CKB 0.2311f
C3978 single_9b_cdac_1.cdac_sw_9b_0.cdac_sw_3_5.nooverlap_clk_0.CLKB0 single_9b_cdac_1.cdac_sw_9b_0.S[5] 0.36037f
C3979 a_8987_23252# a_9095_23618# 0.05722f
C3980 sar9b_0.net7 a_12211_21050# 0.08714f
C3981 a_49221_26990# single_9b_cdac_0.cdac_sw_9b_0.S[3] 0.22497f
C3982 a_5785_23252# VDPWR 0.34739f
C3983 a_12887_25428# sar9b_0.FINAL 0.03164f
C3984 a_8471_20538# sar9b_0._05_ 0.07543f
C3985 a_8613_26681# sar9b_0.net35 0.04106f
C3986 single_9b_cdac_1.cdac_sw_9b_0.cdac_sw_3_3.tg_sw_3_3.SWN single_9b_cdac_1.cdac_sw_9b_0.cdac_sw_3_3.nooverlap_clk_0.x10.A 0.69086f
C3987 single_9b_cdac_1.cdac_sw_9b_0.cdac_sw_3_0.nooverlap_clk_0.CLKB0 single_9b_cdac_1.cdac_sw_9b_0.cdac_sw_3_1.nooverlap_clk_0.CLKB0 0.02778f
C3988 sar9b_0._14_ sar9b_0.clknet_0_CLK 0.44348f
C3989 VDPWR a_10371_26490# 0.36827f
C3990 single_9b_cdac_1.CF[6] th_dif_sw_0.VCN 0.09453f
C3991 uo_out[4] sar9b_0.net39 0.03466f
C3992 single_9b_cdac_1.SW[0] a_13968_18900# 0.01757f
C3993 sar9b_0.clk_div_0.COUNT\[1\] a_7919_23802# 0.08775f
C3994 a_11121_23802# a_12036_24174# 0.12532f
C3995 uo_out[4] clk 0.04574f
C3996 a_9648_19168# a_10406_19266# 0.06418f
C3997 single_9b_cdac_1.SW[7] sar9b_0.net28 0.01353f
C3998 single_9b_cdac_0.SW[3] VDPWR 2.35537f
C3999 a_13403_23086# sar9b_0.net39 0.01478f
C4000 single_9b_cdac_0.cdac_sw_9b_0.cdac_sw_3_5.nooverlap_clk_0.x8.A single_9b_cdac_0.cdac_sw_9b_0.cdac_sw_3_5.nooverlap_clk_0.sky130_fd_sc_hs__nand2_1_0.Y 0.26942f
C4001 sar9b_0.net42 a_11121_26516# 0.20846f
C4002 a_10955_26516# a_11689_26758# 0.05348f
C4003 a_10827_23252# a_10923_23252# 0.01379f
C4004 a_6907_19444# sar9b_0.clkload0.X 0.3277f
C4005 a_13407_24174# a_13311_24174# 0.01379f
C4006 sar9b_0.net15 a_12887_26516# 0.32712f
C4007 single_9b_cdac_1.CF[6] single_9b_cdac_1.CF[0] 0.02666f
C4008 uio_in[4] uio_in[3] 0.03102f
C4009 single_9b_cdac_1.CF[2] single_9b_cdac_1.cdac_sw_9b_0.cdac_sw_3_0.nooverlap_clk_0.sky130_fd_sc_hs__nand2_1_0.Y 0.17948f
C4010 a_13308_21076# a_13053_21076# 0.05936f
C4011 sar9b_0.net16 a_5393_17977# 0.22318f
C4012 a_14143_23012# a_12887_22714# 0.04357f
C4013 a_12487_20836# sar9b_0.net42 0.03732f
C4014 a_13053_22714# sar9b_0.net9 0.16184f
C4015 sar9b_0.net39 a_8085_27066# 0.73573f
C4016 a_7919_27066# a_8653_27034# 0.05348f
C4017 a_12887_21076# a_13053_21076# 0.90001f
C4018 a_14143_19748# sar9b_0.net15 0.29546f
C4019 a_5483_19676# sar9b_0.net36 0.03431f
C4020 single_9b_cdac_1.cdac_sw_9b_0.cdac_sw_3_3.nooverlap_clk_0.x8.A single_9b_cdac_1.cdac_sw_9b_0.cdac_sw_3_3.nooverlap_clk_0.x6.A 0.11216f
C4021 clk a_8085_27066# 0.03513f
C4022 a_9648_19168# sar9b_0.net5 0.01282f
C4023 single_9b_cdac_1.SW[8] m2_23774_17236# 0.02037f
C4024 a_14451_21620# VDPWR 0.21382f
C4025 single_9b_cdac_1.cdac_sw_9b_0.cdac_sw_3_3.nooverlap_clk_0.x8.A single_9b_cdac_1.cdac_sw_9b_0.cdac_sw_3_3.nooverlap_clk_0.x1.A 0.42784f
C4026 single_9b_cdac_1.cdac_sw_9b_0.cdac_sw_3_6.nooverlap_clk_0.CLKB0 single_9b_cdac_1.CF[6] 0.26707f
C4027 a_13623_21620# VDPWR 0.19211f
C4028 ua[0] single_9b_cdac_1.cdac_sw_9b_0.cdac_sw_3_5.tg_sw_3_3.SWP 1.15121f
C4029 single_9b_cdac_1.CF[7] th_dif_sw_0.VCN 0.09453f
C4030 a_21684_3438# VDPWR 0.07087f
C4031 a_14451_27060# VDPWR 0.21159f
C4032 sar9b_0.net8 single_9b_cdac_1.CF[2] 0.06631f
C4033 a_12225_18362# a_13140_18734# 0.11842f
C4034 single_9b_cdac_1.cdac_sw_9b_0.cdac_sw_3_1.nooverlap_clk_0.x4.A single_9b_cdac_1.cdac_sw_9b_0.cdac_sw_3_1.nooverlap_clk_0.x8.A 0.0303f
C4035 a_7363_23502# VDPWR 0.27673f
C4036 a_6343_20354# sar9b_0.net37 0.03583f
C4037 sar9b_0.net26 single_9b_cdac_1.CF[3] 0.04274f
C4038 single_9b_cdac_0.cdac_sw_9b_0.cdac_sw_3_0.nooverlap_clk_0.x1.A single_9b_cdac_1.CF[2] 0.06503f
C4039 sar9b_0.net39 sar9b_0.net9 0.36163f
C4040 a_6007_27302# a_5968_27176# 0.87824f
C4041 VDPWR a_12036_26516# 0.302f
C4042 a_53154_26999# VDPWR 1.81495f
C4043 VDPWR single_9b_cdac_1.cdac_sw_9b_0.cdac_sw_3_0.nooverlap_clk_0.x6.A 0.38397f
C4044 single_9b_cdac_1.CF[7] single_9b_cdac_1.CF[0] 0.02356f
C4045 a_10016_20256# sar9b_0.net8 0.17054f
C4046 VDPWR w_12795_1601# 0.45037f
C4047 single_9b_cdac_1.cdac_sw_9b_0.cdac_sw_3_8.nooverlap_clk_0.x8.A single_9b_cdac_1.cdac_sw_9b_0.cdac_sw_3_8.nooverlap_clk_0.sky130_fd_sc_hs__nand2_1_0.Y 0.26942f
C4048 a_9460_24340# sar9b_0.net38 0.01998f
C4049 single_9b_cdac_0.cdac_sw_9b_0.S[2] single_9b_cdac_0.cdac_sw_9b_0.S[3] 16.8814f
C4050 sar9b_0.net36 a_5343_25972# 0.0285f
C4051 single_9b_cdac_0.cdac_sw_9b_0.cdac_sw_3_6.nooverlap_clk_0.x10.A single_9b_cdac_0.cdac_sw_9b_0.cdac_sw_3_6.nooverlap_clk_0.sky130_fd_sc_hs__inv_8_0.A 0.05105f
C4052 a_12887_24890# a_13621_24858# 0.07009f
C4053 a_13621_24858# a_13968_25262# 0.05116f
C4054 a_11471_26516# a_11567_26516# 0.01379f
C4055 a_12112_26338# a_12207_26350# 0.04983f
C4056 a_8379_25978# a_9635_26276# 0.04357f
C4057 sar9b_0.net40 a_8895_26350# 0.03363f
C4058 a_5870_19566# sar9b_0.clknet_1_0__leaf_CLK 0.01218f
C4059 single_9b_cdac_1.cdac_sw_9b_0.cdac_sw_3_0.nooverlap_clk_0.x4.A a_54737_15495# 0.01076f
C4060 VDPWR a_14143_19962# 0.35288f
C4061 single_9b_cdac_1.cdac_sw_9b_0.cdac_sw_3_4.nooverlap_clk_0.sky130_fd_sc_hs__inv_8_0.A single_9b_cdac_1.CF[3] 0.06019f
C4062 VDPWR a_12887_25428# 0.45394f
C4063 sar9b_0.net11 a_8471_23252# 0.42306f
C4064 single_9b_cdac_1.cdac_sw_9b_0.cdac_sw_3_8.tg_sw_3_3.SWN single_9b_cdac_1.cdac_sw_9b_0.cdac_sw_3_8.nooverlap_clk_0.CLKB0 0.22879f
C4065 single_9b_cdac_1.cdac_sw_9b_0.S[2] single_9b_cdac_1.cdac_sw_9b_0.S[3] 16.8814f
C4066 a_7620_26350# a_6705_25978# 0.12532f
C4067 sar9b_0.net15 single_9b_cdac_0.SW[7] 0.06816f
C4068 sar9b_0.net37 sar9b_0.net1 0.16329f
C4069 single_9b_cdac_1.cdac_sw_9b_0.S[4] single_9b_cdac_1.cdac_sw_9b_0.S[2] 0.27936f
C4070 a_7795_26276# sar9b_0.net3 0.29201f
C4071 single_9b_cdac_0.cdac_sw_9b_0.cdac_sw_3_5.nooverlap_clk_0.sky130_fd_sc_hs__inv_1_1.A single_9b_cdac_1.CF[5] 0.01887f
C4072 single_9b_cdac_0.cdac_sw_9b_0.cdac_sw_3_5.tg_sw_3_3.SWP single_9b_cdac_1.CF[5] 0.10499f
C4073 th_dif_sw_0.VCP a_21177_7457# 0.0867f
C4074 single_9b_cdac_1.cdac_sw_9b_0.cdac_sw_3_1.tg_sw_3_3.SWN VDPWR 2.82181f
C4075 VDPWR single_9b_cdac_1.CF[2] 2.32234f
C4076 a_10827_23252# VDPWR 0.22267f
C4077 a_6943_22316# a_7039_22138# 0.20109f
C4078 a_13623_23252# sar9b_0.net13 0.03894f
C4079 single_9b_cdac_1.cdac_sw_9b_0.S[4] a_43540_16877# 0.59531f
C4080 single_9b_cdac_1.SW[4] th_dif_sw_0.VCN 0.09453f
C4081 a_13899_24340# sar9b_0.net11 0.01712f
C4082 single_9b_cdac_1.SW[2] th_dif_sw_0.VCN 0.09469f
C4083 single_9b_cdac_1.SW[6] single_9b_cdac_1.cdac_sw_9b_0.S[6] 0.22497f
C4084 single_9b_cdac_1.CF[8] single_9b_cdac_1.cdac_sw_9b_0.cdac_sw_3_8.nooverlap_clk_0.CLKB0 0.26707f
C4085 single_9b_cdac_0.cdac_sw_9b_0.S[2] single_9b_cdac_0.cdac_sw_9b_0.S[5] 0.24472f
C4086 ua[0] single_9b_cdac_0.SW[8] 0.20384f
C4087 single_9b_cdac_0.SW[0] a_62748_26999# 0.28324f
C4088 single_9b_cdac_1.cdac_sw_9b_0.cdac_sw_3_1.nooverlap_clk_0.CLKB0 single_9b_cdac_1.cdac_sw_9b_0.cdac_sw_3_1.nooverlap_clk_0.CLK0 2.7611f
C4089 a_13308_22164# sar9b_0.net9 0.02067f
C4090 a_53154_16877# single_9b_cdac_1.SW[2] 0.28324f
C4091 a_10016_20256# VDPWR 0.2566f
C4092 single_9b_cdac_1.CF[8] single_9b_cdac_1.CF[3] 0.01497f
C4093 single_9b_cdac_1.SW[7] single_9b_cdac_1.cdac_sw_9b_0.cdac_sw_3_7.tg_sw_3_3.SWN 0.14951f
C4094 single_9b_cdac_1.SW[4] single_9b_cdac_1.CF[0] 0.45283f
C4095 sar9b_0.net28 sar9b_0.net12 0.0194f
C4096 single_9b_cdac_0.SW[0] single_9b_cdac_0.SW[7] 0.01225f
C4097 sar9b_0.net27 a_13899_24340# 0.2114f
C4098 single_9b_cdac_1.SW[2] single_9b_cdac_1.CF[0] 0.34049f
C4099 sar9b_0.net26 a_14175_24340# 0.03582f
C4100 single_9b_cdac_0.cdac_sw_9b_0.cdac_sw_3_1.nooverlap_clk_0.sky130_fd_sc_hs__inv_1_1.A single_9b_cdac_0.cdac_sw_9b_0.cdac_sw_3_1.nooverlap_clk_0.x1.A 0.10429f
C4101 single_9b_cdac_1.CF[7] single_9b_cdac_0.cdac_sw_9b_0.S[6] 0.0174f
C4102 a_5785_23252# sar9b_0.net36 0.01068f
C4103 sar9b_0.net37 sar9b_0._02_ 0.03634f
C4104 a_11121_21076# sar9b_0.net42 0.03128f
C4105 single_9b_cdac_1.SW[1] single_9b_cdac_1.SW[5] 0.21765f
C4106 sar9b_0.net38 a_9552_23252# 0.01346f
C4107 a_5711_21076# VDPWR 0.01823f
C4108 sar9b_0.net26 a_14451_24340# 0.04257f
C4109 single_9b_cdac_1.SW[1] single_9b_cdac_1.SW[3] 0.21902f
C4110 a_10311_19450# sar9b_0.net5 0.75705f
C4111 a_13511_21442# sar9b_0.net15 0.0122f
C4112 sar9b_0.net28 a_13968_23086# 0.02839f
C4113 single_9b_cdac_1.cdac_sw_9b_0.cdac_sw_3_1.nooverlap_clk_0.sky130_fd_sc_hs__inv_8_0.A single_9b_cdac_1.CF[1] 0.06019f
C4114 VDPWR single_9b_cdac_1.cdac_sw_9b_0.S[1] 4.14969f
C4115 VDPWR single_9b_cdac_0.cdac_sw_9b_0.cdac_sw_3_7.nooverlap_clk_0.CLK0 2.71729f
C4116 a_9097_22164# a_9665_22406# 0.17799f
C4117 a_8931_22164# a_9447_22164# 0.11208f
C4118 single_9b_cdac_1.cdac_sw_9b_0.cdac_sw_3_4.nooverlap_clk_0.sky130_fd_sc_hs__inv_1_1.A VDPWR 0.38702f
C4119 single_9b_cdac_1.cdac_sw_9b_0.cdac_sw_3_6.nooverlap_clk_0.x6.A single_9b_cdac_1.cdac_sw_9b_0.cdac_sw_3_6.nooverlap_clk_0.x4.A 0.12431f
C4120 single_9b_cdac_0.cdac_sw_9b_0.cdac_sw_3_1.tg_sw_3_3.SWN single_9b_cdac_0.cdac_sw_9b_0.cdac_sw_3_1.nooverlap_clk_0.CLKB0 0.22875f
C4121 a_10311_23252# a_10732_23252# 0.08341f
C4122 a_65367_15501# single_9b_cdac_1.cdac_sw_9b_0.cdac_sw_3_2.nooverlap_clk_0.sky130_fd_sc_hs__nand2_1_0.Y 0.01076f
C4123 sar9b_0.net15 a_13053_21076# 0.05805f
C4124 a_11231_20538# sar9b_0.net2 0.03496f
C4125 sar9b_0.net2 sar9b_0.net12 0.10353f
C4126 single_9b_cdac_1.cdac_sw_9b_0.cdac_sw_3_6.nooverlap_clk_0.x1.A single_9b_cdac_1.cdac_sw_9b_0.cdac_sw_3_6.nooverlap_clk_0.x4.A 0.28523f
C4127 sar9b_0.net31 a_14451_25972# 0.03808f
C4128 a_14175_25972# sar9b_0.net30 0.03063f
C4129 single_9b_cdac_1.cdac_sw_9b_0.cdac_sw_3_2.nooverlap_clk_0.x1.A single_9b_cdac_1.cdac_sw_9b_0.cdac_sw_3_2.nooverlap_clk_0.x6.A 0.03729f
C4130 sar9b_0.clk_div_0.COUNT\[2\] a_7039_22138# 0.03204f
C4131 sar9b_0.net37 a_10356_20354# 0.02624f
C4132 single_9b_cdac_0.cdac_sw_9b_0.cdac_sw_3_7.nooverlap_clk_0.sky130_fd_sc_hs__inv_1_1.A single_9b_cdac_0.cdac_sw_9b_0.cdac_sw_3_7.nooverlap_clk_0.x1.A 0.10429f
C4133 a_6061_19988# a_6930_20241# 0.03024f
C4134 a_6502_20124# a_6343_20354# 0.24864f
C4135 single_9b_cdac_1.CF[4] single_9b_cdac_0.cdac_sw_9b_0.cdac_sw_3_3.nooverlap_clk_0.x4.A 0.0313f
C4136 a_5895_19988# a_6759_20354# 0.03628f
C4137 single_9b_cdac_1.SW[8] single_9b_cdac_1.SW[5] 0.06724f
C4138 single_9b_cdac_1.SW[8] single_9b_cdac_1.SW[3] 0.07708f
C4139 VDPWR w_17430_1606# 0.44324f
C4140 a_13053_22164# a_13621_22406# 0.18639f
C4141 sar9b_0.net3 sar9b_0.net41 0.1588f
C4142 VDPWR single_9b_cdac_0.cdac_sw_9b_0.cdac_sw_3_5.nooverlap_clk_0.CLK0 2.71729f
C4143 VDPWR single_9b_cdac_0.cdac_sw_9b_0.cdac_sw_3_8.nooverlap_clk_0.x6.A 0.38397f
C4144 single_9b_cdac_1.cdac_sw_9b_0.cdac_sw_3_3.nooverlap_clk_0.x4.A single_9b_cdac_1.cdac_sw_9b_0.cdac_sw_3_3.nooverlap_clk_0.x6.A 0.12431f
C4145 a_11471_18900# a_11579_19266# 0.05722f
C4146 single_9b_cdac_1.CF[6] single_9b_cdac_1.CF[3] 0.02099f
C4147 single_9b_cdac_1.cdac_sw_9b_0.S[8] th_dif_sw_0.VCP 0.82395f
C4148 single_9b_cdac_0.SW[3] single_9b_cdac_0.cdac_sw_9b_0.S[3] 0.22939f
C4149 single_9b_cdac_1.CF[0] single_9b_cdac_1.cdac_sw_9b_0.cdac_sw_3_2.nooverlap_clk_0.x3.Y 0.12898f
C4150 a_14451_25972# single_9b_cdac_0.SW[4] 0.11003f
C4151 single_9b_cdac_1.cdac_sw_9b_0.cdac_sw_3_3.nooverlap_clk_0.x4.A single_9b_cdac_1.cdac_sw_9b_0.cdac_sw_3_3.nooverlap_clk_0.x1.A 0.28523f
C4152 single_9b_cdac_1.cdac_sw_9b_0.cdac_sw_3_2.nooverlap_clk_0.CLK0 single_9b_cdac_1.cdac_sw_9b_0.cdac_sw_3_2.tg_sw_3_3.SWN 0.17533f
C4153 sar9b_0.net10 a_10937_22164# 0.03792f
C4154 single_9b_cdac_0.cdac_sw_9b_0.cdac_sw_3_4.tg_sw_3_3.SWP single_9b_cdac_0.cdac_sw_9b_0.cdac_sw_3_0.tg_sw_3_3.SWP 0.02545f
C4155 a_9115_21076# sar9b_0.net38 0.04219f
C4156 VDPWR a_7325_26681# 0.23495f
C4157 sar9b_0._03_ a_8085_23802# 0.21151f
C4158 a_8379_24340# sar9b_0.net38 0.03061f
C4159 a_6778_22682# a_6610_22708# 0.23992f
C4160 a_9635_24314# VDPWR 0.38552f
C4161 a_9281_26516# sar9b_0.FINAL 0.02812f
C4162 a_12036_21076# VDPWR 0.32062f
C4163 sar9b_0.net17 a_5435_26516# 0.03317f
C4164 sar9b_0.net8 single_9b_cdac_1.CF[0] 0.07386f
C4165 a_10311_19450# sar9b_0.net38 0.17427f
C4166 ua[0] single_9b_cdac_1.cdac_sw_9b_0.cdac_sw_3_8.nooverlap_clk_0.CLK0 0.14027f
C4167 sar9b_0._06_ sar9b_0.clknet_0_CLK 0.01059f
C4168 single_9b_cdac_1.cdac_sw_9b_0.cdac_sw_3_4.nooverlap_clk_0.x6.A single_9b_cdac_1.cdac_sw_9b_0.cdac_sw_3_4.nooverlap_clk_0.x4.A 0.12431f
C4169 sar9b_0._13_ sar9b_0.net37 0.07873f
C4170 a_9370_19152# VDPWR 0.30174f
C4171 a_10055_20130# a_10142_20354# 0.07009f
C4172 single_9b_cdac_1.cdac_sw_9b_0.cdac_sw_3_4.nooverlap_clk_0.x1.A single_9b_cdac_1.cdac_sw_9b_0.cdac_sw_3_4.nooverlap_clk_0.x4.A 0.28523f
C4173 VDPWR a_13511_22530# 0.1421f
C4174 a_11121_23802# a_11376_24162# 0.06418f
C4175 sar9b_0.net1 a_13053_22164# 0.23439f
C4176 uo_out[0] uio_in[7] 0.03102f
C4177 a_11649_27279# VDPWR 0.26904f
C4178 sar9b_0._14_ sar9b_0.clk_div_0.COUNT\[1\] 0.03298f
C4179 clk a_14897_9355# 0.02917f
C4180 single_9b_cdac_0.cdac_sw_9b_0.cdac_sw_3_3.nooverlap_clk_0.x1.A single_9b_cdac_0.cdac_sw_9b_0.cdac_sw_3_3.nooverlap_clk_0.x3.Y 0.07579f
C4181 single_9b_cdac_1.cdac_sw_9b_0.cdac_sw_3_5.tg_sw_3_3.SWP a_38738_16877# 0.04592f
C4182 a_12887_21076# a_13347_21620# 0.01023f
C4183 a_13621_19418# a_13511_19444# 0.09774f
C4184 single_9b_cdac_1.cdac_sw_9b_0.cdac_sw_3_4.nooverlap_clk_0.CLK0 single_9b_cdac_1.cdac_sw_9b_0.S[3] 0.28575f
C4185 a_12480_18722# a_12575_18734# 0.04983f
C4186 VDPWR th_dif_sw_0.VCN 1.99513f
C4187 a_8340_27426# sar9b_0.FINAL 0.01889f
C4188 a_5863_19662# a_6070_19721# 0.27314f
C4189 a_5579_19676# a_5999_19822# 0.03684f
C4190 single_9b_cdac_1.CF[7] single_9b_cdac_1.CF[3] 0.02349f
C4191 a_8085_23802# sar9b_0.net35 0.01652f
C4192 single_9b_cdac_0.cdac_sw_9b_0.cdac_sw_3_0.nooverlap_clk_0.CLK0 a_54032_26990# 0.14695f
C4193 sar9b_0.net15 single_9b_cdac_1.CF[5] 0.16625f
C4194 a_5969_25428# a_6427_25794# 0.03462f
C4195 single_9b_cdac_0.cdac_sw_9b_0.cdac_sw_3_7.nooverlap_clk_0.CLKB0 single_9b_cdac_0.cdac_sw_9b_0.cdac_sw_3_6.tg_sw_3_3.SWN 0.01152f
C4196 single_9b_cdac_1.cdac_sw_9b_0.cdac_sw_3_6.nooverlap_clk_0.x10.A single_9b_cdac_1.cdac_sw_9b_0.cdac_sw_3_6.tg_sw_3_3.SWN 0.69086f
C4197 a_8471_20538# a_9503_20506# 0.04875f
C4198 a_8637_20538# a_8910_20532# 0.0802f
C4199 a_9115_26516# sar9b_0.net41 0.57956f
C4200 sar9b_0._09_ sar9b_0._08_ 0.54728f
C4201 a_53154_16877# VDPWR 1.81495f
C4202 sar9b_0.net4 a_10679_25428# 0.26301f
C4203 a_21177_7457# th_dif_sw_0.th_sw_1.CKB 2.27999f
C4204 sar9b_0.net3 a_11121_26516# 0.58185f
C4205 a_11287_22164# a_11192_22164# 0.04983f
C4206 a_12027_22138# a_11852_22164# 0.23366f
C4207 a_12887_26516# sar9b_0.net1 0.1736f
C4208 VDPWR single_9b_cdac_1.CF[0] 2.54546f
C4209 sar9b_0.net37 sar9b_0._09_ 0.02778f
C4210 single_9b_cdac_1.cdac_sw_9b_0.cdac_sw_3_6.nooverlap_clk_0.sky130_fd_sc_hs__inv_8_0.A single_9b_cdac_1.CF[6] 0.06019f
C4211 a_14871_9671# VDPWR 0.67026f
C4212 single_9b_cdac_0.cdac_sw_9b_0.cdac_sw_3_4.nooverlap_clk_0.CLKB0 VDPWR 2.81423f
C4213 tdc_0.delay_gate_ori_1.sky130_fd_sc_hs__and2_1_0.A a_16331_9671# 0.18915f
C4214 sar9b_0.net40 sar9b_0.net12 0.6995f
C4215 sar9b_0.net38 sar9b_0.net5 0.70516f
C4216 sar9b_0.net15 sar9b_0.net41 0.68666f
C4217 a_10955_23802# sar9b_0.net42 0.04133f
C4218 a_9417_23074# a_9107_22682# 0.01379f
C4219 a_9670_22708# a_8912_22824# 0.06418f
C4220 single_9b_cdac_0.SW[3] single_9b_cdac_0.SW[6] 0.026f
C4221 sar9b_0.net31 single_9b_cdac_0.SW[3] 0.11754f
C4222 sar9b_0.net26 single_9b_cdac_1.CF[1] 0.04386f
C4223 sar9b_0.net15 a_11852_22164# 0.22217f
C4224 sar9b_0.net40 a_8800_26338# 0.17009f
C4225 single_9b_cdac_1.cdac_sw_9b_0.cdac_sw_3_8.nooverlap_clk_0.x3.Y single_9b_cdac_1.cdac_sw_9b_0.cdac_sw_3_8.nooverlap_clk_0.x1.A 0.07579f
C4226 VDPWR a_9727_23226# 0.35173f
C4227 a_8379_24340# a_8800_24340# 0.08968f
C4228 single_9b_cdac_0.cdac_sw_9b_0.cdac_sw_3_5.nooverlap_clk_0.x1.A single_9b_cdac_1.CF[5] 0.06503f
C4229 tdc_0.phase_detector_0.INN a_15400_11316# 0.02778f
C4230 single_9b_cdac_0.SW[0] single_9b_cdac_1.CF[5] 0.61075f
C4231 single_9b_cdac_0.cdac_sw_9b_0.cdac_sw_3_1.nooverlap_clk_0.x4.A single_9b_cdac_1.CF[1] 0.0313f
C4232 single_9b_cdac_1.cdac_sw_9b_0.cdac_sw_3_6.nooverlap_clk_0.CLKB0 VDPWR 2.81428f
C4233 VDPWR a_11689_23770# 0.25048f
C4234 a_12036_24174# sar9b_0.net13 0.04739f
C4235 a_14143_19748# a_13968_19822# 0.23366f
C4236 a_13403_21076# sar9b_0.net39 0.04574f
C4237 single_9b_cdac_0.SW[3] single_9b_cdac_0.SW[4] 12.2625f
C4238 single_9b_cdac_0.SW[7] sar9b_0.net30 0.04486f
C4239 single_9b_cdac_1.cdac_sw_9b_0.cdac_sw_3_0.nooverlap_clk_0.sky130_fd_sc_hs__nand2_1_0.Y a_55773_15501# 0.01076f
C4240 single_9b_cdac_0.cdac_sw_9b_0.S[4] single_9b_cdac_0.cdac_sw_9b_0.cdac_sw_3_3.tg_sw_3_3.SWP 1.55985f
C4241 single_9b_cdac_0.cdac_sw_9b_0.cdac_sw_3_0.tg_sw_3_3.SWN single_9b_cdac_0.cdac_sw_9b_0.cdac_sw_3_0.nooverlap_clk_0.CLK0 0.17533f
C4242 a_5393_17977# VDPWR 0.28054f
C4243 VDPWR a_9281_26516# 0.57526f
C4244 single_9b_cdac_1.SW[2] single_9b_cdac_1.CF[3] 0.01297f
C4245 single_9b_cdac_1.cdac_sw_9b_0.cdac_sw_3_3.nooverlap_clk_0.x8.A VDPWR 0.84059f
C4246 a_6319_25428# sar9b_0.FINAL 0.01605f
C4247 a_12793_18330# VDPWR 0.20768f
C4248 uo_out[2] VDPWR 0.63635f
C4249 VDPWR a_57946_16877# 1.81495f
C4250 a_6219_22316# VDPWR 0.20865f
C4251 single_9b_cdac_1.cdac_sw_9b_0.cdac_sw_3_2.nooverlap_clk_0.x4.A single_9b_cdac_1.cdac_sw_9b_0.cdac_sw_3_2.nooverlap_clk_0.sky130_fd_sc_hs__nand2_1_0.Y 0.01751f
C4252 a_8895_26350# clk 0.01558f
C4253 single_9b_cdac_1.cdac_sw_9b_0.cdac_sw_3_8.nooverlap_clk_0.CLKB0 single_9b_cdac_1.cdac_sw_9b_0.cdac_sw_3_8.nooverlap_clk_0.sky130_fd_sc_hs__inv_8_0.A 0.6919f
C4254 a_12795_23802# sar9b_0.net12 0.02667f
C4255 single_9b_cdac_0.cdac_sw_9b_0.cdac_sw_3_3.tg_sw_3_3.SWP a_43540_26999# 0.04592f
C4256 ua[0] single_9b_cdac_0.cdac_sw_9b_0.cdac_sw_3_5.tg_sw_3_3.SWP 1.15122f
C4257 single_9b_cdac_0.cdac_sw_9b_0.S[6] VDPWR 4.16175f
C4258 a_8340_27426# VDPWR 0.07683f
C4259 single_9b_cdac_0.cdac_sw_9b_0.cdac_sw_3_5.nooverlap_clk_0.sky130_fd_sc_hs__nand2_1_0.Y a_41357_29911# 0.01076f
C4260 sar9b_0.net8 a_13071_21620# 0.03125f
C4261 sar9b_0.FINAL a_6539_25978# 0.27244f
C4262 ua[0] single_9b_cdac_1.cdac_sw_9b_0.S[8] 16.4165f
C4263 sar9b_0.net3 a_6163_27034# 0.17613f
C4264 a_5690_27192# a_6094_27060# 0.05116f
C4265 sar9b_0.net7 single_9b_cdac_1.SW[8] 0.02379f
C4266 single_9b_cdac_0.cdac_sw_9b_0.cdac_sw_3_4.nooverlap_clk_0.CLK0 single_9b_cdac_0.cdac_sw_9b_0.cdac_sw_3_4.tg_sw_3_3.SWP 0.19266f
C4267 a_10845_25428# sar9b_0.net42 0.04271f
C4268 a_10311_19450# a_11567_19748# 0.04357f
C4269 single_9b_cdac_1.CF[8] single_9b_cdac_1.CF[1] 0.0147f
C4270 uio_out[0] a_7325_26681# 0.10944f
C4271 a_5619_23252# sar9b_0._02_ 0.0828f
C4272 single_9b_cdac_0.cdac_sw_9b_0.cdac_sw_3_0.nooverlap_clk_0.x8.A single_9b_cdac_0.cdac_sw_9b_0.cdac_sw_3_0.nooverlap_clk_0.x10.A 0.42509f
C4273 a_11471_21076# a_11567_21076# 0.01379f
C4274 sar9b_0.net38 a_9107_22682# 0.02262f
C4275 VDPWR a_9988_19266# 0.14212f
C4276 single_9b_cdac_1.cdac_sw_9b_0.cdac_sw_3_6.tg_sw_3_3.SWP single_9b_cdac_1.CF[6] 0.10499f
C4277 sar9b_0.FINAL sar9b_0.net33 0.23339f
C4278 a_6943_22316# VDPWR 0.2287f
C4279 single_9b_cdac_1.SW[6] a_14451_20532# 0.12781f
C4280 a_8895_26350# a_8991_26350# 0.01379f
C4281 a_9543_19748# sar9b_0.net15 0.33717f
C4282 a_15151_10456# VDPWR 0.3789f
C4283 single_9b_cdac_1.cdac_sw_9b_0.S[6] single_9b_cdac_1.cdac_sw_9b_0.S[1] 0.26325f
C4284 single_9b_cdac_1.SW[7] clk 0.08259f
C4285 a_12487_20836# sar9b_0.net15 0.26758f
C4286 single_9b_cdac_1.SW[0] single_9b_cdac_1.cdac_sw_9b_0.cdac_sw_3_5.tg_sw_3_3.SWN 0.12586f
C4287 a_16527_10454# tdc_0.delay_gate_ori_1.sky130_fd_sc_hs__and2_1_0.A 0.09051f
C4288 sar9b_0.net15 a_12887_19988# 0.30401f
C4289 single_9b_cdac_1.cdac_sw_9b_0.cdac_sw_3_5.nooverlap_clk_0.x10.A single_9b_cdac_1.cdac_sw_9b_0.cdac_sw_3_5.nooverlap_clk_0.x8.A 0.42509f
C4290 a_62748_26999# single_9b_cdac_0.cdac_sw_9b_0.cdac_sw_3_2.nooverlap_clk_0.CLKB0 0.23864f
C4291 sar9b_0._11_ sar9b_0.clknet_0_CLK 0.24918f
C4292 single_9b_cdac_0.cdac_sw_9b_0.cdac_sw_3_2.nooverlap_clk_0.x1.A single_9b_cdac_0.cdac_sw_9b_0.cdac_sw_3_2.nooverlap_clk_0.x10.A 0.05472f
C4293 a_13347_20532# single_9b_cdac_1.SW[2] 0.13524f
C4294 tdc_0.OUTN tdc_0.phase_detector_0.pd_out_0.B 0.19342f
C4295 single_9b_cdac_1.cdac_sw_9b_0.cdac_sw_3_5.nooverlap_clk_0.x1.A single_9b_cdac_1.cdac_sw_9b_0.cdac_sw_3_5.nooverlap_clk_0.sky130_fd_sc_hs__inv_1_1.A 0.10429f
C4296 sar9b_0.net3 a_6169_26758# 0.167f
C4297 a_10732_23252# sar9b_0.net2 0.18195f
C4298 a_12036_18900# sar9b_0.net6 0.07061f
C4299 a_11505_22406# sar9b_0.net9 0.04307f
C4300 a_44418_17740# single_9b_cdac_1.SW[4] 0.18991f
C4301 sar9b_0.net3 a_6149_23770# 0.03689f
C4302 single_9b_cdac_0.cdac_sw_9b_0.cdac_sw_3_6.tg_sw_3_3.SWN single_9b_cdac_1.CF[6] 0.12358f
C4303 single_9b_cdac_0.cdac_sw_9b_0.cdac_sw_3_5.tg_sw_3_3.SWN single_9b_cdac_0.cdac_sw_9b_0.cdac_sw_3_5.nooverlap_clk_0.CLK0 0.17533f
C4304 VDPWR a_13071_21620# 0.25778f
C4305 a_8912_22824# a_9038_22708# 0.18639f
C4306 a_14143_25402# sar9b_0.net15 0.27757f
C4307 a_13899_21620# sar9b_0.net27 0.01477f
C4308 single_9b_cdac_0.cdac_sw_9b_0.S[5] single_9b_cdac_0.cdac_sw_9b_0.cdac_sw_3_5.nooverlap_clk_0.CLK0 0.27713f
C4309 sar9b_0.clk_div_0.COUNT\[0\] a_7817_23252# 0.07771f
C4310 a_5863_19662# VDPWR 0.67103f
C4311 a_11760_25428# VDPWR 0.33456f
C4312 single_9b_cdac_0.cdac_sw_9b_0.cdac_sw_3_4.nooverlap_clk_0.x4.A VDPWR 0.62443f
C4313 single_9b_cdac_1.CF[6] single_9b_cdac_1.CF[1] 0.02011f
C4314 a_13053_21076# sar9b_0.net1 0.23227f
C4315 a_6319_25428# VDPWR 0.21465f
C4316 a_8637_20538# VDPWR 0.30676f
C4317 single_9b_cdac_1.cdac_sw_9b_0.cdac_sw_3_1.nooverlap_clk_0.x4.A single_9b_cdac_1.cdac_sw_9b_0.cdac_sw_3_1.nooverlap_clk_0.sky130_fd_sc_hs__nand2_1_0.Y 0.01751f
C4318 single_9b_cdac_1.cdac_sw_9b_0.cdac_sw_3_8.nooverlap_clk_0.CLKB0 VDPWR 2.81428f
C4319 a_10732_19810# a_10827_19822# 0.04983f
C4320 a_8951_23770# a_8783_23796# 0.31086f
C4321 single_9b_cdac_1.CF[7] single_9b_cdac_1.cdac_sw_9b_0.cdac_sw_3_6.tg_sw_3_3.SWP 0.19147f
C4322 a_9536_26516# sar9b_0.FINAL 0.0253f
C4323 single_9b_cdac_0.cdac_sw_9b_0.S[3] th_dif_sw_0.VCN 27.329f
C4324 a_11567_19748# sar9b_0.net5 0.05868f
C4325 single_9b_cdac_0.cdac_sw_9b_0.cdac_sw_3_5.nooverlap_clk_0.CLKB0 single_9b_cdac_0.cdac_sw_9b_0.cdac_sw_3_3.tg_sw_3_3.SWN 0.01152f
C4326 sar9b_0._14_ sar9b_0._12_ 0.03509f
C4327 single_9b_cdac_0.cdac_sw_9b_0.cdac_sw_3_5.nooverlap_clk_0.x4.A single_9b_cdac_0.cdac_sw_9b_0.cdac_sw_3_5.nooverlap_clk_0.sky130_fd_sc_hs__nand2_1_0.Y 0.01751f
C4328 sar9b_0.net27 single_9b_cdac_0.SW[1] 0.05832f
C4329 VDPWR single_9b_cdac_1.CF[3] 2.36597f
C4330 sar9b_0.clk_div_0.COUNT\[2\] VDPWR 0.55819f
C4331 sar9b_0.net26 single_9b_cdac_1.CF[8] 0.0374f
C4332 a_30717_29917# single_9b_cdac_0.cdac_sw_9b_0.cdac_sw_3_7.nooverlap_clk_0.x4.A 0.01076f
C4333 single_9b_cdac_1.cdac_sw_9b_0.cdac_sw_3_3.tg_sw_3_3.SWN single_9b_cdac_1.cdac_sw_9b_0.cdac_sw_3_3.tg_sw_3_3.SWP 3.10626f
C4334 a_10955_21076# sar9b_0.net9 0.39216f
C4335 a_9021_19418# a_9368_19822# 0.05116f
C4336 single_9b_cdac_0.cdac_sw_9b_0.cdac_sw_3_7.nooverlap_clk_0.CLK0 single_9b_cdac_0.SW[6] 0.0187f
C4337 single_9b_cdac_1.cdac_sw_9b_0.cdac_sw_3_0.tg_sw_3_3.SWP single_9b_cdac_1.SW[0] 0.08409f
C4338 sar9b_0.net30 single_9b_cdac_1.CF[5] 0.0213f
C4339 single_9b_cdac_1.cdac_sw_9b_0.cdac_sw_3_7.nooverlap_clk_0.CLK0 single_9b_cdac_1.cdac_sw_9b_0.cdac_sw_3_8.nooverlap_clk_0.CLK0 0.02632f
C4340 sar9b_0.net37 sar9b_0.net6 0.26172f
C4341 single_9b_cdac_0.cdac_sw_9b_0.cdac_sw_3_4.nooverlap_clk_0.CLKB0 single_9b_cdac_0.cdac_sw_9b_0.S[3] 0.36041f
C4342 VDPWR a_6539_25978# 0.43381f
C4343 a_13968_21076# sar9b_0.net28 0.03921f
C4344 single_9b_cdac_1.CF[7] single_9b_cdac_0.cdac_sw_9b_0.cdac_sw_3_6.tg_sw_3_3.SWN 0.03488f
C4345 a_9368_19822# sar9b_0.net4 0.06574f
C4346 sar9b_0.net24 a_12211_26490# 0.06111f
C4347 sar9b_0.net11 sar9b_0._03_ 0.06526f
C4348 single_9b_cdac_1.cdac_sw_9b_0.cdac_sw_3_8.nooverlap_clk_0.CLK0 a_25210_17740# 0.14695f
C4349 single_9b_cdac_1.cdac_sw_9b_0.cdac_sw_3_3.nooverlap_clk_0.x4.A VDPWR 0.62443f
C4350 sar9b_0.net37 a_13053_19988# 0.54884f
C4351 single_9b_cdac_0.cdac_sw_9b_0.S[5] th_dif_sw_0.VCN 6.18357f
C4352 single_9b_cdac_0.cdac_sw_9b_0.cdac_sw_3_7.nooverlap_clk_0.CLK0 single_9b_cdac_0.cdac_sw_9b_0.cdac_sw_3_7.tg_sw_3_3.SWP 0.19266f
C4353 single_9b_cdac_1.CF[7] single_9b_cdac_1.CF[1] 0.01994f
C4354 a_9097_22164# VDPWR 0.5528f
C4355 VDPWR sar9b_0.net33 1.00605f
C4356 single_9b_cdac_0.cdac_sw_9b_0.cdac_sw_3_2.tg_sw_3_3.SWN single_9b_cdac_0.cdac_sw_9b_0.cdac_sw_3_2.nooverlap_clk_0.CLK0 0.17533f
C4357 a_5856_26516# a_5435_26516# 0.09016f
C4358 a_11567_19748# sar9b_0.net38 0.0644f
C4359 a_12793_18330# sar9b_0.net36 0.02199f
C4360 single_9b_cdac_1.cdac_sw_9b_0.cdac_sw_3_3.tg_sw_3_3.SWN single_9b_cdac_1.cdac_sw_9b_0.cdac_sw_3_4.tg_sw_3_3.SWN 0.02624f
C4361 a_12887_26516# a_13053_26516# 0.90645f
C4362 a_11045_23494# sar9b_0.net12 0.04306f
C4363 uo_out[4] ui_in[0] 0.06786f
C4364 ua[0] single_9b_cdac_0.cdac_sw_9b_0.cdac_sw_3_0.tg_sw_3_3.SWP 1.15133f
C4365 sar9b_0.clknet_1_1__leaf_CLK a_7919_23802# 0.22627f
C4366 single_9b_cdac_1.SW[6] single_9b_cdac_1.cdac_sw_9b_0.cdac_sw_3_6.nooverlap_clk_0.CLK0 0.24288f
C4367 a_14175_27060# sar9b_0.net34 0.03419f
C4368 single_9b_cdac_0.cdac_sw_9b_0.cdac_sw_3_1.tg_sw_3_3.SWN single_9b_cdac_1.CF[2] 0.03547f
C4369 single_9b_cdac_1.SW[8] sar9b_0.net9 0.03092f
C4370 single_9b_cdac_1.CF[8] single_9b_cdac_1.cdac_sw_9b_0.cdac_sw_3_8.tg_sw_3_3.SWN 0.12358f
C4371 VDPWR a_29134_16877# 1.81495f
C4372 single_9b_cdac_0.cdac_sw_9b_0.cdac_sw_3_2.tg_sw_3_3.SWP a_62748_26999# 0.04592f
C4373 sar9b_0.net26 single_9b_cdac_1.CF[6] 0.03677f
C4374 sar9b_0.net37 a_6631_24590# 0.01123f
C4375 VDPWR a_8912_22824# 0.58078f
C4376 VDPWR a_13311_24174# 0.20392f
C4377 sar9b_0.net40 a_10732_23252# 0.0123f
C4378 sar9b_0.net11 sar9b_0.net35 0.28161f
C4379 sar9b_0.net15 a_11121_21076# 0.09139f
C4380 single_9b_cdac_1.cdac_sw_9b_0.cdac_sw_3_6.nooverlap_clk_0.CLKB0 single_9b_cdac_1.cdac_sw_9b_0.S[6] 0.36006f
C4381 a_14451_18356# VDPWR 0.21373f
C4382 single_9b_cdac_1.cdac_sw_9b_0.cdac_sw_3_0.nooverlap_clk_0.x8.A single_9b_cdac_1.cdac_sw_9b_0.cdac_sw_3_0.nooverlap_clk_0.sky130_fd_sc_hs__inv_1_1.A 0.08121f
C4383 sar9b_0.net40 a_10311_24890# 0.04015f
C4384 a_6930_20241# sar9b_0.net15 0.40555f
C4385 single_9b_cdac_1.SW[0] single_9b_cdac_1.cdac_sw_9b_0.cdac_sw_3_1.tg_sw_3_3.SWP 0.08409f
C4386 single_9b_cdac_1.CF[8] single_9b_cdac_0.cdac_sw_9b_0.cdac_sw_3_8.nooverlap_clk_0.x3.Y 0.12898f
C4387 sar9b_0.net15 a_13403_22164# 0.16757f
C4388 a_13053_22714# a_13968_23086# 0.12532f
C4389 single_9b_cdac_1.cdac_sw_9b_0.cdac_sw_3_6.nooverlap_clk_0.sky130_fd_sc_hs__inv_8_0.A VDPWR 0.96907f
C4390 VDPWR a_13347_20532# 0.18735f
C4391 sar9b_0.net12 sar9b_0.net39 0.93344f
C4392 VDPWR a_8273_23796# 0.07579f
C4393 sar9b_0.net11 sar9b_0.clk_div_0.COUNT\[0\] 0.05655f
C4394 a_11376_24162# sar9b_0.net13 0.02533f
C4395 single_9b_cdac_0.SW[6] th_dif_sw_0.VCN 0.09469f
C4396 a_14175_24340# VDPWR 0.19604f
C4397 a_8453_19450# sar9b_0.net35 0.03254f
C4398 single_9b_cdac_1.CF[7] single_9b_cdac_0.cdac_sw_9b_0.cdac_sw_3_7.nooverlap_clk_0.CLKB0 0.26707f
C4399 ua[0] single_9b_cdac_0.SW[0] 0.15351f
C4400 single_9b_cdac_0.cdac_sw_9b_0.cdac_sw_3_3.nooverlap_clk_0.CLK0 single_9b_cdac_0.cdac_sw_9b_0.cdac_sw_3_5.nooverlap_clk_0.CLK0 0.02632f
C4401 a_6058_23618# VDPWR 0.27739f
C4402 single_9b_cdac_0.cdac_sw_9b_0.S[6] single_9b_cdac_0.cdac_sw_9b_0.S[3] 0.61733f
C4403 sar9b_0.net41 sar9b_0.net1 0.07922f
C4404 VDPWR a_9536_26516# 0.08228f
C4405 sar9b_0.clk_div_0.COUNT\[1\] a_8526_23770# 0.03782f
C4406 single_9b_cdac_0.SW[1] single_9b_cdac_0.SW[8] 0.01285f
C4407 single_9b_cdac_1.cdac_sw_9b_0.cdac_sw_3_4.nooverlap_clk_0.CLKB0 single_9b_cdac_1.CF[3] 0.26707f
C4408 single_9b_cdac_0.SW[4] th_dif_sw_0.VCN 0.09453f
C4409 VDPWR a_14451_24340# 0.21396f
C4410 sar9b_0.net24 sar9b_0.net39 0.13821f
C4411 sar9b_0.net27 a_12887_22714# 0.02948f
C4412 single_9b_cdac_1.cdac_sw_9b_0.cdac_sw_3_3.nooverlap_clk_0.CLKB0 single_9b_cdac_1.cdac_sw_9b_0.cdac_sw_3_3.nooverlap_clk_0.CLK0 2.7611f
C4413 a_10955_26516# a_12211_26490# 0.04357f
C4414 sar9b_0.net26 single_9b_cdac_1.CF[7] 0.03655f
C4415 single_9b_cdac_1.cdac_sw_9b_0.cdac_sw_3_6.nooverlap_clk_0.x3.Y single_9b_cdac_1.cdac_sw_9b_0.cdac_sw_3_6.nooverlap_clk_0.x1.A 0.07579f
C4416 single_9b_cdac_1.SW[3] sar9b_0.net5 0.03165f
C4417 a_8287_19450# a_8708_19810# 0.09016f
C4418 single_9b_cdac_1.cdac_sw_9b_0.cdac_sw_3_5.nooverlap_clk_0.CLKB0 single_9b_cdac_1.cdac_sw_9b_0.cdac_sw_3_3.nooverlap_clk_0.CLKB0 0.02632f
C4419 a_11747_20910# a_11843_20910# 0.01379f
C4420 a_14143_19962# a_14451_20532# 0.01215f
C4421 tdc_0.RDY tdc_0.OUTP 1.39109f
C4422 single_9b_cdac_1.cdac_sw_9b_0.cdac_sw_3_7.tg_sw_3_3.SWN single_9b_cdac_1.cdac_sw_9b_0.S[7] 0.84426f
C4423 single_9b_cdac_0.cdac_sw_9b_0.S[6] single_9b_cdac_0.cdac_sw_9b_0.S[5] 18.1238f
C4424 a_7919_27066# a_9175_27364# 0.04357f
C4425 sar9b_0.net39 a_8435_27438# 0.03391f
C4426 single_9b_cdac_1.CF[8] single_9b_cdac_1.CF[6] 0.02271f
C4427 a_6525_22708# sar9b_0.clk_div_0.COUNT\[0\] 0.01771f
C4428 single_9b_cdac_1.cdac_sw_9b_0.cdac_sw_3_3.nooverlap_clk_0.x1.A single_9b_cdac_1.cdac_sw_9b_0.cdac_sw_3_3.nooverlap_clk_0.x6.A 0.03729f
C4429 sar9b_0.net15 a_8471_23252# 0.29788f
C4430 sar9b_0.net4 a_8545_24340# 0.02913f
C4431 a_29134_26999# single_9b_cdac_0.cdac_sw_9b_0.S[7] 0.59531f
C4432 single_9b_cdac_1.CF[8] single_9b_cdac_0.cdac_sw_9b_0.cdac_sw_3_8.nooverlap_clk_0.x8.A 0.31534f
C4433 m2_23774_26966# VDPWR 0.19016f
C4434 a_10477_23252# sar9b_0.net42 0.18404f
C4435 single_9b_cdac_1.cdac_sw_9b_0.cdac_sw_3_1.nooverlap_clk_0.x4.A single_9b_cdac_1.cdac_sw_9b_0.cdac_sw_3_1.nooverlap_clk_0.x1.A 0.28523f
C4436 single_9b_cdac_0.cdac_sw_9b_0.cdac_sw_3_6.nooverlap_clk_0.sky130_fd_sc_hs__inv_1_1.A single_9b_cdac_1.CF[6] 0.01887f
C4437 a_6759_20354# sar9b_0.net37 0.03217f
C4438 sar9b_0.net27 a_13968_22164# 0.01378f
C4439 a_6674_21050# VDPWR 0.2029f
C4440 single_9b_cdac_1.cdac_sw_9b_0.S[0] a_62748_16877# 0.59531f
C4441 a_6007_27302# a_6094_27060# 0.07009f
C4442 a_5968_27176# a_6163_27034# 0.21772f
C4443 a_13053_24890# VDPWR 0.30418f
C4444 VDPWR a_11579_26882# 0.13542f
C4445 VDPWR a_10732_25250# 0.07851f
C4446 single_9b_cdac_1.cdac_sw_9b_0.cdac_sw_3_2.nooverlap_clk_0.x8.A single_9b_cdac_1.cdac_sw_9b_0.cdac_sw_3_2.nooverlap_clk_0.sky130_fd_sc_hs__nand2_1_0.Y 0.26942f
C4447 a_6679_22316# sar9b_0._07_ 0.11229f
C4448 sar9b_0.net8 single_9b_cdac_1.CF[1] 0.03972f
C4449 single_9b_cdac_1.cdac_sw_9b_0.cdac_sw_3_4.nooverlap_clk_0.x4.A single_9b_cdac_1.cdac_sw_9b_0.cdac_sw_3_4.nooverlap_clk_0.x3.Y 0.07517f
C4450 single_9b_cdac_1.cdac_sw_9b_0.S[8] a_25210_17740# 0.22352f
C4451 a_9115_21076# a_9849_21318# 0.05348f
C4452 sar9b_0.net2 a_11287_22164# 0.01044f
C4453 single_9b_cdac_1.cdac_sw_9b_0.cdac_sw_3_8.nooverlap_clk_0.x1.A single_9b_cdac_1.cdac_sw_9b_0.cdac_sw_3_8.nooverlap_clk_0.sky130_fd_sc_hs__nand2_1_0.Y 0.01003f
C4454 sar9b_0._10_ sar9b_0.clk_div_0.COUNT\[0\] 0.07783f
C4455 sar9b_0.net26 single_9b_cdac_1.SW[4] 0.04178f
C4456 single_9b_cdac_0.cdac_sw_9b_0.cdac_sw_3_6.nooverlap_clk_0.x3.Y single_9b_cdac_0.cdac_sw_9b_0.cdac_sw_3_6.nooverlap_clk_0.x4.A 0.07517f
C4457 a_12887_24890# a_14143_25188# 0.04357f
C4458 a_12683_18356# sar9b_0.net35 0.02644f
C4459 a_13053_24890# a_13403_25262# 0.21663f
C4460 single_9b_cdac_1.cdac_sw_9b_0.cdac_sw_3_6.tg_sw_3_3.SWP VDPWR 3.27833f
C4461 a_14143_25188# a_13968_25262# 0.23366f
C4462 sar9b_0.net26 single_9b_cdac_1.SW[2] 0.05758f
C4463 single_9b_cdac_0.cdac_sw_9b_0.S[6] single_9b_cdac_0.SW[6] 0.22497f
C4464 sar9b_0.net40 a_9460_26350# 0.05679f
C4465 single_9b_cdac_0.cdac_sw_9b_0.S[8] a_25210_26990# 0.22352f
C4466 single_9b_cdac_1.cdac_sw_9b_0.cdac_sw_3_1.nooverlap_clk_0.sky130_fd_sc_hs__inv_8_0.A VDPWR 0.96907f
C4467 single_9b_cdac_1.CF[7] single_9b_cdac_1.CF[8] 3.70925f
C4468 VDPWR a_13308_19988# 0.07761f
C4469 VDPWR a_13621_25670# 0.2031f
C4470 a_7795_26276# a_7620_26350# 0.23366f
C4471 sar9b_0.clk_div_0.COUNT\[1\] sar9b_0._11_ 0.77731f
C4472 a_10311_19450# a_11045_19418# 0.05348f
C4473 a_12887_19988# sar9b_0.net1 0.18652f
C4474 sar9b_0.net15 a_10955_23802# 0.32815f
C4475 single_9b_cdac_1.cdac_sw_9b_0.S[3] single_9b_cdac_1.cdac_sw_9b_0.S[8] 0.31498f
C4476 single_9b_cdac_1.cdac_sw_9b_0.cdac_sw_3_1.nooverlap_clk_0.x3.Y single_9b_cdac_1.CF[1] 0.12898f
C4477 a_8545_25978# sar9b_0.net38 0.06809f
C4478 a_8379_25978# sar9b_0.net3 0.29528f
C4479 single_9b_cdac_1.cdac_sw_9b_0.S[4] single_9b_cdac_1.cdac_sw_9b_0.S[8] 1.41363f
C4480 single_9b_cdac_0.SW[3] sar9b_0.net32 0.01124f
C4481 a_6943_22316# sar9b_0.clk_div_0.COUNT\[3\] 0.03929f
C4482 a_13899_24340# single_9b_cdac_0.SW[0] 0.11579f
C4483 single_9b_cdac_1.cdac_sw_9b_0.cdac_sw_3_0.tg_sw_3_3.SWN single_9b_cdac_1.SW[0] 0.12586f
C4484 a_5973_23252# a_5785_23252# 0.09503f
C4485 ua[0] single_9b_cdac_0.cdac_sw_9b_0.cdac_sw_3_4.nooverlap_clk_0.CLK0 0.12069f
C4486 a_11392_23252# VDPWR 0.29446f
C4487 a_14175_23252# sar9b_0.net13 0.07356f
C4488 sar9b_0._06_ sar9b_0._12_ 0.4929f
C4489 a_11691_25978# a_12425_25946# 0.06225f
C4490 VDPWR single_9b_cdac_0.cdac_sw_9b_0.cdac_sw_3_6.tg_sw_3_3.SWN 2.82223f
C4491 single_9b_cdac_0.cdac_sw_9b_0.cdac_sw_3_8.nooverlap_clk_0.CLK0 a_25210_26990# 0.14695f
C4492 sar9b_0.net2 a_12036_18900# 0.01391f
C4493 a_13623_20532# single_9b_cdac_1.SW[3] 0.12687f
C4494 single_9b_cdac_0.cdac_sw_9b_0.cdac_sw_3_4.nooverlap_clk_0.x4.A single_9b_cdac_0.cdac_sw_9b_0.cdac_sw_3_4.nooverlap_clk_0.x1.A 0.28523f
C4495 sar9b_0.net15 a_9687_19042# 0.54121f
C4496 a_14451_18356# sar9b_0.net36 0.20303f
C4497 VDPWR single_9b_cdac_1.CF[1] 2.36034f
C4498 single_9b_cdac_1.cdac_sw_9b_0.S[1] a_58824_17740# 0.22352f
C4499 a_13403_19988# a_13499_19988# 0.01379f
C4500 a_10211_20225# VDPWR 0.19978f
C4501 sar9b_0.net3 a_12425_25946# 0.1702f
C4502 single_9b_cdac_1.cdac_sw_9b_0.cdac_sw_3_4.tg_sw_3_3.SWN single_9b_cdac_1.SW[3] 0.14997f
C4503 ua[0] single_9b_cdac_0.cdac_sw_9b_0.cdac_sw_3_6.tg_sw_3_3.SWP 1.15122f
C4504 single_9b_cdac_0.cdac_sw_9b_0.cdac_sw_3_2.nooverlap_clk_0.x4.A single_9b_cdac_1.CF[0] 0.0313f
C4505 single_9b_cdac_1.CF[7] single_9b_cdac_1.CF[6] 5.87613f
C4506 single_9b_cdac_0.cdac_sw_9b_0.cdac_sw_3_4.nooverlap_clk_0.x1.A single_9b_cdac_1.CF[3] 0.06503f
C4507 ua[2] th_dif_sw_0.th_sw_1.CK 0.42268f
C4508 a_5601_26516# a_6169_26758# 0.17402f
C4509 single_9b_cdac_1.cdac_sw_9b_0.cdac_sw_3_2.nooverlap_clk_0.CLK0 single_9b_cdac_1.SW[0] 0.24456f
C4510 a_11471_21076# sar9b_0.net42 0.01726f
C4511 a_9447_22164# sar9b_0.net38 0.01778f
C4512 a_8637_20538# sar9b_0.clk_div_0.COUNT\[3\] 0.17621f
C4513 sar9b_0.net3 a_7035_22708# 0.01542f
C4514 single_9b_cdac_1.cdac_sw_9b_0.cdac_sw_3_5.tg_sw_3_3.SWN single_9b_cdac_1.CF[5] 0.12358f
C4515 a_8895_24340# a_8991_24340# 0.01379f
C4516 a_11045_19418# sar9b_0.net5 0.04657f
C4517 single_9b_cdac_0.cdac_sw_9b_0.S[4] single_9b_cdac_0.cdac_sw_9b_0.cdac_sw_3_3.tg_sw_3_3.SWN 0.84427f
C4518 a_12887_22164# a_13053_22164# 0.82606f
C4519 single_9b_cdac_1.cdac_sw_9b_0.cdac_sw_3_7.nooverlap_clk_0.CLK0 a_30012_17740# 0.14695f
C4520 single_9b_cdac_0.cdac_sw_9b_0.cdac_sw_3_8.tg_sw_3_3.SWN single_9b_cdac_0.cdac_sw_9b_0.cdac_sw_3_8.nooverlap_clk_0.CLKB0 0.22875f
C4521 a_8931_22164# a_10012_22164# 0.10232f
C4522 a_9097_22164# a_10187_22138# 0.0421f
C4523 a_10477_23252# a_10935_23618# 0.03441f
C4524 sar9b_0.clk_div_0.COUNT\[2\] sar9b_0.clk_div_0.COUNT\[3\] 0.14806f
C4525 a_10845_25428# sar9b_0.net15 0.03707f
C4526 a_9097_22164# sar9b_0.net10 0.4769f
C4527 single_9b_cdac_1.cdac_sw_9b_0.cdac_sw_3_8.nooverlap_clk_0.x4.A a_25915_15495# 0.01076f
C4528 a_12937_27279# uo_out[2] 0.11004f
C4529 sar9b_0.net37 sar9b_0.net2 0.04465f
C4530 a_6502_20124# a_6759_20354# 0.03548f
C4531 single_9b_cdac_0.cdac_sw_9b_0.cdac_sw_3_1.tg_sw_3_3.SWP single_9b_cdac_0.cdac_sw_9b_0.cdac_sw_3_0.tg_sw_3_3.SWP 0.02813f
C4532 sar9b_0.net4 sar9b_0.net2 0.75071f
C4533 single_9b_cdac_0.cdac_sw_9b_0.cdac_sw_3_7.nooverlap_clk_0.CLKB0 VDPWR 2.81428f
C4534 a_13053_22164# a_14143_22138# 0.04242f
C4535 a_13621_22406# a_13403_22164# 0.20964f
C4536 sar9b_0.net7 sar9b_0.net5 0.09697f
C4537 a_14143_21050# a_14451_21620# 0.01215f
C4538 a_13403_21076# single_9b_cdac_1.SW[8] 0.01076f
C4539 sar9b_0.net3 a_9849_26758# 0.16277f
C4540 a_11121_18900# sar9b_0.net5 0.01391f
C4541 sar9b_0._14_ a_7345_21594# 0.0347f
C4542 single_9b_cdac_1.cdac_sw_9b_0.cdac_sw_3_4.nooverlap_clk_0.CLK0 single_9b_cdac_1.cdac_sw_9b_0.cdac_sw_3_4.tg_sw_3_3.SWP 0.19266f
C4543 single_9b_cdac_1.CF[8] single_9b_cdac_1.cdac_sw_9b_0.cdac_sw_3_8.nooverlap_clk_0.sky130_fd_sc_hs__inv_8_0.A 0.06019f
C4544 a_12887_25428# sar9b_0.net32 0.02731f
C4545 a_10477_24890# a_10827_25262# 0.21686f
C4546 single_9b_cdac_1.cdac_sw_9b_0.cdac_sw_3_5.tg_sw_3_3.SWN single_9b_cdac_1.cdac_sw_9b_0.cdac_sw_3_6.tg_sw_3_3.SWN 0.02638f
C4547 single_9b_cdac_1.CF[0] single_9b_cdac_1.cdac_sw_9b_0.cdac_sw_3_2.nooverlap_clk_0.x10.A 0.02149f
C4548 sar9b_0.net10 a_8912_22824# 0.28376f
C4549 a_6778_22682# a_7035_22708# 0.03684f
C4550 sar9b_0.net26 VDPWR 1.21324f
C4551 a_11579_21442# VDPWR 0.14595f
C4552 single_9b_cdac_1.CF[6] single_9b_cdac_1.SW[4] 0.01482f
C4553 a_11045_19418# sar9b_0.net38 0.02188f
C4554 single_9b_cdac_0.cdac_sw_9b_0.cdac_sw_3_1.nooverlap_clk_0.x4.A VDPWR 0.62443f
C4555 single_9b_cdac_1.CF[6] single_9b_cdac_1.SW[2] 0.01297f
C4556 single_9b_cdac_0.SW[6] sar9b_0.net33 0.0432f
C4557 sar9b_0.net31 sar9b_0.net33 0.0258f
C4558 single_9b_cdac_1.cdac_sw_9b_0.cdac_sw_3_0.tg_sw_3_3.SWP single_9b_cdac_1.cdac_sw_9b_0.cdac_sw_3_0.nooverlap_clk_0.CLK0 0.19266f
C4559 a_11471_24174# a_11376_24162# 0.04983f
C4560 a_11287_22164# a_10771_22164# 0.10419f
C4561 ui_in[6] ui_in[5] 0.03102f
C4562 single_9b_cdac_0.cdac_sw_9b_0.cdac_sw_3_2.nooverlap_clk_0.x8.A single_9b_cdac_0.cdac_sw_9b_0.cdac_sw_3_2.nooverlap_clk_0.x10.A 0.42509f
C4563 sar9b_0.net15 a_13621_26758# 0.18311f
C4564 single_9b_cdac_1.cdac_sw_9b_0.cdac_sw_3_7.nooverlap_clk_0.x10.A single_9b_cdac_1.cdac_sw_9b_0.cdac_sw_3_7.tg_sw_3_3.SWN 0.69086f
C4565 single_9b_cdac_0.SW[4] sar9b_0.net33 0.03798f
C4566 sar9b_0.net7 sar9b_0.net38 0.02293f
C4567 a_13053_21076# sar9b_0.net6 0.03161f
C4568 single_9b_cdac_1.cdac_sw_9b_0.cdac_sw_3_4.nooverlap_clk_0.sky130_fd_sc_hs__inv_8_0.A VDPWR 0.96841f
C4569 a_5863_19662# a_6907_19444# 0.08622f
C4570 a_6308_27060# sar9b_0.FINAL 0.02688f
C4571 a_5870_19566# a_5999_19822# 0.12729f
C4572 single_9b_cdac_0.cdac_sw_9b_0.cdac_sw_3_0.nooverlap_clk_0.sky130_fd_sc_hs__inv_8_0.A single_9b_cdac_0.cdac_sw_9b_0.cdac_sw_3_0.nooverlap_clk_0.x1.A 0.45521f
C4573 single_9b_cdac_1.SW[7] single_9b_cdac_1.SW[1] 0.21975f
C4574 a_6319_25428# a_6427_25794# 0.05722f
C4575 single_9b_cdac_0.cdac_sw_9b_0.cdac_sw_3_2.nooverlap_clk_0.sky130_fd_sc_hs__inv_1_1.A single_9b_cdac_1.CF[0] 0.01887f
C4576 a_8637_20538# a_9335_20532# 0.19497f
C4577 ua[0] single_9b_cdac_0.cdac_sw_9b_0.cdac_sw_3_2.nooverlap_clk_0.CLKB0 0.11944f
C4578 a_5803_25428# a_5969_25428# 0.76686f
C4579 single_9b_cdac_1.cdac_sw_9b_0.cdac_sw_3_8.tg_sw_3_3.SWN VDPWR 2.81718f
C4580 a_9115_26516# a_9849_26758# 0.05338f
C4581 a_36555_29911# single_9b_cdac_0.cdac_sw_9b_0.cdac_sw_3_6.nooverlap_clk_0.sky130_fd_sc_hs__nand2_1_0.Y 0.01076f
C4582 sar9b_0.net3 a_11471_26516# 0.18344f
C4583 single_9b_cdac_1.CF[7] single_9b_cdac_1.SW[4] 0.01482f
C4584 single_9b_cdac_1.CF[7] single_9b_cdac_1.SW[2] 0.01297f
C4585 single_9b_cdac_1.CF[8] single_9b_cdac_0.cdac_sw_9b_0.cdac_sw_3_8.nooverlap_clk_0.x10.A 0.02149f
C4586 single_9b_cdac_1.SW[7] single_9b_cdac_1.SW[8] 3.74293f
C4587 a_9281_21076# sar9b_0.net8 0.73746f
C4588 single_9b_cdac_1.cdac_sw_9b_0.cdac_sw_3_5.nooverlap_clk_0.x4.A VDPWR 0.62443f
C4589 VDPWR single_9b_cdac_0.cdac_sw_9b_0.cdac_sw_3_7.nooverlap_clk_0.x6.A 0.38397f
C4590 sar9b_0.net22 sar9b_0.net41 0.03468f
C4591 VDPWR single_9b_cdac_0.cdac_sw_9b_0.cdac_sw_3_8.nooverlap_clk_0.x3.Y 0.3196f
C4592 VDPWR a_9665_22406# 0.20884f
C4593 sar9b_0.net31 a_14451_24340# 0.01929f
C4594 sar9b_0.net40 sar9b_0.net4 0.55032f
C4595 single_9b_cdac_1.CF[8] VDPWR 2.43331f
C4596 sar9b_0.net15 a_11395_22530# 0.04357f
C4597 VDPWR a_8892_23252# 0.08228f
C4598 single_9b_cdac_0.cdac_sw_9b_0.S[0] single_9b_cdac_0.SW[0] 0.22983f
C4599 single_9b_cdac_1.SW[0] single_9b_cdac_1.cdac_sw_9b_0.cdac_sw_3_3.nooverlap_clk_0.CLK0 0.03931f
C4600 a_9503_20506# sar9b_0.net38 0.02388f
C4601 VDPWR a_12211_24100# 0.37461f
C4602 single_9b_cdac_1.cdac_sw_9b_0.cdac_sw_3_6.nooverlap_clk_0.sky130_fd_sc_hs__inv_1_1.A single_9b_cdac_1.CF[6] 0.01887f
C4603 single_9b_cdac_0.cdac_sw_9b_0.cdac_sw_3_8.nooverlap_clk_0.sky130_fd_sc_hs__inv_1_1.A single_9b_cdac_0.cdac_sw_9b_0.cdac_sw_3_8.nooverlap_clk_0.sky130_fd_sc_hs__nand2_1_0.Y 0.12223f
C4604 single_9b_cdac_1.cdac_sw_9b_0.cdac_sw_3_5.nooverlap_clk_0.CLK0 single_9b_cdac_1.SW[0] 0.03931f
C4605 single_9b_cdac_0.SW[3] single_9b_cdac_0.cdac_sw_9b_0.cdac_sw_3_4.tg_sw_3_3.SWN 0.15108f
C4606 single_9b_cdac_0.cdac_sw_9b_0.cdac_sw_3_0.nooverlap_clk_0.sky130_fd_sc_hs__inv_8_0.A VDPWR 0.96978f
C4607 a_48343_16877# single_9b_cdac_1.SW[3] 0.28324f
C4608 m2_23774_26966# a_24332_26999# 0.01541f
C4609 single_9b_cdac_1.cdac_sw_9b_0.cdac_sw_3_6.tg_sw_3_3.SWP single_9b_cdac_1.cdac_sw_9b_0.S[6] 1.56037f
C4610 single_9b_cdac_0.cdac_sw_9b_0.cdac_sw_3_4.nooverlap_clk_0.CLKB0 single_9b_cdac_0.cdac_sw_9b_0.cdac_sw_3_3.nooverlap_clk_0.CLKB0 0.02618f
C4611 single_9b_cdac_1.cdac_sw_9b_0.cdac_sw_3_5.nooverlap_clk_0.CLKB0 single_9b_cdac_1.SW[0] 0.05632f
C4612 a_13308_26516# a_12887_26516# 0.09313f
C4613 a_13071_21620# sar9b_0.net43 0.18687f
C4614 single_9b_cdac_1.CF[0] single_9b_cdac_1.cdac_sw_9b_0.cdac_sw_3_2.nooverlap_clk_0.x4.A 0.0313f
C4615 single_9b_cdac_0.cdac_sw_9b_0.cdac_sw_3_6.nooverlap_clk_0.sky130_fd_sc_hs__inv_1_1.A VDPWR 0.38716f
C4616 a_10637_27279# sar9b_0.net22 0.19957f
C4617 single_9b_cdac_0.cdac_sw_9b_0.cdac_sw_3_1.nooverlap_clk_0.CLK0 single_9b_cdac_1.CF[1] 0.42014f
C4618 sar9b_0.net16 VDPWR 1.21354f
C4619 a_10311_17812# VDPWR 0.3435f
C4620 sar9b_0.net11 a_12961_23802# 0.0358f
C4621 single_9b_cdac_1.CF[4] single_9b_cdac_1.cdac_sw_9b_0.cdac_sw_3_3.nooverlap_clk_0.CLKB0 0.26707f
C4622 single_9b_cdac_1.cdac_sw_9b_0.cdac_sw_3_3.nooverlap_clk_0.x6.A VDPWR 0.38397f
C4623 single_9b_cdac_1.cdac_sw_9b_0.cdac_sw_3_3.nooverlap_clk_0.x1.A VDPWR 0.75849f
C4624 sar9b_0.net3 sar9b_0._03_ 0.04022f
C4625 a_38738_26999# VDPWR 1.81495f
C4626 VDPWR a_6059_26882# 0.15254f
C4627 sar9b_0.net5 sar9b_0.net9 0.0491f
C4628 single_9b_cdac_0.SW[5] single_9b_cdac_0.cdac_sw_9b_0.cdac_sw_3_5.nooverlap_clk_0.CLKB0 0.36446f
C4629 a_13315_18660# VDPWR 0.35601f
C4630 sar9b_0.net37 a_6171_22714# 0.03436f
C4631 a_14175_27060# uo_out[0] 0.1104f
C4632 single_9b_cdac_0.cdac_sw_9b_0.cdac_sw_3_0.nooverlap_clk_0.x3.Y single_9b_cdac_1.CF[2] 0.12898f
C4633 a_7039_22138# VDPWR 0.12546f
C4634 sar9b_0.net4 a_10771_22164# 0.27704f
C4635 a_9281_21076# VDPWR 0.58139f
C4636 a_34814_26990# single_9b_cdac_0.SW[6] 0.18991f
C4637 single_9b_cdac_1.cdac_sw_9b_0.S[2] single_9b_cdac_1.cdac_sw_9b_0.S[1] 16.9154f
C4638 single_9b_cdac_1.SW[3] single_9b_cdac_1.SW[5] 0.07263f
C4639 a_7059_21228# sar9b_0._07_ 0.17311f
C4640 single_9b_cdac_1.SW[2] single_9b_cdac_1.SW[4] 0.46854f
C4641 single_9b_cdac_1.cdac_sw_9b_0.cdac_sw_3_6.nooverlap_clk_0.CLKB0 single_9b_cdac_1.cdac_sw_9b_0.cdac_sw_3_6.nooverlap_clk_0.CLK0 2.7611f
C4642 sar9b_0.net27 a_12961_23802# 0.02255f
C4643 single_9b_cdac_1.cdac_sw_9b_0.cdac_sw_3_1.nooverlap_clk_0.x10.A single_9b_cdac_1.cdac_sw_9b_0.cdac_sw_3_1.nooverlap_clk_0.x8.A 0.42509f
C4644 single_9b_cdac_0.cdac_sw_9b_0.cdac_sw_3_8.nooverlap_clk_0.x10.A single_9b_cdac_0.cdac_sw_9b_0.cdac_sw_3_8.nooverlap_clk_0.x8.A 0.42509f
C4645 single_9b_cdac_0.cdac_sw_9b_0.cdac_sw_3_5.tg_sw_3_3.SWN single_9b_cdac_0.cdac_sw_9b_0.cdac_sw_3_6.tg_sw_3_3.SWN 0.02638f
C4646 VDPWR single_9b_cdac_1.CF[6] 2.21346f
C4647 sar9b_0._04_ a_6525_22708# 0.11485f
C4648 a_10477_19450# VDPWR 0.39532f
C4649 single_9b_cdac_1.cdac_sw_9b_0.cdac_sw_3_4.nooverlap_clk_0.sky130_fd_sc_hs__inv_8_0.A single_9b_cdac_1.cdac_sw_9b_0.cdac_sw_3_4.nooverlap_clk_0.CLKB0 0.6919f
C4650 sar9b_0.net3 a_7919_27066# 0.55568f
C4651 a_6308_27060# VDPWR 0.13611f
C4652 sar9b_0.net41 sar9b_0.net6 0.20366f
C4653 single_9b_cdac_0.SW[5] a_39616_26990# 0.18991f
C4654 a_8471_20538# a_8825_20532# 0.06222f
C4655 a_11397_20538# a_12312_20910# 0.11876f
C4656 VDPWR single_9b_cdac_0.cdac_sw_9b_0.cdac_sw_3_8.nooverlap_clk_0.x8.A 0.84061f
C4657 sar9b_0.net3 sar9b_0.net35 0.2124f
C4658 a_11195_25428# sar9b_0.net42 0.01955f
C4659 ua[0] single_9b_cdac_0.cdac_sw_9b_0.cdac_sw_3_2.tg_sw_3_3.SWP 1.14952f
C4660 a_10477_19450# a_11392_19822# 0.12532f
C4661 single_9b_cdac_1.SW[0] single_9b_cdac_1.cdac_sw_9b_0.cdac_sw_3_7.tg_sw_3_3.SWN 0.12586f
C4662 ua[2] th_dif_sw_0.VCP 3.30291f
C4663 VDPWR a_10955_18900# 0.45763f
C4664 VDPWR a_9670_22708# 0.08231f
C4665 sar9b_0.net35 sar9b_0.net19 0.07986f
C4666 a_57946_26999# single_9b_cdac_0.cdac_sw_9b_0.S[1] 0.59531f
C4667 sar9b_0.net25 a_13623_25972# 0.04929f
C4668 sar9b_0.net3 sar9b_0.clk_div_0.COUNT\[0\] 0.67323f
C4669 a_10311_23252# sar9b_0.net41 0.11144f
C4670 sar9b_0._10_ sar9b_0._04_ 0.03964f
C4671 single_9b_cdac_1.SW[6] sar9b_0.net42 0.10328f
C4672 single_9b_cdac_0.cdac_sw_9b_0.cdac_sw_3_8.tg_sw_3_3.SWN single_9b_cdac_0.cdac_sw_9b_0.cdac_sw_3_8.tg_sw_3_3.SWP 3.04383f
C4673 sar9b_0.net15 a_13621_20230# 0.16678f
C4674 single_9b_cdac_1.cdac_sw_9b_0.cdac_sw_3_5.nooverlap_clk_0.x10.A single_9b_cdac_1.cdac_sw_9b_0.cdac_sw_3_5.nooverlap_clk_0.x1.A 0.05472f
C4675 a_13899_20532# single_9b_cdac_1.SW[4] 0.11566f
C4676 single_9b_cdac_1.CF[7] VDPWR 2.26771f
C4677 a_11045_24858# VDPWR 0.20896f
C4678 ua[0] single_9b_cdac_1.cdac_sw_9b_0.cdac_sw_3_5.tg_sw_3_3.SWN 3.10215f
C4679 a_13899_20532# single_9b_cdac_1.SW[2] 0.01659f
C4680 single_9b_cdac_0.cdac_sw_9b_0.cdac_sw_3_6.tg_sw_3_3.SWN single_9b_cdac_0.SW[6] 0.15428f
C4681 sar9b_0.net3 a_6691_26490# 0.33121f
C4682 a_13899_23252# single_9b_cdac_1.CF[6] 0.11189f
C4683 single_9b_cdac_0.SW[1] single_9b_cdac_0.SW[0] 18.6591f
C4684 a_13379_27398# a_13857_27279# 0.01559f
C4685 single_9b_cdac_0.cdac_sw_9b_0.cdac_sw_3_1.nooverlap_clk_0.sky130_fd_sc_hs__inv_1_1.A single_9b_cdac_1.CF[1] 0.01887f
C4686 a_6701_20506# VDPWR 1.26917f
C4687 a_10477_23252# sar9b_0.net15 0.02441f
C4688 single_9b_cdac_0.SW[8] a_14143_26490# 0.01002f
C4689 a_10827_25262# a_10923_25262# 0.01379f
C4690 single_9b_cdac_0.cdac_sw_9b_0.S[6] single_9b_cdac_0.cdac_sw_9b_0.cdac_sw_3_6.nooverlap_clk_0.CLKB0 0.36006f
C4691 sar9b_0._06_ a_7345_21594# 0.02112f
C4692 a_13308_25428# sar9b_0.net15 0.02644f
C4693 single_9b_cdac_1.cdac_sw_9b_0.cdac_sw_3_0.tg_sw_3_3.SWN single_9b_cdac_1.cdac_sw_9b_0.cdac_sw_3_0.nooverlap_clk_0.CLK0 0.17533f
C4694 a_6070_19721# VDPWR 0.28082f
C4695 a_11121_26516# a_11689_26758# 0.17072f
C4696 single_9b_cdac_1.cdac_sw_9b_0.cdac_sw_3_2.tg_sw_3_3.SWP single_9b_cdac_1.cdac_sw_9b_0.cdac_sw_3_1.tg_sw_3_3.SWP 0.02666f
C4697 a_6884_25428# VDPWR 0.29763f
C4698 a_8910_20532# VDPWR 0.24507f
C4699 a_5863_19662# sar9b_0._00_ 0.08135f
C4700 sar9b_0.clk_div_0.COUNT\[0\] a_6778_22682# 0.02392f
C4701 single_9b_cdac_1.cdac_sw_9b_0.S[2] a_53154_16877# 0.59531f
C4702 sar9b_0.net12 sar9b_0.net13 0.2027f
C4703 single_9b_cdac_0.cdac_sw_9b_0.cdac_sw_3_5.nooverlap_clk_0.x10.A single_9b_cdac_0.cdac_sw_9b_0.cdac_sw_3_5.nooverlap_clk_0.x1.A 0.05472f
C4704 a_12887_19450# sar9b_0.net5 0.34156f
C4705 sar9b_0._15_ sar9b_0._09_ 0.01195f
C4706 th_dif_sw_0.CK VDPWR 1.14176f
C4707 sar9b_0.net42 a_10937_22164# 0.0225f
C4708 uo_out[2] uo_out[1] 2.94977f
C4709 a_12887_24890# sar9b_0.net12 0.02261f
C4710 a_13347_21620# sar9b_0.net6 0.05245f
C4711 a_13621_22682# VDPWR 0.20427f
C4712 sar9b_0.net24 sar9b_0.net13 0.06788f
C4713 a_9543_19748# a_9368_19822# 0.23366f
C4714 single_9b_cdac_1.SW[0] single_9b_cdac_1.cdac_sw_9b_0.cdac_sw_3_8.tg_sw_3_3.SWP 0.08409f
C4715 a_12887_19988# sar9b_0.net6 0.59597f
C4716 sar9b_0.net15 sar9b_0.net35 0.27989f
C4717 VDPWR single_9b_cdac_1.SW[4] 2.2103f
C4718 ua[0] single_9b_cdac_1.cdac_sw_9b_0.cdac_sw_3_0.tg_sw_3_3.SWP 1.15132f
C4719 sar9b_0.net42 a_12312_20910# 0.05482f
C4720 single_9b_cdac_0.cdac_sw_9b_0.cdac_sw_3_7.nooverlap_clk_0.CLKB0 single_9b_cdac_0.SW[6] 0.02552f
C4721 sar9b_0.net12 a_13053_25428# 0.15072f
C4722 VDPWR single_9b_cdac_1.SW[2] 2.31702f
C4723 a_12887_19988# a_13053_19988# 0.74261f
C4724 sar9b_0.net27 a_14143_19962# 0.12905f
C4725 sar9b_0.net16 sar9b_0.net36 0.63862f
C4726 sar9b_0.net15 a_12887_22714# 0.32519f
C4727 sar9b_0.net37 a_13403_19988# 0.02998f
C4728 sar9b_0.net15 sar9b_0.clk_div_0.COUNT\[0\] 0.01251f
C4729 single_9b_cdac_0.SW[3] single_9b_cdac_0.SW[8] 0.02603f
C4730 a_13315_18660# sar9b_0.net36 0.11466f
C4731 a_12887_19450# sar9b_0.net38 0.13086f
C4732 a_12887_26516# a_13403_26516# 0.11535f
C4733 a_11567_23226# sar9b_0.net12 0.05871f
C4734 sar9b_0.net27 single_9b_cdac_1.CF[2] 0.1166f
C4735 sar9b_0.net15 a_13216_24162# 0.01784f
C4736 VDPWR sar9b_0.FINAL 4.70687f
C4737 single_9b_cdac_0.cdac_sw_9b_0.cdac_sw_3_7.nooverlap_clk_0.CLKB0 single_9b_cdac_0.cdac_sw_9b_0.cdac_sw_3_7.tg_sw_3_3.SWP 1.71649f
C4738 sar9b_0.net26 sar9b_0.net31 0.02415f
C4739 sar9b_0.net37 sar9b_0._12_ 0.03889f
C4740 a_6651_23520# a_5619_23252# 0.04875f
C4741 single_9b_cdac_1.cdac_sw_9b_0.cdac_sw_3_8.nooverlap_clk_0.sky130_fd_sc_hs__inv_8_0.A VDPWR 0.96907f
C4742 VDPWR a_9038_22708# 0.20813f
C4743 VDPWR single_9b_cdac_1.cdac_sw_9b_0.cdac_sw_3_0.nooverlap_clk_0.sky130_fd_sc_hs__nand2_1_0.Y 0.62573f
C4744 a_9113_24582# sar9b_0.net15 0.15941f
C4745 single_9b_cdac_1.CF[4] single_9b_cdac_0.cdac_sw_9b_0.cdac_sw_3_3.nooverlap_clk_0.x8.A 0.31534f
C4746 sar9b_0.net15 a_11471_21076# 0.19954f
C4747 single_9b_cdac_0.cdac_sw_9b_0.cdac_sw_3_1.tg_sw_3_3.SWN single_9b_cdac_1.CF[1] 0.12358f
C4748 single_9b_cdac_1.cdac_sw_9b_0.cdac_sw_3_0.nooverlap_clk_0.x1.A single_9b_cdac_1.cdac_sw_9b_0.cdac_sw_3_0.nooverlap_clk_0.sky130_fd_sc_hs__inv_1_1.A 0.10429f
C4749 uio_out[1] a_5343_25972# 0.03373f
C4750 VDPWR single_9b_cdac_1.cdac_sw_9b_0.cdac_sw_3_2.nooverlap_clk_0.x3.Y 0.3196f
C4751 a_9535_19962# sar9b_0.net15 0.28026f
C4752 sar9b_0.net15 a_13968_22164# 0.23665f
C4753 a_13403_25428# a_13308_25428# 0.04983f
C4754 a_14143_25402# a_13968_25428# 0.23366f
C4755 VDPWR a_13899_20532# 0.19093f
C4756 a_6451_21326# sar9b_0._08_ 0.03837f
C4757 ua[2] th_dif_sw_0.th_sw_1.CKB 0.08416f
C4758 single_9b_cdac_0.SW[2] single_9b_cdac_0.cdac_sw_9b_0.cdac_sw_3_0.nooverlap_clk_0.CLK0 0.2428f
C4759 a_14451_27060# single_9b_cdac_0.SW[8] 0.10954f
C4760 a_8803_19822# sar9b_0.net35 0.01835f
C4761 sar9b_0.net10 a_9665_22406# 0.07215f
C4762 ua[0] single_9b_cdac_1.cdac_sw_9b_0.cdac_sw_3_1.tg_sw_3_3.SWP 1.15121f
C4763 sar9b_0.net4 clk 0.02159f
C4764 VDPWR sar9b_0.net8 1.46945f
C4765 sar9b_0.clk_div_0.COUNT\[1\] a_8951_23770# 0.12819f
C4766 a_12211_24100# sar9b_0.net10 0.07724f
C4767 single_9b_cdac_1.cdac_sw_9b_0.cdac_sw_3_7.nooverlap_clk_0.x8.A single_9b_cdac_1.cdac_sw_9b_0.cdac_sw_3_7.nooverlap_clk_0.x4.A 0.0303f
C4768 single_9b_cdac_0.cdac_sw_9b_0.cdac_sw_3_0.nooverlap_clk_0.x1.A VDPWR 0.75899f
C4769 VDPWR a_9003_24706# 0.14215f
C4770 single_9b_cdac_1.cdac_sw_9b_0.cdac_sw_3_6.nooverlap_clk_0.sky130_fd_sc_hs__inv_1_1.A VDPWR 0.38716f
C4771 single_9b_cdac_0.cdac_sw_9b_0.cdac_sw_3_5.nooverlap_clk_0.x8.A single_9b_cdac_1.CF[5] 0.31534f
C4772 sar9b_0.net28 single_9b_cdac_1.CF[5] 0.04273f
C4773 a_6726_27060# sar9b_0.net3 0.01785f
C4774 a_38738_26999# single_9b_cdac_0.cdac_sw_9b_0.S[5] 0.59531f
C4775 a_13379_27398# a_13621_26758# 0.01037f
C4776 a_10955_26516# a_11376_26516# 0.09016f
C4777 single_9b_cdac_1.CF[4] single_9b_cdac_1.cdac_sw_9b_0.cdac_sw_3_3.nooverlap_clk_0.sky130_fd_sc_hs__nand2_1_0.Y 0.17948f
C4778 a_13419_23796# a_13529_23770# 0.09774f
C4779 single_9b_cdac_0.cdac_sw_9b_0.S[0] single_9b_cdac_0.cdac_sw_9b_0.cdac_sw_3_2.nooverlap_clk_0.CLKB0 0.36044f
C4780 single_9b_cdac_1.cdac_sw_9b_0.cdac_sw_3_1.nooverlap_clk_0.x3.Y VDPWR 0.3196f
C4781 single_9b_cdac_1.CF[5] sar9b_0.net29 0.03905f
C4782 single_9b_cdac_0.SW[1] sar9b_0.net30 0.02958f
C4783 single_9b_cdac_0.cdac_sw_9b_0.cdac_sw_3_5.tg_sw_3_3.SWN single_9b_cdac_1.CF[6] 0.03488f
C4784 single_9b_cdac_0.cdac_sw_9b_0.cdac_sw_3_4.nooverlap_clk_0.CLKB0 single_9b_cdac_0.cdac_sw_9b_0.cdac_sw_3_4.tg_sw_3_3.SWN 0.22875f
C4785 sar9b_0.net15 a_14451_17812# 0.20102f
C4786 a_10482_3438# th_dif_sw_0.th_sw_1.CK 0.1221f
C4787 a_8708_19810# sar9b_0.net4 0.0174f
C4788 single_9b_cdac_0.cdac_sw_9b_0.S[5] single_9b_cdac_1.CF[6] 0.01664f
C4789 sar9b_0.net39 a_9000_27438# 0.06055f
C4790 single_9b_cdac_0.cdac_sw_9b_0.cdac_sw_3_8.nooverlap_clk_0.x10.A VDPWR 0.95338f
C4791 clk a_9000_27438# 0.01898f
C4792 single_9b_cdac_1.CF[0] single_9b_cdac_1.cdac_sw_9b_0.cdac_sw_3_2.nooverlap_clk_0.x8.A 0.31534f
C4793 a_10679_25428# a_10845_25428# 0.61654f
C4794 sar9b_0.net33 sar9b_0.net32 0.02978f
C4795 a_10827_19822# sar9b_0.net15 0.15705f
C4796 single_9b_cdac_0.cdac_sw_9b_0.cdac_sw_3_1.nooverlap_clk_0.x8.A single_9b_cdac_0.cdac_sw_9b_0.cdac_sw_3_1.nooverlap_clk_0.x1.A 0.42784f
C4797 single_9b_cdac_1.CF[8] single_9b_cdac_0.SW[4] 0.01522f
C4798 sar9b_0.net15 a_9205_23494# 0.16055f
C4799 sar9b_0.net4 a_8895_24340# 0.03584f
C4800 sar9b_0._11_ sar9b_0.clknet_1_1__leaf_CLK 0.03505f
C4801 single_9b_cdac_1.CF[8] single_9b_cdac_0.cdac_sw_9b_0.cdac_sw_3_7.tg_sw_3_3.SWP 0.19143f
C4802 single_9b_cdac_1.CF[4] single_9b_cdac_1.SW[0] 0.22459f
C4803 sar9b_0.net15 a_13511_26882# 0.01987f
C4804 single_9b_cdac_1.cdac_sw_9b_0.cdac_sw_3_2.nooverlap_clk_0.CLK0 single_9b_cdac_1.cdac_sw_9b_0.cdac_sw_3_2.tg_sw_3_3.SWP 0.19266f
C4805 a_9738_20240# sar9b_0.net37 0.05371f
C4806 a_7735_21076# VDPWR 0.22999f
C4807 single_9b_cdac_0.cdac_sw_9b_0.cdac_sw_3_2.tg_sw_3_3.SWP single_9b_cdac_0.cdac_sw_9b_0.cdac_sw_3_1.tg_sw_3_3.SWP 0.02666f
C4808 a_5711_21076# sar9b_0._10_ 0.05082f
C4809 ua[0] single_9b_cdac_0.cdac_sw_9b_0.cdac_sw_3_0.tg_sw_3_3.SWN 3.10229f
C4810 sar9b_0.net40 a_13053_21076# 0.03435f
C4811 a_6163_27034# a_6094_27060# 0.20964f
C4812 a_5968_27176# sar9b_0.net35 0.27218f
C4813 a_7039_22138# sar9b_0.clk_div_0.COUNT\[3\] 0.11025f
C4814 single_9b_cdac_1.cdac_sw_9b_0.S[2] single_9b_cdac_1.CF[3] 0.01472f
C4815 a_13403_25262# VDPWR 0.19375f
C4816 a_14143_25188# single_9b_cdac_0.SW[5] 0.01129f
C4817 single_9b_cdac_1.cdac_sw_9b_0.cdac_sw_3_2.nooverlap_clk_0.x1.A single_9b_cdac_1.cdac_sw_9b_0.cdac_sw_3_2.nooverlap_clk_0.sky130_fd_sc_hs__nand2_1_0.Y 0.01003f
C4818 a_8085_23802# a_8273_23796# 0.09972f
C4819 sar9b_0.net3 a_6859_21710# 0.11682f
C4820 single_9b_cdac_1.CF[7] single_9b_cdac_1.cdac_sw_9b_0.S[6] 0.0174f
C4821 single_9b_cdac_1.cdac_sw_9b_0.cdac_sw_3_5.nooverlap_clk_0.CLK0 single_9b_cdac_1.CF[5] 0.42014f
C4822 sar9b_0.net41 sar9b_0.net2 0.31952f
C4823 a_11392_19822# VDPWR 0.3012f
C4824 clk single_9b_cdac_1.SW[0] 0.22068f
C4825 a_9115_21076# a_10371_21050# 0.04357f
C4826 a_9281_21076# a_9631_21076# 0.21963f
C4827 sar9b_0.net10 a_9670_22708# 0.16124f
C4828 single_9b_cdac_1.cdac_sw_9b_0.cdac_sw_3_5.nooverlap_clk_0.CLKB0 single_9b_cdac_1.CF[5] 0.26707f
C4829 sar9b_0.net15 a_12059_18362# 0.29576f
C4830 a_5969_25428# sar9b_0.net3 0.05749f
C4831 single_9b_cdac_0.SW[6] single_9b_cdac_1.CF[6] 1.79589f
C4832 sar9b_0._13_ a_7035_22708# 0.01034f
C4833 a_13053_22714# a_13053_22164# 0.02763f
C4834 a_13511_22708# sar9b_0.net15 0.02032f
C4835 single_9b_cdac_0.cdac_sw_9b_0.cdac_sw_3_4.nooverlap_clk_0.sky130_fd_sc_hs__inv_1_1.A single_9b_cdac_1.CF[3] 0.01887f
C4836 a_6960_26338# a_6705_25978# 0.05587f
C4837 a_8895_26350# sar9b_0.net38 0.04012f
C4838 single_9b_cdac_1.CF[6] single_9b_cdac_0.SW[4] 0.02008f
C4839 single_9b_cdac_0.cdac_sw_9b_0.cdac_sw_3_2.tg_sw_3_3.SWN single_9b_cdac_0.cdac_sw_9b_0.cdac_sw_3_2.nooverlap_clk_0.x10.A 0.69086f
C4840 sar9b_0.net27 single_9b_cdac_1.CF[0] 0.03472f
C4841 sar9b_0.net36 sar9b_0.FINAL 0.08258f
C4842 uio_out[0] sar9b_0.FINAL 0.1373f
C4843 a_5973_23252# a_6058_23618# 0.03733f
C4844 a_13899_23252# VDPWR 0.19386f
C4845 sar9b_0.net39 a_13053_22164# 0.03716f
C4846 sar9b_0.net3 a_5343_25972# 0.33463f
C4847 a_11691_25978# a_12947_26276# 0.04357f
C4848 ua[0] single_9b_cdac_1.cdac_sw_9b_0.cdac_sw_3_0.tg_sw_3_3.SWN 3.10226f
C4849 a_14175_20532# single_9b_cdac_1.SW[5] 0.11941f
C4850 single_9b_cdac_0.cdac_sw_9b_0.cdac_sw_3_2.tg_sw_3_3.SWP single_9b_cdac_0.cdac_sw_9b_0.S[0] 1.55985f
C4851 a_13308_25428# sar9b_0.net1 0.15824f
C4852 single_9b_cdac_1.cdac_sw_9b_0.cdac_sw_3_6.tg_sw_3_3.SWP single_9b_cdac_1.cdac_sw_9b_0.cdac_sw_3_6.nooverlap_clk_0.CLK0 0.19266f
C4853 sar9b_0.net15 a_9774_19266# 0.17022f
C4854 a_21368_4076# th_dif_sw_0.th_sw_1.CK 0.04727f
C4855 a_6249_19988# VDPWR 0.0695f
C4856 sar9b_0.net3 a_12947_26276# 0.2789f
C4857 single_9b_cdac_1.CF[7] single_9b_cdac_0.SW[6] 0.12064f
C4858 a_6169_26758# a_5951_26516# 0.20964f
C4859 a_5601_26516# a_6691_26490# 0.04182f
C4860 single_9b_cdac_1.cdac_sw_9b_0.cdac_sw_3_4.nooverlap_clk_0.CLKB0 VDPWR 2.81423f
C4861 single_9b_cdac_0.cdac_sw_9b_0.S[0] a_63626_26990# 0.22513f
C4862 uo_out[6] a_7919_27066# 0.03718f
C4863 single_9b_cdac_1.CF[7] single_9b_cdac_0.SW[4] 0.02019f
C4864 a_10955_18900# a_11689_19142# 0.05348f
C4865 sar9b_0.net39 a_12887_26516# 0.03995f
C4866 a_13053_26516# a_13621_26758# 0.18639f
C4867 a_8910_20532# sar9b_0.clk_div_0.COUNT\[3\] 0.03108f
C4868 a_11857_25978# a_12425_25946# 0.1803f
C4869 sar9b_0.net2 a_13308_18900# 0.15774f
C4870 single_9b_cdac_1.CF[7] single_9b_cdac_0.cdac_sw_9b_0.cdac_sw_3_7.tg_sw_3_3.SWP 0.10499f
C4871 a_6149_23770# sar9b_0.clknet_0_CLK 0.31926f
C4872 ua[0] single_9b_cdac_1.cdac_sw_9b_0.cdac_sw_3_2.nooverlap_clk_0.CLK0 0.11907f
C4873 a_11121_21076# a_11689_21318# 0.18639f
C4874 uo_out[6] sar9b_0.net35 0.10968f
C4875 sar9b_0.net35 sar9b_0.net1 0.02616f
C4876 a_12887_22164# a_13403_22164# 0.11535f
C4877 sar9b_0.net15 a_6859_21710# 0.1104f
C4878 single_9b_cdac_0.cdac_sw_9b_0.cdac_sw_3_6.nooverlap_clk_0.sky130_fd_sc_hs__inv_1_1.A single_9b_cdac_0.cdac_sw_9b_0.cdac_sw_3_6.nooverlap_clk_0.x1.A 0.10429f
C4879 a_9097_22164# a_9352_22164# 0.06121f
C4880 a_10827_23252# a_10935_23618# 0.05722f
C4881 sar9b_0.net23 a_10955_26516# 0.09473f
C4882 single_9b_cdac_1.cdac_sw_9b_0.cdac_sw_3_7.nooverlap_clk_0.x4.A single_9b_cdac_1.cdac_sw_9b_0.cdac_sw_3_7.nooverlap_clk_0.x3.Y 0.07517f
C4883 a_11195_25428# sar9b_0.net15 0.15582f
C4884 sar9b_0.net40 sar9b_0.net41 0.46234f
C4885 single_9b_cdac_0.SW[8] th_dif_sw_0.VCN 0.11809f
C4886 sar9b_0.net1 a_12887_22714# 0.20121f
C4887 single_9b_cdac_0.cdac_sw_9b_0.cdac_sw_3_4.nooverlap_clk_0.x4.A single_9b_cdac_0.cdac_sw_9b_0.cdac_sw_3_4.nooverlap_clk_0.x8.A 0.0303f
C4888 single_9b_cdac_1.cdac_sw_9b_0.cdac_sw_3_5.nooverlap_clk_0.x8.A single_9b_cdac_1.cdac_sw_9b_0.cdac_sw_3_5.nooverlap_clk_0.sky130_fd_sc_hs__nand2_1_0.Y 0.26942f
C4889 a_6930_20241# a_6759_20354# 0.28549f
C4890 single_9b_cdac_1.cdac_sw_9b_0.cdac_sw_3_6.tg_sw_3_3.SWN single_9b_cdac_1.cdac_sw_9b_0.cdac_sw_3_7.tg_sw_3_3.SWN 0.02638f
C4891 a_13621_22406# a_13968_22164# 0.05116f
C4892 a_13053_22164# a_13308_22164# 0.06044f
C4893 sar9b_0.net7 a_12887_18900# 0.25702f
C4894 a_12211_24100# sar9b_0.net43 0.10237f
C4895 tdc_0.RDY a_16159_13315# 0.14369f
C4896 single_9b_cdac_0.cdac_sw_9b_0.S[2] single_9b_cdac_0.cdac_sw_9b_0.cdac_sw_3_0.tg_sw_3_3.SWP 1.55949f
C4897 single_9b_cdac_0.cdac_sw_9b_0.cdac_sw_3_6.tg_sw_3_3.SWN single_9b_cdac_0.cdac_sw_9b_0.cdac_sw_3_6.nooverlap_clk_0.CLKB0 0.22875f
C4898 a_6171_22714# a_6610_22708# 0.25938f
C4899 a_11471_18900# a_11567_18900# 0.01379f
C4900 a_13968_21076# single_9b_cdac_1.SW[8] 0.01826f
C4901 single_9b_cdac_1.SW[7] single_9b_cdac_1.cdac_sw_9b_0.cdac_sw_3_7.nooverlap_clk_0.CLKB0 0.363f
C4902 sar9b_0.net3 a_10371_26490# 0.34113f
C4903 single_9b_cdac_0.cdac_sw_9b_0.cdac_sw_3_4.tg_sw_3_3.SWN single_9b_cdac_1.CF[3] 0.12359f
C4904 a_13216_24162# sar9b_0.net1 0.17476f
C4905 clk single_9b_cdac_0.cdac_sw_9b_0.S[1] 0.02119f
C4906 a_30012_26990# single_9b_cdac_0.cdac_sw_9b_0.S[7] 0.22513f
C4907 a_13621_25670# sar9b_0.net32 0.01848f
C4908 single_9b_cdac_0.cdac_sw_9b_0.cdac_sw_3_4.nooverlap_clk_0.x8.A single_9b_cdac_1.CF[3] 0.31534f
C4909 single_9b_cdac_1.SW[6] sar9b_0.net15 0.05291f
C4910 a_9003_25972# VDPWR 0.14217f
C4911 a_13621_21318# VDPWR 0.20779f
C4912 a_10477_24890# a_11392_25262# 0.11716f
C4913 a_5711_21076# a_5884_21326# 0.03259f
C4914 single_9b_cdac_0.cdac_sw_9b_0.cdac_sw_3_6.nooverlap_clk_0.x1.A single_9b_cdac_1.CF[6] 0.06503f
C4915 a_7203_22682# a_7035_22708# 0.31086f
C4916 single_9b_cdac_1.cdac_sw_9b_0.cdac_sw_3_4.nooverlap_clk_0.CLK0 single_9b_cdac_1.CF[3] 0.42015f
C4917 sar9b_0._15_ sar9b_0.clknet_0_CLK 0.03805f
C4918 VDPWR sar9b_0.net36 3.00113f
C4919 single_9b_cdac_1.cdac_sw_9b_0.cdac_sw_3_1.nooverlap_clk_0.x4.A single_9b_cdac_1.CF[1] 0.0313f
C4920 uio_out[0] VDPWR 1.38113f
C4921 single_9b_cdac_0.cdac_sw_9b_0.cdac_sw_3_0.nooverlap_clk_0.sky130_fd_sc_hs__nand2_1_0.Y single_9b_cdac_0.cdac_sw_9b_0.cdac_sw_3_0.nooverlap_clk_0.x4.A 0.01751f
C4922 tdc_0.phase_detector_0.pd_out_0.A a_16970_11404# 0.18949f
C4923 a_5895_19988# sar9b_0.clknet_1_0__leaf_CLK 0.68566f
C4924 a_11287_22164# a_11505_22406# 0.20964f
C4925 a_12027_22138# a_10937_22164# 0.04242f
C4926 a_11852_22164# a_10771_22164# 0.10236f
C4927 single_9b_cdac_0.cdac_sw_9b_0.cdac_sw_3_1.nooverlap_clk_0.CLK0 VDPWR 2.71729f
C4928 a_10477_24890# sar9b_0.net12 0.26625f
C4929 a_11376_18900# sar9b_0.net6 0.17041f
C4930 a_9113_25946# VDPWR 0.21154f
C4931 a_8531_27438# a_8435_27438# 0.01379f
C4932 sar9b_0.net15 a_14143_26490# 0.28229f
C4933 sar9b_0._02_ sar9b_0.clk_div_0.COUNT\[0\] 0.06318f
C4934 clk a_8951_23770# 0.02787f
C4935 VDPWR single_9b_cdac_0.cdac_sw_9b_0.S[3] 4.15101f
C4936 clk single_9b_cdac_0.SW[7] 0.28339f
C4937 single_9b_cdac_1.CF[4] single_9b_cdac_0.cdac_sw_9b_0.cdac_sw_3_3.nooverlap_clk_0.x1.A 0.06503f
C4938 single_9b_cdac_1.CF[2] single_9b_cdac_1.cdac_sw_9b_0.cdac_sw_3_0.nooverlap_clk_0.x3.Y 0.12898f
C4939 sar9b_0.net37 sar9b_0.clknet_1_1__leaf_CLK 0.22576f
C4940 a_12683_18356# a_12793_18330# 0.09774f
C4941 a_8783_23796# sar9b_0.net35 0.01866f
C4942 tdc_0.phase_detector_0.pd_out_0.A VDPWR 1.77491f
C4943 sar9b_0.net15 a_10937_22164# 0.4707f
C4944 sar9b_0.net17 a_5690_27192# 0.0119f
C4945 a_6726_27060# a_5968_27176# 0.05936f
C4946 a_6473_27426# a_6163_27034# 0.01379f
C4947 single_9b_cdac_0.cdac_sw_9b_0.cdac_sw_3_0.nooverlap_clk_0.CLKB0 single_9b_cdac_0.cdac_sw_9b_0.cdac_sw_3_0.nooverlap_clk_0.CLK0 2.7611f
C4948 a_7363_23502# sar9b_0.net3 0.06561f
C4949 single_9b_cdac_0.cdac_sw_9b_0.cdac_sw_3_7.nooverlap_clk_0.sky130_fd_sc_hs__nand2_1_0.Y single_9b_cdac_0.cdac_sw_9b_0.cdac_sw_3_7.nooverlap_clk_0.sky130_fd_sc_hs__inv_1_1.A 0.12223f
C4950 single_9b_cdac_0.cdac_sw_9b_0.cdac_sw_3_7.nooverlap_clk_0.CLKB0 single_9b_cdac_0.cdac_sw_9b_0.cdac_sw_3_6.nooverlap_clk_0.CLKB0 0.02632f
C4951 sar9b_0.net15 a_8634_22840# 0.23661f
C4952 sar9b_0.net37 a_6537_25670# 0.01139f
C4953 a_5803_25428# a_6319_25428# 0.10923f
C4954 sar9b_0.net15 a_12961_23802# 0.08545f
C4955 a_8471_20538# sar9b_0.net4 0.03235f
C4956 a_9115_26516# a_10371_26490# 0.04348f
C4957 sar9b_0.net41 a_9631_26516# 0.04014f
C4958 single_9b_cdac_0.cdac_sw_9b_0.cdac_sw_3_4.nooverlap_clk_0.CLK0 a_49221_26990# 0.14695f
C4959 single_9b_cdac_1.cdac_sw_9b_0.cdac_sw_3_2.nooverlap_clk_0.CLKB0 single_9b_cdac_1.cdac_sw_9b_0.cdac_sw_3_2.nooverlap_clk_0.CLK0 2.7611f
C4960 sar9b_0.net3 a_12036_26516# 0.28595f
C4961 single_9b_cdac_1.cdac_sw_9b_0.S[6] VDPWR 4.16106f
C4962 sar9b_0.net40 a_13347_21620# 0.02254f
C4963 single_9b_cdac_1.SW[0] a_62748_16877# 0.28324f
C4964 single_9b_cdac_0.cdac_sw_9b_0.cdac_sw_3_5.tg_sw_3_3.SWN VDPWR 2.82223f
C4965 a_9631_21076# sar9b_0.net8 0.03368f
C4966 single_9b_cdac_0.cdac_sw_9b_0.cdac_sw_3_3.nooverlap_clk_0.x10.A VDPWR 0.95338f
C4967 sar9b_0.net15 a_12312_20910# 0.22145f
C4968 single_9b_cdac_0.cdac_sw_9b_0.cdac_sw_3_8.tg_sw_3_3.SWN single_9b_cdac_0.cdac_sw_9b_0.S[8] 0.84381f
C4969 VDPWR single_9b_cdac_0.cdac_sw_9b_0.S[5] 4.15421f
C4970 sar9b_0.net7 sar9b_0.net9 0.13956f
C4971 VDPWR a_10187_22138# 0.36296f
C4972 single_9b_cdac_1.cdac_sw_9b_0.cdac_sw_3_1.nooverlap_clk_0.CLKB0 single_9b_cdac_1.cdac_sw_9b_0.cdac_sw_3_2.tg_sw_3_3.SWN 0.01175f
C4973 ua[2] a_10166_3438# 0.65711f
C4974 VDPWR sar9b_0.net10 1.43459f
C4975 single_9b_cdac_1.cdac_sw_9b_0.cdac_sw_3_5.nooverlap_clk_0.sky130_fd_sc_hs__inv_1_1.A single_9b_cdac_1.CF[5] 0.01887f
C4976 a_11121_21076# sar9b_0.net2 0.28536f
C4977 VDPWR a_24332_26999# 1.81495f
C4978 VDPWR single_9b_cdac_0.cdac_sw_9b_0.cdac_sw_3_4.nooverlap_clk_0.x1.A 0.75815f
C4979 sar9b_0._13_ sar9b_0.clk_div_0.COUNT\[0\] 0.3697f
C4980 a_13511_21442# sar9b_0.net39 0.02438f
C4981 ua[0] single_9b_cdac_1.cdac_sw_9b_0.cdac_sw_3_3.nooverlap_clk_0.CLK0 0.12076f
C4982 a_8800_26338# sar9b_0.net38 0.01555f
C4983 single_9b_cdac_0.SW[0] a_12961_23802# 0.01205f
C4984 a_11045_19418# a_10935_19444# 0.09774f
C4985 single_9b_cdac_0.cdac_sw_9b_0.cdac_sw_3_7.nooverlap_clk_0.CLKB0 single_9b_cdac_0.cdac_sw_9b_0.cdac_sw_3_7.nooverlap_clk_0.sky130_fd_sc_hs__inv_8_0.A 0.6919f
C4986 single_9b_cdac_1.CF[4] single_9b_cdac_0.cdac_sw_9b_0.cdac_sw_3_3.nooverlap_clk_0.sky130_fd_sc_hs__nand2_1_0.Y 0.17948f
C4987 ua[0] single_9b_cdac_1.cdac_sw_9b_0.cdac_sw_3_5.nooverlap_clk_0.CLK0 0.12077f
C4988 a_13053_21076# sar9b_0.net39 0.36143f
C4989 single_9b_cdac_0.cdac_sw_9b_0.cdac_sw_3_8.tg_sw_3_3.SWN single_9b_cdac_0.cdac_sw_9b_0.cdac_sw_3_8.nooverlap_clk_0.CLK0 0.17533f
C4990 single_9b_cdac_1.CF[4] single_9b_cdac_0.cdac_sw_9b_0.cdac_sw_3_4.tg_sw_3_3.SWP 0.19125f
C4991 ua[0] single_9b_cdac_1.cdac_sw_9b_0.cdac_sw_3_5.nooverlap_clk_0.CLKB0 0.1236f
C4992 single_9b_cdac_1.cdac_sw_9b_0.cdac_sw_3_3.nooverlap_clk_0.x8.A single_9b_cdac_1.cdac_sw_9b_0.cdac_sw_3_3.nooverlap_clk_0.sky130_fd_sc_hs__inv_8_0.A 0.04988f
C4993 a_8613_26681# sar9b_0.FINAL 0.03969f
C4994 a_8471_23252# a_8637_23252# 0.90033f
C4995 single_9b_cdac_0.cdac_sw_9b_0.cdac_sw_3_1.nooverlap_clk_0.sky130_fd_sc_hs__inv_1_1.A VDPWR 0.38716f
C4996 sar9b_0.clk_div_0.COUNT\[3\] VDPWR 0.59545f
C4997 a_12059_18362# sar9b_0.net1 0.02702f
C4998 VDPWR single_9b_cdac_0.SW[6] 2.1691f
C4999 a_9631_21076# VDPWR 0.22005f
C5000 sar9b_0.net31 VDPWR 0.54067f
C5001 single_9b_cdac_1.cdac_sw_9b_0.cdac_sw_3_0.nooverlap_clk_0.CLK0 a_54032_17740# 0.14695f
C5002 single_9b_cdac_1.cdac_sw_9b_0.S[8] single_9b_cdac_1.cdac_sw_9b_0.S[1] 0.22526f
C5003 single_9b_cdac_1.cdac_sw_9b_0.S[5] single_9b_cdac_1.SW[5] 0.22549f
C5004 single_9b_cdac_1.cdac_sw_9b_0.cdac_sw_3_1.nooverlap_clk_0.x10.A single_9b_cdac_1.cdac_sw_9b_0.cdac_sw_3_1.nooverlap_clk_0.x1.A 0.05472f
C5005 single_9b_cdac_0.cdac_sw_9b_0.cdac_sw_3_5.tg_sw_3_3.SWP single_9b_cdac_0.cdac_sw_9b_0.cdac_sw_3_5.nooverlap_clk_0.CLK0 0.19266f
C5006 sar9b_0.net4 a_8951_22950# 0.26116f
C5007 single_9b_cdac_0.SW[0] single_9b_cdac_0.SW[3] 0.01065f
C5008 a_14451_23252# single_9b_cdac_1.CF[8] 0.11025f
C5009 uio_in[3] uio_in[2] 0.03102f
C5010 VDPWR single_9b_cdac_0.SW[4] 2.26179f
C5011 sar9b_0._09_ sar9b_0.clk_div_0.COUNT\[0\] 0.06201f
C5012 VDPWR single_9b_cdac_0.cdac_sw_9b_0.cdac_sw_3_7.tg_sw_3_3.SWP 3.27795f
C5013 a_21368_4076# th_dif_sw_0.VCP 0.18144f
C5014 a_13053_22714# single_9b_cdac_1.CF[5] 0.01342f
C5015 single_9b_cdac_0.cdac_sw_9b_0.cdac_sw_3_5.nooverlap_clk_0.sky130_fd_sc_hs__inv_8_0.A single_9b_cdac_0.cdac_sw_9b_0.cdac_sw_3_5.nooverlap_clk_0.CLKB0 0.6919f
C5016 sar9b_0.net37 a_13071_20532# 0.19404f
C5017 ua[0] single_9b_cdac_0.cdac_sw_9b_0.cdac_sw_3_6.nooverlap_clk_0.CLK0 0.12077f
C5018 a_13899_24340# sar9b_0.net28 0.03013f
C5019 sar9b_0.net37 a_6226_23364# 0.01791f
C5020 a_53154_26999# single_9b_cdac_0.cdac_sw_9b_0.cdac_sw_3_0.tg_sw_3_3.SWP 0.04592f
C5021 single_9b_cdac_1.CF[4] single_9b_cdac_1.CF[5] 10.0488f
C5022 VDPWR a_11689_19142# 0.2362f
C5023 ua[0] single_9b_cdac_0.cdac_sw_9b_0.cdac_sw_3_2.tg_sw_3_3.SWN 3.10048f
C5024 VDPWR a_13308_23074# 0.08279f
C5025 sar9b_0.net2 a_8471_23252# 0.31967f
C5026 uo_out[3] sar9b_0.net39 0.02489f
C5027 ua[0] single_9b_cdac_1.cdac_sw_9b_0.cdac_sw_3_7.tg_sw_3_3.SWN 3.10215f
C5028 uo_out[3] clk 0.04568f
C5029 single_9b_cdac_1.cdac_sw_9b_0.cdac_sw_3_7.nooverlap_clk_0.x10.A single_9b_cdac_1.cdac_sw_9b_0.cdac_sw_3_7.nooverlap_clk_0.sky130_fd_sc_hs__inv_8_0.A 0.05105f
C5030 sar9b_0.net4 a_10955_21076# 0.03034f
C5031 a_9113_25946# a_9003_25972# 0.09774f
C5032 sar9b_0.FINAL sar9b_0.net43 0.08754f
C5033 single_9b_cdac_1.cdac_sw_9b_0.cdac_sw_3_6.nooverlap_clk_0.CLK0 single_9b_cdac_1.CF[6] 0.42014f
C5034 clk single_9b_cdac_1.CF[5] 0.08196f
C5035 sar9b_0.net15 a_14143_19962# 0.28492f
C5036 sar9b_0.net15 a_12887_25428# 0.61874f
C5037 a_6651_23520# a_6149_23770# 0.01635f
C5038 sar9b_0.net30 a_14451_25972# 0.21553f
C5039 VDPWR single_9b_cdac_0.cdac_sw_9b_0.cdac_sw_3_3.nooverlap_clk_0.CLK0 2.71729f
C5040 single_9b_cdac_1.cdac_sw_9b_0.cdac_sw_3_0.nooverlap_clk_0.x10.A single_9b_cdac_1.cdac_sw_9b_0.cdac_sw_3_0.nooverlap_clk_0.sky130_fd_sc_hs__inv_8_0.A 0.05105f
C5041 a_11567_25188# VDPWR 0.38255f
C5042 sar9b_0.net37 single_9b_cdac_1.SW[1] 0.14715f
C5043 single_9b_cdac_1.CF[4] single_9b_cdac_1.cdac_sw_9b_0.cdac_sw_3_3.nooverlap_clk_0.sky130_fd_sc_hs__inv_1_1.A 0.01887f
C5044 ua[2] a_10254_2858# 0.12559f
C5045 single_9b_cdac_0.cdac_sw_9b_0.cdac_sw_3_1.nooverlap_clk_0.CLKB0 single_9b_cdac_0.cdac_sw_9b_0.cdac_sw_3_2.nooverlap_clk_0.CLKB0 0.02632f
C5046 sar9b_0.net3 a_7325_26681# 0.04365f
C5047 sar9b_0.clk_div_0.COUNT\[1\] a_6149_23770# 0.01267f
C5048 a_10482_3438# th_dif_sw_0.th_sw_1.CKB 0.0331f
C5049 sar9b_0.net15 single_9b_cdac_1.CF[2] 0.02035f
C5050 a_10827_23252# sar9b_0.net15 0.15257f
C5051 VDPWR a_13053_18900# 0.57661f
C5052 single_9b_cdac_0.cdac_sw_9b_0.cdac_sw_3_0.tg_sw_3_3.SWP single_9b_cdac_1.CF[2] 0.10503f
C5053 single_9b_cdac_0.cdac_sw_9b_0.cdac_sw_3_6.nooverlap_clk_0.CLKB0 single_9b_cdac_1.CF[6] 0.26707f
C5054 sar9b_0.net11 a_13053_24890# 0.48228f
C5055 a_8545_25978# a_8895_26350# 0.21963f
C5056 a_10477_24890# a_10935_24884# 0.02761f
C5057 sar9b_0.net11 a_10732_25250# 0.01618f
C5058 a_6701_20506# sar9b_0._00_ 0.01231f
C5059 sar9b_0.net18 a_7417_27279# 0.01108f
C5060 a_6907_19444# VDPWR 0.37717f
C5061 a_7325_26681# sar9b_0.net19 0.01334f
C5062 a_11689_26758# a_11471_26516# 0.20964f
C5063 a_11121_26516# a_12211_26490# 0.04242f
C5064 sar9b_0.net41 sar9b_0.net39 0.06818f
C5065 VDPWR a_8613_26681# 0.27637f
C5066 a_6427_25794# VDPWR 0.14329f
C5067 a_9335_20532# VDPWR 0.19213f
C5068 clk sar9b_0.net41 0.02352f
C5069 sar9b_0.clk_div_0.COUNT\[0\] a_7203_22682# 0.07574f
C5070 a_6315_21050# sar9b_0._08_ 0.06581f
C5071 single_9b_cdac_1.SW[7] single_9b_cdac_1.SW[5] 0.04779f
C5072 a_10774_20354# sar9b_0.net2 0.15762f
C5073 a_10955_23802# sar9b_0.net2 0.29095f
C5074 sar9b_0.net8 sar9b_0.net43 0.06925f
C5075 single_9b_cdac_1.SW[7] single_9b_cdac_1.SW[3] 0.06919f
C5076 a_12315_25972# VDPWR 0.14196f
C5077 single_9b_cdac_0.SW[2] single_9b_cdac_0.SW[7] 0.01791f
C5078 a_12887_19450# a_12887_18900# 0.03658f
C5079 single_9b_cdac_0.cdac_sw_9b_0.cdac_sw_3_1.tg_sw_3_3.SWN VDPWR 2.82231f
C5080 sar9b_0.net15 a_10016_20256# 0.07372f
C5081 a_14175_18356# single_9b_cdac_1.SW[0] 0.1112f
C5082 a_7163_25972# VDPWR 0.14219f
C5083 a_6315_21050# sar9b_0.net37 0.01192f
C5084 single_9b_cdac_0.cdac_sw_9b_0.cdac_sw_3_5.nooverlap_clk_0.x4.A single_9b_cdac_1.CF[5] 0.0313f
C5085 a_25915_29917# single_9b_cdac_0.cdac_sw_9b_0.cdac_sw_3_8.nooverlap_clk_0.x4.A 0.01076f
C5086 a_10637_27279# sar9b_0.net39 0.0281f
C5087 a_12937_27279# VDPWR 0.22231f
C5088 a_14143_23012# VDPWR 0.3648f
C5089 single_9b_cdac_1.cdac_sw_9b_0.cdac_sw_3_8.nooverlap_clk_0.CLKB0 single_9b_cdac_1.cdac_sw_9b_0.cdac_sw_3_8.nooverlap_clk_0.CLK0 2.7611f
C5090 single_9b_cdac_0.SW[0] single_9b_cdac_1.CF[2] 0.35203f
C5091 single_9b_cdac_0.cdac_sw_9b_0.cdac_sw_3_4.tg_sw_3_3.SWP a_48343_26999# 0.04592f
C5092 single_9b_cdac_0.cdac_sw_9b_0.cdac_sw_3_6.nooverlap_clk_0.x1.A VDPWR 0.75853f
C5093 a_14451_23252# single_9b_cdac_1.CF[7] 0.12275f
C5094 single_9b_cdac_0.cdac_sw_9b_0.S[4] single_9b_cdac_0.cdac_sw_9b_0.S[7] 1.63295f
C5095 clk th_dif_sw_0.VCP 1.62194f
C5096 sar9b_0.net2 a_9687_19042# 0.28747f
C5097 single_9b_cdac_0.cdac_sw_9b_0.cdac_sw_3_6.nooverlap_clk_0.x8.A single_9b_cdac_0.cdac_sw_9b_0.cdac_sw_3_6.nooverlap_clk_0.sky130_fd_sc_hs__inv_1_1.A 0.08121f
C5098 a_5619_23252# sar9b_0.clknet_1_1__leaf_CLK 0.30799f
C5099 a_10311_24890# a_10477_24890# 0.88744f
C5100 single_9b_cdac_0.cdac_sw_9b_0.cdac_sw_3_2.nooverlap_clk_0.x4.A VDPWR 0.62443f
C5101 sar9b_0.net42 a_13347_20532# 0.03526f
C5102 ua[0] single_9b_cdac_1.cdac_sw_9b_0.cdac_sw_3_8.tg_sw_3_3.SWP 1.20704f
C5103 single_9b_cdac_0.cdac_sw_9b_0.cdac_sw_3_4.nooverlap_clk_0.CLK0 single_9b_cdac_0.SW[3] 0.24207f
C5104 a_13053_19988# a_13621_20230# 0.18122f
C5105 a_12887_19988# a_13403_19988# 0.11182f
C5106 single_9b_cdac_0.cdac_sw_9b_0.S[5] single_9b_cdac_0.cdac_sw_9b_0.S[3] 0.97085f
C5107 sar9b_0.net37 a_13968_19988# 0.05908f
C5108 single_9b_cdac_1.cdac_sw_9b_0.cdac_sw_3_1.nooverlap_clk_0.x10.A single_9b_cdac_1.cdac_sw_9b_0.cdac_sw_3_1.tg_sw_3_3.SWN 0.69086f
C5109 VDPWR a_8653_27034# 0.21068f
C5110 single_9b_cdac_1.cdac_sw_9b_0.cdac_sw_3_5.tg_sw_3_3.SWP single_9b_cdac_1.cdac_sw_9b_0.cdac_sw_3_6.tg_sw_3_3.SWP 0.02666f
C5111 single_9b_cdac_1.SW[0] single_9b_cdac_1.SW[1] 18.7364f
C5112 a_12887_26516# a_13968_26516# 0.10236f
C5113 sar9b_0.net1 a_12947_26276# 0.02796f
C5114 a_13623_23252# sar9b_0.net12 0.04171f
C5115 a_10732_19810# a_10477_19450# 0.05639f
C5116 VDPWR sar9b_0.net43 1.25928f
C5117 a_13053_19450# single_9b_cdac_1.SW[2] 0.0144f
C5118 a_9687_19042# a_9843_19137# 0.10748f
C5119 a_9738_20240# sar9b_0.net41 0.01615f
C5120 single_9b_cdac_0.cdac_sw_9b_0.cdac_sw_3_3.tg_sw_3_3.SWP single_9b_cdac_0.cdac_sw_9b_0.cdac_sw_3_4.tg_sw_3_3.SWP 0.02652f
C5121 sar9b_0.net14 VDPWR 0.23328f
C5122 sar9b_0.net2 a_11376_18900# 0.01019f
C5123 single_9b_cdac_0.cdac_sw_9b_0.cdac_sw_3_6.nooverlap_clk_0.x8.A single_9b_cdac_1.CF[6] 0.31534f
C5124 a_13403_25428# a_12887_25428# 0.10748f
C5125 a_57946_26999# single_9b_cdac_0.cdac_sw_9b_0.cdac_sw_3_1.tg_sw_3_3.SWP 0.04592f
C5126 tdc_0.phase_detector_0.INN VDPWR 0.51155f
C5127 single_9b_cdac_0.cdac_sw_9b_0.cdac_sw_3_4.nooverlap_clk_0.x4.A single_9b_cdac_0.cdac_sw_9b_0.cdac_sw_3_4.nooverlap_clk_0.x3.Y 0.07517f
C5128 single_9b_cdac_1.SW[8] single_9b_cdac_1.SW[0] 0.02165f
C5129 ua[2] dw_12589_1395# 1.41142f
C5130 single_9b_cdac_0.cdac_sw_9b_0.cdac_sw_3_5.tg_sw_3_3.SWN single_9b_cdac_0.cdac_sw_9b_0.S[5] 0.84426f
C5131 sar9b_0.net30 single_9b_cdac_0.SW[3] 0.14924f
C5132 a_38738_16877# single_9b_cdac_1.cdac_sw_9b_0.cdac_sw_3_5.nooverlap_clk_0.CLKB0 0.23864f
C5133 a_10311_23252# a_10477_23252# 0.57407f
C5134 a_9635_24314# sar9b_0.net15 0.32028f
C5135 sar9b_0.net27 single_9b_cdac_1.CF[1] 0.08222f
C5136 sar9b_0.net15 a_12036_21076# 0.26162f
C5137 single_9b_cdac_0.cdac_sw_9b_0.cdac_sw_3_7.nooverlap_clk_0.x10.A single_9b_cdac_0.cdac_sw_9b_0.cdac_sw_3_7.tg_sw_3_3.SWN 0.69086f
C5138 a_12961_23802# sar9b_0.net1 0.31445f
C5139 single_9b_cdac_0.cdac_sw_9b_0.cdac_sw_3_0.nooverlap_clk_0.x8.A single_9b_cdac_0.cdac_sw_9b_0.cdac_sw_3_0.nooverlap_clk_0.x4.A 0.0303f
C5140 a_21368_4076# th_dif_sw_0.th_sw_1.CKB 0.06595f
C5141 sar9b_0.net3 a_9281_26516# 0.04055f
C5142 sar9b_0.net37 a_10055_20130# 0.03123f
C5143 sar9b_0.net39 a_13347_21620# 0.01163f
C5144 sar9b_0.net4 a_10055_20130# 0.03511f
C5145 sar9b_0.net15 a_9370_19152# 0.23913f
C5146 a_13511_26882# a_13053_26516# 0.03462f
C5147 single_9b_cdac_1.CF[7] single_9b_cdac_0.cdac_sw_9b_0.cdac_sw_3_7.nooverlap_clk_0.sky130_fd_sc_hs__inv_8_0.A 0.06019f
C5148 sar9b_0.net15 a_13511_22530# 0.02025f
C5149 single_9b_cdac_0.cdac_sw_9b_0.cdac_sw_3_4.nooverlap_clk_0.x3.Y single_9b_cdac_1.CF[3] 0.12898f
C5150 VDPWR a_14451_20532# 0.21369f
C5151 ua[0] a_21368_4076# 0.18413f
C5152 a_6631_24590# sar9b_0._03_ 0.09756f
C5153 a_13899_21620# a_12887_22164# 0.01008f
C5154 m2_23774_26966# single_9b_cdac_0.SW[8] 0.02037f
C5155 VDPWR single_9b_cdac_1.cdac_sw_9b_0.cdac_sw_3_2.nooverlap_clk_0.x10.A 0.95338f
C5156 sar9b_0.net10 a_10187_22138# 0.08173f
C5157 single_9b_cdac_1.cdac_sw_9b_0.cdac_sw_3_7.nooverlap_clk_0.x6.A single_9b_cdac_1.cdac_sw_9b_0.cdac_sw_3_7.nooverlap_clk_0.x4.A 0.12431f
C5158 single_9b_cdac_1.cdac_sw_9b_0.cdac_sw_3_7.nooverlap_clk_0.x1.A single_9b_cdac_1.cdac_sw_9b_0.cdac_sw_3_7.nooverlap_clk_0.x4.A 0.28523f
C5159 single_9b_cdac_0.cdac_sw_9b_0.cdac_sw_3_3.tg_sw_3_3.SWP single_9b_cdac_1.CF[5] 0.19143f
C5160 a_8340_27426# sar9b_0.net3 0.02735f
C5161 single_9b_cdac_0.cdac_sw_9b_0.cdac_sw_3_8.tg_sw_3_3.SWN single_9b_cdac_0.SW[7] 0.07852f
C5162 single_9b_cdac_1.cdac_sw_9b_0.cdac_sw_3_2.nooverlap_clk_0.x4.A single_9b_cdac_1.cdac_sw_9b_0.cdac_sw_3_2.nooverlap_clk_0.x3.Y 0.07517f
C5163 a_13308_19810# VDPWR 0.07683f
C5164 sar9b_0.net26 sar9b_0.net11 0.01972f
C5165 a_8803_19822# a_8899_19822# 0.01379f
C5166 single_9b_cdac_0.cdac_sw_9b_0.cdac_sw_3_2.nooverlap_clk_0.sky130_fd_sc_hs__nand2_1_0.Y a_65367_29911# 0.01076f
C5167 single_9b_cdac_0.cdac_sw_9b_0.cdac_sw_3_5.tg_sw_3_3.SWN single_9b_cdac_0.SW[4] 0.02589f
C5168 th_dif_sw_0.CKB th_dif_sw_0.VCP 0.21902f
C5169 VDPWR single_9b_cdac_0.cdac_sw_9b_0.cdac_sw_3_2.nooverlap_clk_0.sky130_fd_sc_hs__inv_1_1.A 0.38317f
C5170 single_9b_cdac_0.SW[2] single_9b_cdac_1.CF[5] 0.02008f
C5171 single_9b_cdac_1.CF[0] single_9b_cdac_1.cdac_sw_9b_0.cdac_sw_3_2.nooverlap_clk_0.x1.A 0.06503f
C5172 a_10845_25428# a_11413_25670# 0.17589f
C5173 a_10679_25428# a_11195_25428# 0.11082f
C5174 sar9b_0.clk_div_0.COUNT\[0\] a_6631_24590# 0.05008f
C5175 single_9b_cdac_0.SW[0] th_dif_sw_0.VCN 0.09453f
C5176 sar9b_0.net26 sar9b_0.net27 0.14852f
C5177 a_9115_26516# a_9281_26516# 0.67121f
C5178 a_5619_23252# a_6226_23364# 0.14145f
C5179 sar9b_0._02_ a_5785_23252# 0.17622f
C5180 sar9b_0._09_ a_6859_21710# 0.01763f
C5181 a_10679_25428# a_11100_25428# 0.09016f
C5182 sar9b_0.net15 a_9727_23226# 0.27766f
C5183 sar9b_0.net4 a_9460_24340# 0.04513f
C5184 single_9b_cdac_1.cdac_sw_9b_0.S[4] single_9b_cdac_1.cdac_sw_9b_0.cdac_sw_3_3.nooverlap_clk_0.CLK0 0.28813f
C5185 sar9b_0.net15 a_11689_23770# 0.17842f
C5186 sar9b_0.net34 a_14143_26490# 0.06269f
C5187 single_9b_cdac_1.cdac_sw_9b_0.S[8] single_9b_cdac_1.cdac_sw_9b_0.cdac_sw_3_8.nooverlap_clk_0.CLKB0 0.3601f
C5188 a_11392_23252# sar9b_0.net42 0.06519f
C5189 single_9b_cdac_0.cdac_sw_9b_0.cdac_sw_3_0.nooverlap_clk_0.x10.A single_9b_cdac_1.CF[2] 0.02149f
C5190 sar9b_0._00_ VDPWR 0.40171f
C5191 sar9b_0.net13 a_12887_26516# 0.24832f
C5192 uo_out[1] sar9b_0.FINAL 0.04701f
C5193 ua[0] single_9b_cdac_1.CF[4] 3.57685f
C5194 single_9b_cdac_0.cdac_sw_9b_0.cdac_sw_3_6.nooverlap_clk_0.sky130_fd_sc_hs__nand2_1_0.Y single_9b_cdac_0.cdac_sw_9b_0.cdac_sw_3_6.nooverlap_clk_0.x4.A 0.01751f
C5195 sar9b_0._13_ sar9b_0._04_ 0.01779f
C5196 single_9b_cdac_0.cdac_sw_9b_0.cdac_sw_3_1.tg_sw_3_3.SWN single_9b_cdac_0.cdac_sw_9b_0.cdac_sw_3_1.nooverlap_clk_0.CLK0 0.17533f
C5197 a_8358_23796# a_8273_23796# 0.03733f
C5198 single_9b_cdac_1.cdac_sw_9b_0.S[8] single_9b_cdac_1.CF[3] 0.01297f
C5199 single_9b_cdac_0.SW[0] single_9b_cdac_1.CF[0] 2.15297f
C5200 a_13053_19450# VDPWR 0.46004f
C5201 clk th_dif_sw_0.th_sw_1.CKB 0.0198f
C5202 sar9b_0.net31 single_9b_cdac_0.SW[6] 0.07216f
C5203 a_9115_21076# a_9536_21076# 0.09016f
C5204 a_9281_21076# a_10196_21076# 0.12532f
C5205 a_8545_25978# a_8800_26338# 0.06121f
C5206 single_9b_cdac_1.cdac_sw_9b_0.cdac_sw_3_7.nooverlap_clk_0.CLK0 single_9b_cdac_1.cdac_sw_9b_0.cdac_sw_3_7.tg_sw_3_3.SWN 0.17533f
C5207 sar9b_0.net15 a_12793_18330# 0.15943f
C5208 VDPWR single_9b_cdac_0.cdac_sw_9b_0.cdac_sw_3_3.nooverlap_clk_0.CLKB0 2.81428f
C5209 single_9b_cdac_0.cdac_sw_9b_0.S[4] a_43540_26999# 0.59531f
C5210 a_6319_25428# sar9b_0.net3 0.1583f
C5211 single_9b_cdac_1.cdac_sw_9b_0.S[7] single_9b_cdac_1.cdac_sw_9b_0.cdac_sw_3_7.nooverlap_clk_0.CLKB0 0.36044f
C5212 a_7055_26350# a_7151_26350# 0.01379f
C5213 a_13053_24890# a_13308_25250# 0.05936f
C5214 VDPWR single_9b_cdac_1.cdac_sw_9b_0.cdac_sw_3_2.nooverlap_clk_0.x4.A 0.62443f
C5215 sar9b_0._05_ a_8825_20532# 0.11958f
C5216 single_9b_cdac_1.cdac_sw_9b_0.cdac_sw_3_0.tg_sw_3_3.SWN single_9b_cdac_1.cdac_sw_9b_0.cdac_sw_3_0.nooverlap_clk_0.x10.A 0.69086f
C5217 single_9b_cdac_1.cdac_sw_9b_0.S[2] single_9b_cdac_1.SW[2] 0.22543f
C5218 single_9b_cdac_0.SW[6] single_9b_cdac_0.SW[4] 0.06514f
C5219 sar9b_0.net31 single_9b_cdac_0.SW[4] 0.38919f
C5220 a_8379_25978# sar9b_0.net40 0.6096f
C5221 single_9b_cdac_1.cdac_sw_9b_0.cdac_sw_3_6.nooverlap_clk_0.CLK0 VDPWR 2.71729f
C5222 single_9b_cdac_0.SW[6] single_9b_cdac_0.cdac_sw_9b_0.cdac_sw_3_7.tg_sw_3_3.SWP 0.03532f
C5223 sar9b_0.clk_div_0.COUNT\[2\] sar9b_0.net3 0.45353f
C5224 a_12887_25428# sar9b_0.net1 0.18538f
C5225 a_9460_26350# sar9b_0.net38 0.03338f
C5226 sar9b_0.clknet_1_0__leaf_CLK sar9b_0.net37 0.13202f
C5227 a_43540_16877# single_9b_cdac_1.SW[4] 0.28324f
C5228 single_9b_cdac_1.cdac_sw_9b_0.cdac_sw_3_1.nooverlap_clk_0.x4.A single_9b_cdac_1.cdac_sw_9b_0.cdac_sw_3_1.nooverlap_clk_0.x3.Y 0.07517f
C5229 a_7055_26350# a_6539_25978# 0.11082f
C5230 sar9b_0.clknet_1_1__leaf_CLK a_6610_22708# 0.03332f
C5231 sar9b_0._14_ a_7813_22316# 0.10572f
C5232 a_14451_23252# VDPWR 0.21825f
C5233 a_8545_24340# sar9b_0.net35 0.03566f
C5234 sar9b_0.net39 a_13403_22164# 0.02066f
C5235 sar9b_0.net38 a_6705_25978# 0.73097f
C5236 a_6539_25978# a_7273_25946# 0.05348f
C5237 sar9b_0._15_ sar9b_0._12_ 0.13667f
C5238 sar9b_0.net28 single_9b_cdac_0.SW[1] 0.10417f
C5239 a_12887_22164# a_12887_22714# 0.03658f
C5240 sar9b_0.net3 a_6539_25978# 0.39828f
C5241 VDPWR single_9b_cdac_0.cdac_sw_9b_0.cdac_sw_3_6.nooverlap_clk_0.CLKB0 2.81428f
C5242 sar9b_0.net21 VDPWR 0.20677f
C5243 sar9b_0.net15 a_9988_19266# 0.01491f
C5244 sar9b_0.clk_div_0.COUNT\[0\] sar9b_0.clknet_0_CLK 0.05929f
C5245 single_9b_cdac_0.SW[1] sar9b_0.net29 0.03346f
C5246 single_9b_cdac_1.cdac_sw_9b_0.cdac_sw_3_1.nooverlap_clk_0.x4.A VDPWR 0.62443f
C5247 a_6539_25978# sar9b_0.net19 0.02844f
C5248 single_9b_cdac_0.cdac_sw_9b_0.S[0] single_9b_cdac_0.cdac_sw_9b_0.cdac_sw_3_2.tg_sw_3_3.SWN 0.84427f
C5249 VDPWR a_17125_9355# 0.01057f
C5250 VDPWR a_8085_23802# 0.3089f
C5251 single_9b_cdac_0.SW[1] a_57946_26999# 0.28324f
C5252 single_9b_cdac_1.cdac_sw_9b_0.cdac_sw_3_7.tg_sw_3_3.SWN single_9b_cdac_1.cdac_sw_9b_0.cdac_sw_3_7.tg_sw_3_3.SWP 3.10626f
C5253 single_9b_cdac_0.cdac_sw_9b_0.cdac_sw_3_5.nooverlap_clk_0.x8.A single_9b_cdac_0.cdac_sw_9b_0.cdac_sw_3_5.nooverlap_clk_0.x10.A 0.42509f
C5254 single_9b_cdac_1.cdac_sw_9b_0.cdac_sw_3_3.tg_sw_3_3.SWP single_9b_cdac_1.cdac_sw_9b_0.cdac_sw_3_3.nooverlap_clk_0.CLKB0 1.71649f
C5255 a_5487_27034# sar9b_0.FINAL 0.01054f
C5256 a_12059_18362# sar9b_0.net6 0.46712f
C5257 a_6169_26758# a_6516_26516# 0.05116f
C5258 sar9b_0.net4 tdc_0.RDY 0.01821f
C5259 single_9b_cdac_0.cdac_sw_9b_0.cdac_sw_3_3.nooverlap_clk_0.CLK0 single_9b_cdac_0.SW[4] 0.24199f
C5260 tdc_0.phase_detector_0.INN tdc_0.phase_detector_0.pd_out_0.A 0.06563f
C5261 a_11121_18900# a_11471_18900# 0.21963f
C5262 a_10955_18900# a_12211_18874# 0.04357f
C5263 VDPWR sar9b_0.net32 0.43147f
C5264 a_13621_26758# a_13403_26516# 0.20964f
C5265 a_13053_26516# a_14143_26490# 0.04242f
C5266 sar9b_0._07_ a_6587_21852# 0.3369f
C5267 a_11857_25978# a_12947_26276# 0.04242f
C5268 a_12425_25946# a_12207_26350# 0.20964f
C5269 a_9335_20532# sar9b_0.clk_div_0.COUNT\[3\] 0.04692f
C5270 single_9b_cdac_1.cdac_sw_9b_0.cdac_sw_3_0.tg_sw_3_3.SWP single_9b_cdac_1.cdac_sw_9b_0.cdac_sw_3_4.tg_sw_3_3.SWP 0.02545f
C5271 a_8545_24340# a_9113_24582# 0.18639f
C5272 a_11121_21076# a_12211_21050# 0.04242f
C5273 a_11689_21318# a_11471_21076# 0.20964f
C5274 uo_out[1] VDPWR 0.43917f
C5275 single_9b_cdac_0.cdac_sw_9b_0.cdac_sw_3_1.nooverlap_clk_0.x10.A single_9b_cdac_0.cdac_sw_9b_0.cdac_sw_3_1.nooverlap_clk_0.sky130_fd_sc_hs__inv_8_0.A 0.05105f
C5276 a_12887_22164# a_13968_22164# 0.10236f
C5277 sar9b_0.net34 a_14451_27060# 0.23386f
C5278 single_9b_cdac_1.cdac_sw_9b_0.cdac_sw_3_3.nooverlap_clk_0.CLKB0 single_9b_cdac_1.cdac_sw_9b_0.cdac_sw_3_4.tg_sw_3_3.SWN 0.01173f
C5279 single_9b_cdac_1.cdac_sw_9b_0.cdac_sw_3_2.tg_sw_3_3.SWP a_62748_16877# 0.04592f
C5280 VDPWR single_9b_cdac_0.cdac_sw_9b_0.cdac_sw_3_7.nooverlap_clk_0.sky130_fd_sc_hs__inv_8_0.A 0.96901f
C5281 a_5973_23252# VDPWR 0.09219f
C5282 sar9b_0.net4 a_9115_21076# 0.26936f
C5283 a_10166_3438# a_10482_3438# 0.61926f
C5284 sar9b_0.net27 single_9b_cdac_1.CF[6] 0.06016f
C5285 a_11760_25428# sar9b_0.net15 0.25787f
C5286 single_9b_cdac_1.cdac_sw_9b_0.cdac_sw_3_3.tg_sw_3_3.SWN single_9b_cdac_1.cdac_sw_9b_0.cdac_sw_3_3.nooverlap_clk_0.CLKB0 0.22879f
C5287 sar9b_0.net4 a_8379_24340# 0.49554f
C5288 single_9b_cdac_1.cdac_sw_9b_0.cdac_sw_3_5.nooverlap_clk_0.x1.A single_9b_cdac_1.cdac_sw_9b_0.cdac_sw_3_5.nooverlap_clk_0.sky130_fd_sc_hs__nand2_1_0.Y 0.01003f
C5289 single_9b_cdac_1.cdac_sw_9b_0.cdac_sw_3_0.nooverlap_clk_0.CLKB0 single_9b_cdac_1.SW[0] 0.05632f
C5290 a_10311_19450# sar9b_0.net4 0.28283f
C5291 tdc_0.OUTP a_16159_13315# 0.05276f
C5292 clk a_8471_23252# 0.02833f
C5293 a_13403_22164# a_13308_22164# 0.04983f
C5294 a_13621_22406# a_13511_22530# 0.09774f
C5295 a_14143_22138# a_13968_22164# 0.23366f
C5296 tdc_0.RDY tdc_0.phase_detector_0.pd_out_0.B 0.0496f
C5297 sar9b_0.net10 sar9b_0.net43 0.91918f
C5298 a_6171_22714# a_7035_22708# 0.03036f
C5299 single_9b_cdac_1.cdac_sw_9b_0.cdac_sw_3_5.nooverlap_clk_0.x8.A single_9b_cdac_1.cdac_sw_9b_0.cdac_sw_3_5.nooverlap_clk_0.x6.A 0.11216f
C5300 a_10732_19810# VDPWR 0.07852f
C5301 single_9b_cdac_1.cdac_sw_9b_0.cdac_sw_3_5.nooverlap_clk_0.x8.A single_9b_cdac_1.cdac_sw_9b_0.cdac_sw_3_5.nooverlap_clk_0.x1.A 0.42784f
C5302 sar9b_0.net35 a_8637_23252# 0.02756f
C5303 single_9b_cdac_0.cdac_sw_9b_0.cdac_sw_3_4.nooverlap_clk_0.CLK0 single_9b_cdac_0.cdac_sw_9b_0.cdac_sw_3_4.nooverlap_clk_0.CLKB0 2.7611f
C5304 a_10477_23252# sar9b_0.net2 0.27835f
C5305 single_9b_cdac_1.cdac_sw_9b_0.cdac_sw_3_5.tg_sw_3_3.SWP single_9b_cdac_1.CF[6] 0.19147f
C5306 sar9b_0.net15 single_9b_cdac_1.CF[3] 0.04118f
C5307 single_9b_cdac_0.cdac_sw_9b_0.cdac_sw_3_0.tg_sw_3_3.SWP single_9b_cdac_1.CF[3] 0.18985f
C5308 single_9b_cdac_1.SW[8] a_13053_21076# 0.06011f
C5309 a_14143_21050# VDPWR 0.35114f
C5310 a_9536_21076# sar9b_0.net38 0.01316f
C5311 a_11231_20538# sar9b_0.net7 0.57073f
C5312 a_11045_24858# sar9b_0.net11 0.01919f
C5313 ua[0] th_dif_sw_0.CKB 0.02532f
C5314 single_9b_cdac_0.cdac_sw_9b_0.cdac_sw_3_6.nooverlap_clk_0.x8.A VDPWR 0.84061f
C5315 single_9b_cdac_0.cdac_sw_9b_0.cdac_sw_3_2.nooverlap_clk_0.x1.A single_9b_cdac_1.CF[0] 0.06503f
C5316 sar9b_0.net16 sar9b_0._10_ 0.128f
C5317 sar9b_0._00_ sar9b_0.net36 0.03032f
C5318 single_9b_cdac_1.cdac_sw_9b_0.S[2] VDPWR 4.14971f
C5319 single_9b_cdac_0.cdac_sw_9b_0.cdac_sw_3_0.nooverlap_clk_0.x1.A single_9b_cdac_0.cdac_sw_9b_0.cdac_sw_3_0.nooverlap_clk_0.x3.Y 0.07579f
C5320 a_10016_20256# a_10356_20354# 0.02761f
C5321 single_9b_cdac_1.CF[8] single_9b_cdac_0.SW[8] 1.89002f
C5322 a_6502_20124# sar9b_0.clknet_1_0__leaf_CLK 0.02612f
C5323 a_12887_18900# a_13621_19142# 0.0532f
C5324 a_11852_22164# a_11505_22406# 0.05116f
C5325 a_11192_22164# a_10937_22164# 0.05639f
C5326 single_9b_cdac_1.cdac_sw_9b_0.cdac_sw_3_8.tg_sw_3_3.SWP single_9b_cdac_1.cdac_sw_9b_0.cdac_sw_3_7.tg_sw_3_3.SWP 0.02666f
C5327 a_43540_16877# VDPWR 1.81495f
C5328 a_13403_23086# a_13499_23086# 0.01379f
C5329 a_9635_26276# VDPWR 0.35448f
C5330 a_9097_22164# sar9b_0.net15 0.03255f
C5331 single_9b_cdac_0.cdac_sw_9b_0.cdac_sw_3_7.nooverlap_clk_0.x6.A single_9b_cdac_0.cdac_sw_9b_0.cdac_sw_3_7.nooverlap_clk_0.x8.A 0.11216f
C5332 sar9b_0.net15 sar9b_0.net33 0.28705f
C5333 VDPWR single_9b_cdac_0.cdac_sw_9b_0.cdac_sw_3_4.nooverlap_clk_0.sky130_fd_sc_hs__inv_1_1.A 0.38702f
C5334 a_54032_26990# single_9b_cdac_0.cdac_sw_9b_0.S[2] 0.22367f
C5335 single_9b_cdac_1.cdac_sw_9b_0.cdac_sw_3_6.nooverlap_clk_0.x10.A single_9b_cdac_1.cdac_sw_9b_0.cdac_sw_3_6.nooverlap_clk_0.sky130_fd_sc_hs__inv_8_0.A 0.05105f
C5336 single_9b_cdac_0.SW[0] single_9b_cdac_1.CF[3] 0.40374f
C5337 ua[0] single_9b_cdac_0.cdac_sw_9b_0.cdac_sw_3_3.tg_sw_3_3.SWP 1.15121f
C5338 a_10371_21050# sar9b_0.net9 0.08644f
C5339 single_9b_cdac_1.SW[0] single_9b_cdac_1.cdac_sw_9b_0.cdac_sw_3_1.nooverlap_clk_0.CLKB0 0.05632f
C5340 sar9b_0.net2 sar9b_0.net35 0.74357f
C5341 sar9b_0.net37 sar9b_0.net5 0.0155f
C5342 a_5487_27034# VDPWR 0.3612f
C5343 sar9b_0.net4 sar9b_0.net5 0.92834f
C5344 sar9b_0.net41 a_13071_20532# 0.03498f
C5345 single_9b_cdac_1.SW[1] single_9b_cdac_1.CF[5] 0.22097f
C5346 sar9b_0.net15 a_8912_22824# 0.05836f
C5347 a_5803_25428# a_6884_25428# 0.10236f
C5348 sar9b_0.net15 a_13311_24174# 0.19301f
C5349 single_9b_cdac_0.cdac_sw_9b_0.cdac_sw_3_8.tg_sw_3_3.SWN single_9b_cdac_0.cdac_sw_9b_0.cdac_sw_3_7.tg_sw_3_3.SWN 0.02638f
C5350 a_9078_20506# sar9b_0.net4 0.02115f
C5351 a_9115_26516# a_9536_26516# 0.08671f
C5352 sar9b_0.net3 a_11579_26882# 0.03909f
C5353 single_9b_cdac_1.cdac_sw_9b_0.cdac_sw_3_6.nooverlap_clk_0.x8.A single_9b_cdac_1.cdac_sw_9b_0.cdac_sw_3_6.nooverlap_clk_0.sky130_fd_sc_hs__inv_8_0.A 0.04988f
C5354 sar9b_0.net15 a_14451_18356# 0.02204f
C5355 VDPWR single_9b_cdac_0.cdac_sw_9b_0.cdac_sw_3_0.nooverlap_clk_0.x3.Y 0.3196f
C5356 a_9849_26758# a_9631_26516# 0.20964f
C5357 single_9b_cdac_0.SW[7] a_29134_26999# 0.28324f
C5358 ua[0] single_9b_cdac_0.SW[2] 0.15413f
C5359 a_10196_21076# sar9b_0.net8 0.05849f
C5360 sar9b_0.net28 a_13968_22164# 0.02189f
C5361 sar9b_0.net25 a_12887_26516# 0.02671f
C5362 a_10482_3438# a_10254_2858# 0.11186f
C5363 single_9b_cdac_1.cdac_sw_9b_0.cdac_sw_3_5.nooverlap_clk_0.x4.A a_40321_15495# 0.01076f
C5364 a_6315_21050# sar9b_0._01_ 0.08194f
C5365 sar9b_0.net27 a_13621_22682# 0.0134f
C5366 single_9b_cdac_1.cdac_sw_9b_0.cdac_sw_3_5.nooverlap_clk_0.x10.A single_9b_cdac_1.CF[5] 0.02149f
C5367 a_9252_22708# a_9107_22682# 0.05722f
C5368 VDPWR a_9352_22164# 0.08228f
C5369 single_9b_cdac_1.cdac_sw_9b_0.cdac_sw_3_8.tg_sw_3_3.SWN single_9b_cdac_1.cdac_sw_9b_0.cdac_sw_3_8.nooverlap_clk_0.CLK0 0.17533f
C5370 single_9b_cdac_1.CF[5] sar9b_0.net13 0.05932f
C5371 sar9b_0.net22 a_10371_26490# 0.02339f
C5372 sar9b_0.net40 sar9b_0.net20 0.01749f
C5373 ua[2] th_dif_sw_0.th_sw_1.th_sw_main_0.VGS 0.93546f
C5374 single_9b_cdac_0.cdac_sw_9b_0.S[6] single_9b_cdac_0.cdac_sw_9b_0.cdac_sw_3_6.tg_sw_3_3.SWP 1.5604f
C5375 sar9b_0.net27 single_9b_cdac_1.SW[4] 0.05237f
C5376 a_11965_20506# a_11855_20532# 0.09774f
C5377 sar9b_0.net37 sar9b_0.net38 0.10317f
C5378 sar9b_0.net40 a_10477_23252# 0.02535f
C5379 sar9b_0.net4 sar9b_0.net38 0.41195f
C5380 sar9b_0.net27 single_9b_cdac_1.SW[2] 0.28359f
C5381 single_9b_cdac_0.cdac_sw_9b_0.cdac_sw_3_0.tg_sw_3_3.SWN single_9b_cdac_0.cdac_sw_9b_0.S[2] 0.84425f
C5382 single_9b_cdac_0.cdac_sw_9b_0.cdac_sw_3_1.nooverlap_clk_0.x8.A single_9b_cdac_1.CF[1] 0.31534f
C5383 single_9b_cdac_1.CF[8] single_9b_cdac_1.cdac_sw_9b_0.cdac_sw_3_8.nooverlap_clk_0.CLK0 0.42014f
C5384 single_9b_cdac_1.cdac_sw_9b_0.cdac_sw_3_6.nooverlap_clk_0.CLK0 single_9b_cdac_1.cdac_sw_9b_0.S[6] 0.26427f
C5385 single_9b_cdac_1.SW[0] single_9b_cdac_1.cdac_sw_9b_0.cdac_sw_3_1.nooverlap_clk_0.CLK0 0.03931f
C5386 single_9b_cdac_1.cdac_sw_9b_0.cdac_sw_3_3.nooverlap_clk_0.x1.A single_9b_cdac_1.cdac_sw_9b_0.cdac_sw_3_3.nooverlap_clk_0.sky130_fd_sc_hs__inv_8_0.A 0.45521f
C5387 sar9b_0.clk_div_0.COUNT\[1\] sar9b_0._03_ 0.49518f
C5388 single_9b_cdac_1.cdac_sw_9b_0.cdac_sw_3_0.nooverlap_clk_0.x6.A single_9b_cdac_1.cdac_sw_9b_0.cdac_sw_3_0.nooverlap_clk_0.x4.A 0.12431f
C5389 tdc_0.phase_detector_0.INP tdc_0.phase_detector_0.pd_out_0.B 0.06558f
C5390 a_8637_23252# a_9205_23494# 0.18639f
C5391 a_8471_23252# a_8987_23252# 0.11053f
C5392 a_5803_25428# sar9b_0.FINAL 0.606f
C5393 uo_out[3] ui_in[0] 0.06786f
C5394 sar9b_0._06_ a_7813_22316# 0.19332f
C5395 a_10196_21076# VDPWR 0.29454f
C5396 a_9167_18874# a_9687_19042# 0.04357f
C5397 a_12059_18362# a_12427_17812# 0.01107f
C5398 single_9b_cdac_0.cdac_sw_9b_0.cdac_sw_3_2.nooverlap_clk_0.CLKB0 single_9b_cdac_1.CF[0] 0.26707f
C5399 a_11045_24858# sar9b_0.net42 0.01808f
C5400 a_8379_25978# clk 0.02095f
C5401 VDPWR single_9b_cdac_0.cdac_sw_9b_0.cdac_sw_3_4.tg_sw_3_3.SWN 2.82222f
C5402 single_9b_cdac_0.cdac_sw_9b_0.cdac_sw_3_5.tg_sw_3_3.SWN single_9b_cdac_0.cdac_sw_9b_0.cdac_sw_3_6.nooverlap_clk_0.CLKB0 0.01152f
C5403 single_9b_cdac_1.CF[2] single_9b_cdac_1.cdac_sw_9b_0.cdac_sw_3_0.nooverlap_clk_0.sky130_fd_sc_hs__inv_8_0.A 0.06019f
C5404 single_9b_cdac_1.CF[4] single_9b_cdac_1.cdac_sw_9b_0.S[3] 0.01514f
C5405 single_9b_cdac_1.CF[7] single_9b_cdac_0.cdac_sw_9b_0.cdac_sw_3_7.nooverlap_clk_0.x8.A 0.31534f
C5406 a_8543_27060# VDPWR 0.1421f
C5407 VDPWR single_9b_cdac_0.cdac_sw_9b_0.cdac_sw_3_4.nooverlap_clk_0.x8.A 0.84042f
C5408 sar9b_0.net40 sar9b_0.net35 0.02541f
C5409 a_6674_21050# sar9b_0.net15 0.06667f
C5410 single_9b_cdac_1.CF[2] single_9b_cdac_1.cdac_sw_9b_0.cdac_sw_3_0.nooverlap_clk_0.x4.A 0.0313f
C5411 sar9b_0.clk_div_0.COUNT\[1\] sar9b_0.net35 0.0226f
C5412 single_9b_cdac_1.CF[8] single_9b_cdac_1.cdac_sw_9b_0.cdac_sw_3_8.nooverlap_clk_0.sky130_fd_sc_hs__inv_1_1.A 0.01887f
C5413 sar9b_0.clknet_1_1__leaf_CLK a_6149_23770# 1.88552f
C5414 sar9b_0.net27 a_13899_20532# 0.01526f
C5415 single_9b_cdac_1.cdac_sw_9b_0.cdac_sw_3_4.nooverlap_clk_0.CLK0 VDPWR 2.71729f
C5416 a_8085_27066# a_8435_27438# 0.21963f
C5417 a_6651_23520# sar9b_0.clk_div_0.COUNT\[0\] 0.09481f
C5418 VDPWR single_9b_cdac_1.cdac_sw_9b_0.cdac_sw_3_2.nooverlap_clk_0.x8.A 0.83441f
C5419 a_13053_24890# sar9b_0.net15 0.05746f
C5420 single_9b_cdac_0.cdac_sw_9b_0.cdac_sw_3_4.nooverlap_clk_0.CLK0 single_9b_cdac_1.CF[3] 0.42015f
C5421 single_9b_cdac_1.CF[4] single_9b_cdac_0.cdac_sw_9b_0.cdac_sw_3_3.nooverlap_clk_0.sky130_fd_sc_hs__inv_8_0.A 0.06019f
C5422 a_11397_20538# sar9b_0.net8 0.02556f
C5423 single_9b_cdac_0.cdac_sw_9b_0.cdac_sw_3_4.nooverlap_clk_0.sky130_fd_sc_hs__nand2_1_0.Y single_9b_cdac_0.cdac_sw_9b_0.cdac_sw_3_4.nooverlap_clk_0.x4.A 0.01751f
C5424 sar9b_0.net27 sar9b_0.net8 0.0364f
C5425 sar9b_0.clk_div_0.COUNT\[1\] sar9b_0.clk_div_0.COUNT\[0\] 1.16097f
C5426 VDPWR a_12211_18874# 0.3461f
C5427 sar9b_0.net2 a_9205_23494# 0.02243f
C5428 single_9b_cdac_0.SW[4] single_9b_cdac_0.cdac_sw_9b_0.cdac_sw_3_3.nooverlap_clk_0.CLKB0 0.36412f
C5429 a_10955_23802# a_11121_23802# 0.85587f
C5430 single_9b_cdac_1.cdac_sw_9b_0.cdac_sw_3_2.nooverlap_clk_0.CLKB0 a_62748_16877# 0.23864f
C5431 sar9b_0.net4 a_8800_24340# 0.0253f
C5432 dw_12589_1395# a_10482_3438# 0.05509f
C5433 single_9b_cdac_1.cdac_sw_9b_0.cdac_sw_3_0.tg_sw_3_3.SWP single_9b_cdac_1.CF[2] 0.10503f
C5434 clk single_9b_cdac_0.cdac_sw_9b_0.S[0] 0.03331f
C5435 single_9b_cdac_0.cdac_sw_9b_0.cdac_sw_3_4.nooverlap_clk_0.sky130_fd_sc_hs__nand2_1_0.Y single_9b_cdac_1.CF[3] 0.17948f
C5436 single_9b_cdac_0.cdac_sw_9b_0.cdac_sw_3_1.nooverlap_clk_0.x8.A single_9b_cdac_0.cdac_sw_9b_0.cdac_sw_3_1.nooverlap_clk_0.x4.A 0.0303f
C5437 single_9b_cdac_1.cdac_sw_9b_0.cdac_sw_3_0.nooverlap_clk_0.x10.A single_9b_cdac_1.cdac_sw_9b_0.cdac_sw_3_0.nooverlap_clk_0.x8.A 0.42509f
C5438 sar9b_0.net15 a_13621_25670# 0.18034f
C5439 ua[0] single_9b_cdac_0.cdac_sw_9b_0.cdac_sw_3_8.tg_sw_3_3.SWN 3.11836f
C5440 sar9b_0.net11 VDPWR 4.51062f
C5441 single_9b_cdac_0.cdac_sw_9b_0.cdac_sw_3_3.tg_sw_3_3.SWN single_9b_cdac_1.CF[5] 0.03488f
C5442 single_9b_cdac_0.SW[6] single_9b_cdac_0.cdac_sw_9b_0.cdac_sw_3_6.nooverlap_clk_0.CLKB0 0.36512f
C5443 single_9b_cdac_1.SW[8] a_13347_21620# 0.11464f
C5444 a_10055_20130# sar9b_0.net41 0.12362f
C5445 sar9b_0.net42 single_9b_cdac_1.SW[4] 0.01841f
C5446 a_57946_26999# single_9b_cdac_0.cdac_sw_9b_0.cdac_sw_3_1.nooverlap_clk_0.CLKB0 0.23864f
C5447 a_6171_22714# sar9b_0.clk_div_0.COUNT\[0\] 0.46169f
C5448 a_12059_18362# sar9b_0.net2 0.68615f
C5449 a_13623_21620# sar9b_0.net6 0.18463f
C5450 single_9b_cdac_1.cdac_sw_9b_0.cdac_sw_3_8.nooverlap_clk_0.x8.A single_9b_cdac_1.cdac_sw_9b_0.cdac_sw_3_8.nooverlap_clk_0.x4.A 0.0303f
C5451 a_11392_23252# sar9b_0.net15 0.24615f
C5452 VDPWR a_13403_18900# 0.20097f
C5453 sar9b_0.net42 single_9b_cdac_1.SW[2] 0.39824f
C5454 sar9b_0._15_ a_7345_21594# 0.03878f
C5455 sar9b_0.net11 a_13403_25262# 0.0311f
C5456 a_8545_25978# a_9460_26350# 0.12532f
C5457 a_10827_25262# a_10935_24884# 0.05722f
C5458 sar9b_0.net1 a_13071_21620# 0.02032f
C5459 a_8453_19450# VDPWR 0.25964f
C5460 single_9b_cdac_1.SW[0] single_9b_cdac_1.cdac_sw_9b_0.cdac_sw_3_7.nooverlap_clk_0.CLKB0 0.05632f
C5461 a_11689_26758# a_12036_26516# 0.05116f
C5462 a_11121_26516# a_11376_26516# 0.05639f
C5463 ua[1] th_dif_sw_0.th_sw_1.CK 0.42268f
C5464 single_9b_cdac_0.cdac_sw_9b_0.cdac_sw_3_3.nooverlap_clk_0.CLK0 single_9b_cdac_0.cdac_sw_9b_0.cdac_sw_3_3.nooverlap_clk_0.CLKB0 2.7611f
C5465 single_9b_cdac_1.cdac_sw_9b_0.cdac_sw_3_3.tg_sw_3_3.SWP single_9b_cdac_1.SW[0] 0.08409f
C5466 a_11397_20538# VDPWR 0.34248f
C5467 single_9b_cdac_1.cdac_sw_9b_0.cdac_sw_3_4.nooverlap_clk_0.x10.A single_9b_cdac_1.CF[3] 0.02149f
C5468 ua[2] w_12795_1601# 0.89427f
C5469 a_7059_21228# sar9b_0._08_ 0.02158f
C5470 sar9b_0.net27 VDPWR 0.66634f
C5471 a_5803_25428# VDPWR 0.52002f
C5472 a_13053_19450# a_13053_18900# 0.02763f
C5473 single_9b_cdac_1.cdac_sw_9b_0.cdac_sw_3_8.tg_sw_3_3.SWN single_9b_cdac_1.cdac_sw_9b_0.S[8] 0.8438f
C5474 sar9b_0.net42 sar9b_0.FINAL 0.08041f
C5475 sar9b_0.net15 a_10211_20225# 0.18133f
C5476 single_9b_cdac_1.cdac_sw_9b_0.S[2] single_9b_cdac_1.cdac_sw_9b_0.S[6] 0.24885f
C5477 a_12795_23802# a_13216_24162# 0.08264f
C5478 single_9b_cdac_0.SW[6] sar9b_0.net32 0.09883f
C5479 sar9b_0.net31 sar9b_0.net32 0.06517f
C5480 tdc_0.phase_detector_0.pd_out_0.B a_15052_11404# 0.18949f
C5481 VDPWR single_9b_cdac_0.cdac_sw_9b_0.cdac_sw_3_5.nooverlap_clk_0.x3.Y 0.3196f
C5482 single_9b_cdac_0.cdac_sw_9b_0.cdac_sw_3_2.tg_sw_3_3.SWP single_9b_cdac_1.CF[0] 0.10499f
C5483 uo_out[7] sar9b_0.FINAL 0.05745f
C5484 single_9b_cdac_1.cdac_sw_9b_0.cdac_sw_3_5.tg_sw_3_3.SWP VDPWR 3.27833f
C5485 single_9b_cdac_1.cdac_sw_9b_0.cdac_sw_3_1.tg_sw_3_3.SWN single_9b_cdac_1.cdac_sw_9b_0.cdac_sw_3_1.tg_sw_3_3.SWP 3.10626f
C5486 a_6525_22708# VDPWR 0.07264f
C5487 single_9b_cdac_1.CF[2] single_9b_cdac_1.cdac_sw_9b_0.cdac_sw_3_1.tg_sw_3_3.SWP 0.19325f
C5488 sar9b_0._13_ a_6219_22316# 0.2695f
C5489 single_9b_cdac_1.cdac_sw_9b_0.S[5] single_9b_cdac_1.cdac_sw_9b_0.S[0] 0.33259f
C5490 single_9b_cdac_1.SW[0] single_9b_cdac_1.cdac_sw_9b_0.cdac_sw_3_4.tg_sw_3_3.SWN 0.12586f
C5491 single_9b_cdac_0.SW[4] sar9b_0.net32 0.03943f
C5492 sar9b_0.net23 uo_out[3] 0.07404f
C5493 single_9b_cdac_1.cdac_sw_9b_0.cdac_sw_3_1.nooverlap_clk_0.x10.A single_9b_cdac_1.cdac_sw_9b_0.cdac_sw_3_1.nooverlap_clk_0.sky130_fd_sc_hs__inv_8_0.A 0.05105f
C5494 a_13899_23252# sar9b_0.net11 0.19511f
C5495 single_9b_cdac_1.cdac_sw_9b_0.cdac_sw_3_3.tg_sw_3_3.SWN single_9b_cdac_1.SW[0] 0.12586f
C5496 single_9b_cdac_1.cdac_sw_9b_0.cdac_sw_3_4.nooverlap_clk_0.CLK0 single_9b_cdac_1.cdac_sw_9b_0.cdac_sw_3_4.nooverlap_clk_0.CLKB0 2.7611f
C5497 a_10311_24890# a_10827_25262# 0.11535f
C5498 sar9b_0.net42 a_13899_20532# 0.03383f
C5499 a_16185_13034# VDPWR 0.19332f
C5500 a_13621_20230# a_13403_19988# 0.20964f
C5501 a_13053_19988# a_14143_19962# 0.04242f
C5502 a_12887_19988# a_13968_19988# 0.10236f
C5503 sar9b_0.net37 a_13511_20354# 0.02656f
C5504 single_9b_cdac_0.SW[0] single_9b_cdac_1.CF[1] 0.32684f
C5505 a_13511_19266# a_13621_19142# 0.09774f
C5506 a_38738_26999# single_9b_cdac_0.cdac_sw_9b_0.cdac_sw_3_5.tg_sw_3_3.SWP 0.04592f
C5507 single_9b_cdac_0.cdac_sw_9b_0.cdac_sw_3_1.nooverlap_clk_0.x6.A single_9b_cdac_0.cdac_sw_9b_0.cdac_sw_3_1.nooverlap_clk_0.x1.A 0.03729f
C5508 sar9b_0.net42 sar9b_0.net8 0.05045f
C5509 VDPWR a_9175_27364# 0.34491f
C5510 single_9b_cdac_1.CF[4] single_9b_cdac_0.SW[1] 0.02005f
C5511 a_6226_23364# a_6149_23770# 0.01097f
C5512 a_14175_23252# sar9b_0.net12 0.20112f
C5513 single_9b_cdac_0.cdac_sw_9b_0.cdac_sw_3_4.nooverlap_clk_0.x1.A single_9b_cdac_0.cdac_sw_9b_0.cdac_sw_3_4.nooverlap_clk_0.sky130_fd_sc_hs__inv_1_1.A 0.10429f
C5514 a_13899_23252# sar9b_0.net27 0.01532f
C5515 sar9b_0.clknet_1_0__leaf_CLK sar9b_0._01_ 0.12375f
C5516 single_9b_cdac_1.cdac_sw_9b_0.cdac_sw_3_0.nooverlap_clk_0.CLKB0 single_9b_cdac_1.cdac_sw_9b_0.cdac_sw_3_0.nooverlap_clk_0.CLK0 2.7611f
C5517 a_9843_19137# a_9774_19266# 0.20964f
C5518 ua[0] single_9b_cdac_1.SW[1] 0.15672f
C5519 sar9b_0._10_ VDPWR 1.19531f
C5520 a_11121_21076# a_10955_21076# 0.87837f
C5521 single_9b_cdac_0.cdac_sw_9b_0.cdac_sw_3_5.tg_sw_3_3.SWP single_9b_cdac_1.CF[6] 0.19143f
C5522 a_13403_25428# a_13621_25670# 0.20964f
C5523 a_13968_25428# a_12887_25428# 0.10236f
C5524 a_14143_25402# a_13053_25428# 0.04242f
C5525 a_6943_22316# sar9b_0._13_ 0.03557f
C5526 single_9b_cdac_1.cdac_sw_9b_0.cdac_sw_3_1.nooverlap_clk_0.x10.A single_9b_cdac_1.CF[1] 0.02149f
C5527 clk single_9b_cdac_0.SW[1] 0.08259f
C5528 single_9b_cdac_1.cdac_sw_9b_0.cdac_sw_3_6.nooverlap_clk_0.CLKB0 single_9b_cdac_1.cdac_sw_9b_0.cdac_sw_3_5.tg_sw_3_3.SWN 0.01175f
C5529 a_6219_22316# sar9b_0._09_ 0.16195f
C5530 a_10311_23252# a_10827_23252# 0.10591f
C5531 a_10477_23252# a_11045_23494# 0.17194f
C5532 sar9b_0.net26 sar9b_0.net15 0.07817f
C5533 sar9b_0.net15 a_11579_21442# 0.01969f
C5534 a_14451_23252# a_14143_23012# 0.01246f
C5535 single_9b_cdac_1.cdac_sw_9b_0.S[1] single_9b_cdac_1.cdac_sw_9b_0.cdac_sw_3_1.tg_sw_3_3.SWP 1.55942f
C5536 single_9b_cdac_0.cdac_sw_9b_0.cdac_sw_3_7.nooverlap_clk_0.x6.A single_9b_cdac_0.cdac_sw_9b_0.cdac_sw_3_7.nooverlap_clk_0.x1.A 0.03729f
C5537 a_7809_23028# sar9b_0._12_ 0.01172f
C5538 a_18214_3039# th_dif_sw_0.th_sw_1.CKB 0.42927f
C5539 a_12683_18356# VDPWR 0.13232f
C5540 single_9b_cdac_1.cdac_sw_9b_0.cdac_sw_3_4.nooverlap_clk_0.sky130_fd_sc_hs__inv_1_1.A single_9b_cdac_1.cdac_sw_9b_0.cdac_sw_3_4.nooverlap_clk_0.sky130_fd_sc_hs__nand2_1_0.Y 0.12223f
C5541 ua[0] single_9b_cdac_1.SW[8] 0.13942f
C5542 sar9b_0.net37 a_10142_20354# 0.01842f
C5543 single_9b_cdac_0.cdac_sw_9b_0.cdac_sw_3_1.nooverlap_clk_0.CLKB0 single_9b_cdac_0.cdac_sw_9b_0.cdac_sw_3_2.tg_sw_3_3.SWN 0.01152f
C5544 a_13511_26882# a_13403_26516# 0.05722f
C5545 sar9b_0.net3 a_6059_26882# 0.0122f
C5546 a_9447_22164# a_9555_22530# 0.05722f
C5547 single_9b_cdac_0.cdac_sw_9b_0.cdac_sw_3_0.tg_sw_3_3.SWN single_9b_cdac_1.CF[2] 0.12367f
C5548 VDPWR single_9b_cdac_0.SW[8] 2.39266f
C5549 sar9b_0.net10 a_9352_22164# 0.01432f
C5550 a_7039_22138# sar9b_0.net3 0.02074f
C5551 single_9b_cdac_0.cdac_sw_9b_0.cdac_sw_3_4.tg_sw_3_3.SWN single_9b_cdac_0.cdac_sw_9b_0.S[3] 0.84427f
C5552 single_9b_cdac_1.cdac_sw_9b_0.cdac_sw_3_0.tg_sw_3_3.SWP a_53154_16877# 0.04592f
C5553 VDPWR sar9b_0.net42 2.96501f
C5554 a_8471_23252# a_8951_22950# 0.01704f
C5555 sar9b_0.net37 a_6337_22714# 0.03599f
C5556 uio_out[1] sar9b_0.FINAL 0.0389f
C5557 ua[0] single_9b_cdac_0.cdac_sw_9b_0.cdac_sw_3_0.nooverlap_clk_0.CLKB0 0.12378f
C5558 VDPWR single_9b_cdac_0.cdac_sw_9b_0.cdac_sw_3_7.nooverlap_clk_0.x8.A 0.84061f
C5559 a_14451_21620# a_14143_22138# 0.01246f
C5560 a_14451_27060# uo_out[0] 0.13482f
C5561 a_6308_27060# sar9b_0.net3 0.0122f
C5562 uo_out[7] VDPWR 0.70321f
C5563 sar9b_0.net26 single_9b_cdac_0.SW[0] 0.10273f
C5564 a_6943_22316# sar9b_0._09_ 0.01276f
C5565 single_9b_cdac_0.SW[5] a_14175_25972# 0.11062f
C5566 a_6061_19988# VDPWR 0.27648f
C5567 single_9b_cdac_1.cdac_sw_9b_0.cdac_sw_3_6.nooverlap_clk_0.sky130_fd_sc_hs__nand2_1_0.Y single_9b_cdac_1.cdac_sw_9b_0.cdac_sw_3_6.nooverlap_clk_0.x4.A 0.01751f
C5568 ui_in[5] ui_in[4] 0.03102f
C5569 sar9b_0._12_ sar9b_0.net35 0.01261f
C5570 sar9b_0.clk_div_0.COUNT\[2\] sar9b_0._13_ 0.01699f
C5571 sar9b_0.net37 single_9b_cdac_1.SW[5] 0.0123f
C5572 a_13053_21076# sar9b_0.net5 0.02966f
C5573 sar9b_0.net37 single_9b_cdac_1.SW[3] 0.05725f
C5574 a_13053_19450# a_13308_19810# 0.05884f
C5575 a_16331_9671# th_dif_sw_0.VCP 0.10881f
C5576 sar9b_0._12_ sar9b_0.clk_div_0.COUNT\[0\] 0.2508f
C5577 sar9b_0.net2 a_10937_22164# 0.03337f
C5578 a_13621_21318# sar9b_0.net27 0.01158f
C5579 a_13053_22714# a_12887_22714# 0.88768f
C5580 tdc_0.RDY a_7735_17812# 0.24396f
C5581 single_9b_cdac_1.cdac_sw_9b_0.cdac_sw_3_0.tg_sw_3_3.SWN single_9b_cdac_1.cdac_sw_9b_0.cdac_sw_3_1.tg_sw_3_3.SWN 0.02784f
C5582 a_10845_25428# a_11935_25402# 0.04251f
C5583 a_10679_25428# a_11760_25428# 0.10236f
C5584 a_11413_25670# a_11195_25428# 0.20964f
C5585 sar9b_0.net15 a_9665_22406# 0.16188f
C5586 a_7919_27066# sar9b_0.net39 0.61755f
C5587 single_9b_cdac_1.cdac_sw_9b_0.cdac_sw_3_0.tg_sw_3_3.SWN single_9b_cdac_1.CF[2] 0.12367f
C5588 single_9b_cdac_0.cdac_sw_9b_0.cdac_sw_3_2.nooverlap_clk_0.x8.A single_9b_cdac_1.CF[0] 0.31534f
C5589 clk a_7919_27066# 0.02936f
C5590 a_10845_25428# a_11303_25794# 0.03462f
C5591 sar9b_0.net2 a_8634_22840# 0.02326f
C5592 single_9b_cdac_1.cdac_sw_9b_0.cdac_sw_3_3.nooverlap_clk_0.sky130_fd_sc_hs__inv_8_0.A VDPWR 0.969f
C5593 a_5803_25428# sar9b_0.net36 0.01443f
C5594 sar9b_0.net15 a_12211_24100# 0.32261f
C5595 single_9b_cdac_1.cdac_sw_9b_0.cdac_sw_3_5.nooverlap_clk_0.sky130_fd_sc_hs__inv_8_0.A VDPWR 0.96907f
C5596 single_9b_cdac_0.cdac_sw_9b_0.cdac_sw_3_4.nooverlap_clk_0.x1.A single_9b_cdac_0.cdac_sw_9b_0.cdac_sw_3_4.nooverlap_clk_0.x8.A 0.42784f
C5597 clk sar9b_0.net35 2.02887f
C5598 dw_17224_1400# a_21368_4076# 26.7687f
C5599 single_9b_cdac_1.cdac_sw_9b_0.cdac_sw_3_6.nooverlap_clk_0.x10.A single_9b_cdac_1.CF[6] 0.02149f
C5600 th_dif_sw_0.th_sw_0.th_sw_main_0.VGS a_21368_4076# 1.16212f
C5601 sar9b_0.net14 uo_out[1] 0.30907f
C5602 a_9115_21076# sar9b_0.net41 0.03054f
C5603 sar9b_0.net39 a_12887_22714# 0.03872f
C5604 single_9b_cdac_0.cdac_sw_9b_0.cdac_sw_3_6.nooverlap_clk_0.x8.A single_9b_cdac_0.cdac_sw_9b_0.cdac_sw_3_6.nooverlap_clk_0.x1.A 0.42784f
C5605 VDPWR a_13308_25250# 0.07776f
C5606 single_9b_cdac_0.cdac_sw_9b_0.cdac_sw_3_6.tg_sw_3_3.SWN single_9b_cdac_0.cdac_sw_9b_0.cdac_sw_3_6.tg_sw_3_3.SWP 3.10626f
C5607 a_13053_24890# sar9b_0.net1 0.26181f
C5608 a_13403_19822# VDPWR 0.19818f
C5609 single_9b_cdac_1.CF[2] a_14143_22138# 0.01524f
C5610 a_9281_21076# a_9739_21442# 0.03462f
C5611 a_8895_26350# a_8800_26338# 0.04983f
C5612 single_9b_cdac_1.cdac_sw_9b_0.cdac_sw_3_8.nooverlap_clk_0.CLK0 VDPWR 2.71729f
C5613 sar9b_0.net15 a_13315_18660# 0.29548f
C5614 single_9b_cdac_0.cdac_sw_9b_0.cdac_sw_3_8.nooverlap_clk_0.x1.A single_9b_cdac_0.cdac_sw_9b_0.cdac_sw_3_8.nooverlap_clk_0.sky130_fd_sc_hs__nand2_1_0.Y 0.01003f
C5615 a_6884_25428# sar9b_0.net3 0.27122f
C5616 single_9b_cdac_1.cdac_sw_9b_0.cdac_sw_3_0.nooverlap_clk_0.CLK0 single_9b_cdac_1.cdac_sw_9b_0.cdac_sw_3_1.nooverlap_clk_0.CLK0 0.02778f
C5617 a_13403_25262# a_13308_25250# 0.04983f
C5618 a_6651_23520# a_6483_23618# 0.31086f
C5619 single_9b_cdac_1.CF[7] single_9b_cdac_0.cdac_sw_9b_0.cdac_sw_3_7.nooverlap_clk_0.x1.A 0.06503f
C5620 single_9b_cdac_0.SW[0] single_9b_cdac_1.CF[8] 3.60709f
C5621 single_9b_cdac_1.cdac_sw_9b_0.cdac_sw_3_6.nooverlap_clk_0.x8.A single_9b_cdac_1.CF[6] 0.31534f
C5622 sar9b_0.net15 a_9281_21076# 0.02511f
C5623 single_9b_cdac_1.CF[0] sar9b_0.net6 0.10852f
C5624 a_12887_19450# a_13621_19418# 0.07009f
C5625 a_5884_21326# VDPWR 0.31828f
C5626 a_6061_19988# a_6249_19988# 0.15681f
C5627 ua[3] VGND 0.11661f
C5628 ua[4] VGND 0.11661f
C5629 ua[5] VGND 0.14595f
C5630 ua[6] VGND 0.14595f
C5631 ua[7] VGND 0.14595f
C5632 ena VGND 0.06982f
C5633 rst_n VGND 0.04231f
C5634 ui_in[1] VGND 0.04231f
C5635 ui_in[2] VGND 0.04231f
C5636 ui_in[3] VGND 0.04231f
C5637 ui_in[4] VGND 0.04231f
C5638 ui_in[5] VGND 0.04231f
C5639 ui_in[6] VGND 0.04231f
C5640 ui_in[7] VGND 0.04231f
C5641 uio_in[0] VGND 0.04231f
C5642 uio_in[1] VGND 0.04231f
C5643 uio_in[2] VGND 0.04231f
C5644 uio_in[3] VGND 0.04231f
C5645 uio_in[4] VGND 0.04231f
C5646 uio_in[5] VGND 0.04231f
C5647 uio_in[6] VGND 0.04231f
C5648 uio_in[7] VGND 0.04264f
C5649 ua[1] VGND 15.5682f
C5650 ua[2] VGND 15.5235f
C5651 clk VGND 26.0568f
C5652 uio_out[1] VGND 7.04062f
C5653 ui_in[0] VGND 16.1787f
C5654 uo_out[6] VGND 4.21959f
C5655 uio_out[0] VGND 4.58943f
C5656 uo_out[0] VGND 5.29725f
C5657 uo_out[1] VGND 3.97102f
C5658 uo_out[2] VGND 4.29528f
C5659 uo_out[3] VGND 4.04401f
C5660 uo_out[4] VGND 4.18629f
C5661 uo_out[5] VGND 4.18453f
C5662 uo_out[7] VGND 4.51901f
C5663 ua[0] VGND 0.11804p
C5664 VDPWR VGND 1.01256p
C5665 m2_23774_17236# VGND 0.24462f
C5666 m2_23774_26966# VGND 0.24462f
C5667 a_18214_3039# VGND 1.49705f $ **FLOATING
C5668 a_21684_3438# VGND 4.00493f $ **FLOATING
C5669 a_21368_4076# VGND 15.553f $ **FLOATING
C5670 a_10254_2858# VGND 1.4958f $ **FLOATING
C5671 th_dif_sw_0.th_sw_0.th_sw_main_0.VGS VGND 3.32878f $ **FLOATING
C5672 th_dif_sw_0.th_sw_1.th_sw_main_0.VGS VGND 3.32496f $ **FLOATING
C5673 a_10482_3438# VGND 4.00493f $ **FLOATING
C5674 a_10166_3438# VGND 16.0496f $ **FLOATING
C5675 th_dif_sw_0.th_sw_1.CKB VGND 8.08199f $ **FLOATING
C5676 th_dif_sw_0.th_sw_1.CK VGND 9.07818f $ **FLOATING
C5677 a_21177_7457# VGND 2.80515f $ **FLOATING
C5678 a_9132_7271# VGND 2.80492f $ **FLOATING
C5679 a_17125_9355# VGND 0.09476f $ **FLOATING
C5680 a_14897_9355# VGND 0.09476f $ **FLOATING
C5681 th_dif_sw_0.VCP VGND 56.3091f $ **FLOATING
C5682 th_dif_sw_0.VCN VGND 68.2286f $ **FLOATING
C5683 a_16357_9613# VGND 0.05938f $ **FLOATING
C5684 a_15265_9613# VGND 0.05938f $ **FLOATING
C5685 a_16331_9671# VGND 0.82151f $ **FLOATING
C5686 a_14871_9671# VGND 0.82187f $ **FLOATING
C5687 tdc_0.delay_gate_ori_1.sky130_fd_sc_hs__and2_1_0.A VGND 0.66688f $ **FLOATING
C5688 a_16881_10256# VGND 0.01123f $ **FLOATING
C5689 tdc_0.delay_gate_ori_0.sky130_fd_sc_hs__and2_1_0.A VGND 0.66603f $ **FLOATING
C5690 a_15197_10290# VGND 0.01123f $ **FLOATING
C5691 a_16527_10454# VGND 0.18095f $ **FLOATING
C5692 a_15151_10456# VGND 0.18103f $ **FLOATING
C5693 a_16222_11316# VGND 0.04271f $ **FLOATING
C5694 a_15400_11316# VGND 0.04271f $ **FLOATING
C5695 tdc_0.phase_detector_0.INP VGND 1.24598f $ **FLOATING
C5696 tdc_0.phase_detector_0.INN VGND 1.87249f $ **FLOATING
C5697 a_16970_11404# VGND 0.20846f $ **FLOATING
C5698 a_15052_11404# VGND 0.20846f $ **FLOATING
C5699 tdc_0.phase_detector_0.pd_out_0.A VGND 2.40659f $ **FLOATING
C5700 tdc_0.phase_detector_0.pd_out_0.B VGND 1.65957f $ **FLOATING
C5701 a_16159_13315# VGND 0.26136f $ **FLOATING
C5702 single_9b_cdac_1.cdac_sw_9b_0.cdac_sw_3_2.nooverlap_clk_0.x3.Y VGND 0.35827f $ **FLOATING
C5703 single_9b_cdac_1.cdac_sw_9b_0.cdac_sw_3_2.nooverlap_clk_0.sky130_fd_sc_hs__nand2_1_0.Y VGND 0.41378f $ **FLOATING
C5704 single_9b_cdac_1.cdac_sw_9b_0.cdac_sw_3_2.nooverlap_clk_0.x4.A VGND 0.42464f $ **FLOATING
C5705 single_9b_cdac_1.cdac_sw_9b_0.cdac_sw_3_2.nooverlap_clk_0.sky130_fd_sc_hs__inv_1_1.A VGND 0.45426f $ **FLOATING
C5706 single_9b_cdac_1.cdac_sw_9b_0.cdac_sw_3_2.nooverlap_clk_0.x6.A VGND 0.47224f $ **FLOATING
C5707 single_9b_cdac_1.cdac_sw_9b_0.cdac_sw_3_2.nooverlap_clk_0.x1.A VGND 1.60512f $ **FLOATING
C5708 single_9b_cdac_1.cdac_sw_9b_0.cdac_sw_3_2.nooverlap_clk_0.x8.A VGND 1.57322f $ **FLOATING
C5709 single_9b_cdac_1.cdac_sw_9b_0.cdac_sw_3_2.nooverlap_clk_0.sky130_fd_sc_hs__inv_8_0.A VGND 1.39423f $ **FLOATING
C5710 single_9b_cdac_1.cdac_sw_9b_0.cdac_sw_3_2.nooverlap_clk_0.x10.A VGND 1.39185f $ **FLOATING
C5711 a_63626_17740# VGND 0.89497f $ **FLOATING
C5712 single_9b_cdac_1.cdac_sw_9b_0.cdac_sw_3_2.nooverlap_clk_0.CLK0 VGND 2.68117f $ **FLOATING
C5713 single_9b_cdac_1.cdac_sw_9b_0.cdac_sw_3_1.nooverlap_clk_0.x3.Y VGND 0.35827f $ **FLOATING
C5714 single_9b_cdac_1.cdac_sw_9b_0.cdac_sw_3_1.nooverlap_clk_0.sky130_fd_sc_hs__nand2_1_0.Y VGND 0.40523f $ **FLOATING
C5715 single_9b_cdac_1.cdac_sw_9b_0.cdac_sw_3_1.nooverlap_clk_0.x4.A VGND 0.42464f $ **FLOATING
C5716 single_9b_cdac_1.cdac_sw_9b_0.cdac_sw_3_1.nooverlap_clk_0.sky130_fd_sc_hs__inv_1_1.A VGND 0.44898f $ **FLOATING
C5717 single_9b_cdac_1.cdac_sw_9b_0.cdac_sw_3_1.nooverlap_clk_0.x6.A VGND 0.47224f $ **FLOATING
C5718 single_9b_cdac_1.cdac_sw_9b_0.cdac_sw_3_2.nooverlap_clk_0.CLKB0 VGND 3.19276f $ **FLOATING
C5719 a_62748_16877# VGND 0.16243f $ **FLOATING
C5720 single_9b_cdac_1.cdac_sw_9b_0.cdac_sw_3_1.nooverlap_clk_0.x1.A VGND 1.58505f $ **FLOATING
C5721 single_9b_cdac_1.cdac_sw_9b_0.cdac_sw_3_1.nooverlap_clk_0.x8.A VGND 1.56079f $ **FLOATING
C5722 single_9b_cdac_1.cdac_sw_9b_0.cdac_sw_3_2.tg_sw_3_3.SWP VGND 4.52812f $ **FLOATING
C5723 single_9b_cdac_1.cdac_sw_9b_0.S[0] VGND 94.02351f $ **FLOATING
C5724 single_9b_cdac_1.cdac_sw_9b_0.cdac_sw_3_1.nooverlap_clk_0.sky130_fd_sc_hs__inv_8_0.A VGND 1.37294f $ **FLOATING
C5725 single_9b_cdac_1.cdac_sw_9b_0.cdac_sw_3_1.nooverlap_clk_0.x10.A VGND 1.39185f $ **FLOATING
C5726 single_9b_cdac_1.cdac_sw_9b_0.cdac_sw_3_2.tg_sw_3_3.SWN VGND 6.36367f $ **FLOATING
C5727 a_58824_17740# VGND 0.89548f $ **FLOATING
C5728 single_9b_cdac_1.cdac_sw_9b_0.cdac_sw_3_1.nooverlap_clk_0.CLK0 VGND 2.66663f $ **FLOATING
C5729 single_9b_cdac_1.cdac_sw_9b_0.cdac_sw_3_0.nooverlap_clk_0.x3.Y VGND 0.35827f $ **FLOATING
C5730 single_9b_cdac_1.cdac_sw_9b_0.cdac_sw_3_0.nooverlap_clk_0.sky130_fd_sc_hs__nand2_1_0.Y VGND 0.405f $ **FLOATING
C5731 single_9b_cdac_1.cdac_sw_9b_0.cdac_sw_3_0.nooverlap_clk_0.x4.A VGND 0.42464f $ **FLOATING
C5732 single_9b_cdac_1.cdac_sw_9b_0.cdac_sw_3_0.nooverlap_clk_0.sky130_fd_sc_hs__inv_1_1.A VGND 0.44881f $ **FLOATING
C5733 single_9b_cdac_1.cdac_sw_9b_0.cdac_sw_3_0.nooverlap_clk_0.x6.A VGND 0.47224f $ **FLOATING
C5734 single_9b_cdac_1.cdac_sw_9b_0.cdac_sw_3_1.nooverlap_clk_0.CLKB0 VGND 3.16257f $ **FLOATING
C5735 a_57946_16877# VGND 0.16243f $ **FLOATING
C5736 single_9b_cdac_1.cdac_sw_9b_0.cdac_sw_3_0.nooverlap_clk_0.x1.A VGND 1.58431f $ **FLOATING
C5737 single_9b_cdac_1.cdac_sw_9b_0.cdac_sw_3_0.nooverlap_clk_0.x8.A VGND 1.56057f $ **FLOATING
C5738 single_9b_cdac_1.cdac_sw_9b_0.cdac_sw_3_1.tg_sw_3_3.SWP VGND 4.51086f $ **FLOATING
C5739 single_9b_cdac_1.cdac_sw_9b_0.S[1] VGND 47.9705f $ **FLOATING
C5740 single_9b_cdac_1.cdac_sw_9b_0.cdac_sw_3_0.nooverlap_clk_0.sky130_fd_sc_hs__inv_8_0.A VGND 1.37225f $ **FLOATING
C5741 single_9b_cdac_1.cdac_sw_9b_0.cdac_sw_3_0.nooverlap_clk_0.x10.A VGND 1.39185f $ **FLOATING
C5742 single_9b_cdac_1.cdac_sw_9b_0.cdac_sw_3_1.tg_sw_3_3.SWN VGND 6.34714f $ **FLOATING
C5743 a_54032_17740# VGND 0.89543f $ **FLOATING
C5744 single_9b_cdac_1.cdac_sw_9b_0.cdac_sw_3_0.nooverlap_clk_0.CLK0 VGND 2.66664f $ **FLOATING
C5745 single_9b_cdac_1.cdac_sw_9b_0.cdac_sw_3_4.nooverlap_clk_0.x3.Y VGND 0.35827f $ **FLOATING
C5746 single_9b_cdac_1.cdac_sw_9b_0.cdac_sw_3_4.nooverlap_clk_0.sky130_fd_sc_hs__nand2_1_0.Y VGND 0.40542f $ **FLOATING
C5747 single_9b_cdac_1.cdac_sw_9b_0.cdac_sw_3_4.nooverlap_clk_0.x4.A VGND 0.42464f $ **FLOATING
C5748 single_9b_cdac_1.cdac_sw_9b_0.cdac_sw_3_4.nooverlap_clk_0.sky130_fd_sc_hs__inv_1_1.A VGND 0.44912f $ **FLOATING
C5749 single_9b_cdac_1.cdac_sw_9b_0.cdac_sw_3_4.nooverlap_clk_0.x6.A VGND 0.47224f $ **FLOATING
C5750 single_9b_cdac_1.cdac_sw_9b_0.cdac_sw_3_0.nooverlap_clk_0.CLKB0 VGND 3.16256f $ **FLOATING
C5751 a_53154_16877# VGND 0.16243f $ **FLOATING
C5752 single_9b_cdac_1.cdac_sw_9b_0.cdac_sw_3_4.nooverlap_clk_0.x1.A VGND 1.5857f $ **FLOATING
C5753 single_9b_cdac_1.cdac_sw_9b_0.cdac_sw_3_4.nooverlap_clk_0.x8.A VGND 1.56099f $ **FLOATING
C5754 single_9b_cdac_1.cdac_sw_9b_0.cdac_sw_3_0.tg_sw_3_3.SWP VGND 4.51373f $ **FLOATING
C5755 single_9b_cdac_1.cdac_sw_9b_0.S[2] VGND 30.361f $ **FLOATING
C5756 single_9b_cdac_1.cdac_sw_9b_0.cdac_sw_3_4.nooverlap_clk_0.sky130_fd_sc_hs__inv_8_0.A VGND 1.37352f $ **FLOATING
C5757 single_9b_cdac_1.cdac_sw_9b_0.cdac_sw_3_4.nooverlap_clk_0.x10.A VGND 1.39185f $ **FLOATING
C5758 single_9b_cdac_1.cdac_sw_9b_0.cdac_sw_3_0.tg_sw_3_3.SWN VGND 6.34762f $ **FLOATING
C5759 a_49221_17740# VGND 0.89502f $ **FLOATING
C5760 single_9b_cdac_1.cdac_sw_9b_0.cdac_sw_3_4.nooverlap_clk_0.CLK0 VGND 2.66535f $ **FLOATING
C5761 single_9b_cdac_1.cdac_sw_9b_0.cdac_sw_3_3.nooverlap_clk_0.x3.Y VGND 0.35827f $ **FLOATING
C5762 single_9b_cdac_1.cdac_sw_9b_0.cdac_sw_3_3.nooverlap_clk_0.sky130_fd_sc_hs__nand2_1_0.Y VGND 0.40525f $ **FLOATING
C5763 single_9b_cdac_1.cdac_sw_9b_0.cdac_sw_3_3.nooverlap_clk_0.x4.A VGND 0.42464f $ **FLOATING
C5764 single_9b_cdac_1.cdac_sw_9b_0.cdac_sw_3_3.nooverlap_clk_0.sky130_fd_sc_hs__inv_1_1.A VGND 0.44899f $ **FLOATING
C5765 single_9b_cdac_1.cdac_sw_9b_0.cdac_sw_3_3.nooverlap_clk_0.x6.A VGND 0.47224f $ **FLOATING
C5766 single_9b_cdac_1.cdac_sw_9b_0.cdac_sw_3_4.nooverlap_clk_0.CLKB0 VGND 3.16312f $ **FLOATING
C5767 a_48343_16877# VGND 0.16243f $ **FLOATING
C5768 single_9b_cdac_1.cdac_sw_9b_0.cdac_sw_3_3.nooverlap_clk_0.x1.A VGND 1.58513f $ **FLOATING
C5769 single_9b_cdac_1.cdac_sw_9b_0.cdac_sw_3_3.nooverlap_clk_0.x8.A VGND 1.56081f $ **FLOATING
C5770 single_9b_cdac_1.cdac_sw_9b_0.cdac_sw_3_4.tg_sw_3_3.SWP VGND 4.51233f $ **FLOATING
C5771 single_9b_cdac_1.cdac_sw_9b_0.S[3] VGND 21.9682f $ **FLOATING
C5772 single_9b_cdac_1.cdac_sw_9b_0.cdac_sw_3_3.nooverlap_clk_0.sky130_fd_sc_hs__inv_8_0.A VGND 1.37301f $ **FLOATING
C5773 single_9b_cdac_1.cdac_sw_9b_0.cdac_sw_3_3.nooverlap_clk_0.x10.A VGND 1.39185f $ **FLOATING
C5774 single_9b_cdac_1.cdac_sw_9b_0.cdac_sw_3_4.tg_sw_3_3.SWN VGND 6.3477f $ **FLOATING
C5775 a_44418_17740# VGND 0.89497f $ **FLOATING
C5776 single_9b_cdac_1.cdac_sw_9b_0.cdac_sw_3_3.nooverlap_clk_0.CLK0 VGND 2.665f $ **FLOATING
C5777 single_9b_cdac_1.cdac_sw_9b_0.cdac_sw_3_5.nooverlap_clk_0.x3.Y VGND 0.35827f $ **FLOATING
C5778 single_9b_cdac_1.cdac_sw_9b_0.cdac_sw_3_5.nooverlap_clk_0.sky130_fd_sc_hs__nand2_1_0.Y VGND 0.40523f $ **FLOATING
C5779 single_9b_cdac_1.cdac_sw_9b_0.cdac_sw_3_5.nooverlap_clk_0.x4.A VGND 0.42464f $ **FLOATING
C5780 single_9b_cdac_1.cdac_sw_9b_0.cdac_sw_3_5.nooverlap_clk_0.sky130_fd_sc_hs__inv_1_1.A VGND 0.44898f $ **FLOATING
C5781 single_9b_cdac_1.cdac_sw_9b_0.cdac_sw_3_5.nooverlap_clk_0.x6.A VGND 0.47224f $ **FLOATING
C5782 single_9b_cdac_1.cdac_sw_9b_0.cdac_sw_3_3.nooverlap_clk_0.CLKB0 VGND 3.16281f $ **FLOATING
C5783 a_43540_16877# VGND 0.16243f $ **FLOATING
C5784 single_9b_cdac_1.cdac_sw_9b_0.cdac_sw_3_5.nooverlap_clk_0.x1.A VGND 1.58505f $ **FLOATING
C5785 single_9b_cdac_1.cdac_sw_9b_0.cdac_sw_3_5.nooverlap_clk_0.x8.A VGND 1.56079f $ **FLOATING
C5786 single_9b_cdac_1.cdac_sw_9b_0.cdac_sw_3_3.tg_sw_3_3.SWP VGND 4.51195f $ **FLOATING
C5787 single_9b_cdac_1.cdac_sw_9b_0.S[4] VGND 22.6775f $ **FLOATING
C5788 single_9b_cdac_1.cdac_sw_9b_0.cdac_sw_3_5.nooverlap_clk_0.sky130_fd_sc_hs__inv_8_0.A VGND 1.37294f $ **FLOATING
C5789 single_9b_cdac_1.cdac_sw_9b_0.cdac_sw_3_5.nooverlap_clk_0.x10.A VGND 1.39185f $ **FLOATING
C5790 single_9b_cdac_1.cdac_sw_9b_0.cdac_sw_3_3.tg_sw_3_3.SWN VGND 6.3475f $ **FLOATING
C5791 a_39616_17740# VGND 0.89497f $ **FLOATING
C5792 single_9b_cdac_1.cdac_sw_9b_0.cdac_sw_3_5.nooverlap_clk_0.CLK0 VGND 2.66616f $ **FLOATING
C5793 single_9b_cdac_1.cdac_sw_9b_0.cdac_sw_3_6.nooverlap_clk_0.x3.Y VGND 0.35827f $ **FLOATING
C5794 single_9b_cdac_1.cdac_sw_9b_0.cdac_sw_3_6.nooverlap_clk_0.sky130_fd_sc_hs__nand2_1_0.Y VGND 0.40523f $ **FLOATING
C5795 single_9b_cdac_1.cdac_sw_9b_0.cdac_sw_3_6.nooverlap_clk_0.x4.A VGND 0.42464f $ **FLOATING
C5796 single_9b_cdac_1.cdac_sw_9b_0.cdac_sw_3_6.nooverlap_clk_0.sky130_fd_sc_hs__inv_1_1.A VGND 0.44898f $ **FLOATING
C5797 single_9b_cdac_1.cdac_sw_9b_0.cdac_sw_3_6.nooverlap_clk_0.x6.A VGND 0.47224f $ **FLOATING
C5798 single_9b_cdac_1.cdac_sw_9b_0.cdac_sw_3_5.nooverlap_clk_0.CLKB0 VGND 3.16277f $ **FLOATING
C5799 a_38738_16877# VGND 0.16243f $ **FLOATING
C5800 single_9b_cdac_1.cdac_sw_9b_0.cdac_sw_3_6.nooverlap_clk_0.x1.A VGND 1.58505f $ **FLOATING
C5801 single_9b_cdac_1.cdac_sw_9b_0.cdac_sw_3_6.nooverlap_clk_0.x8.A VGND 1.56079f $ **FLOATING
C5802 single_9b_cdac_1.cdac_sw_9b_0.cdac_sw_3_5.tg_sw_3_3.SWP VGND 4.51201f $ **FLOATING
C5803 single_9b_cdac_1.cdac_sw_9b_0.S[5] VGND 17.533f $ **FLOATING
C5804 single_9b_cdac_1.cdac_sw_9b_0.cdac_sw_3_6.nooverlap_clk_0.sky130_fd_sc_hs__inv_8_0.A VGND 1.37294f $ **FLOATING
C5805 single_9b_cdac_1.cdac_sw_9b_0.cdac_sw_3_6.nooverlap_clk_0.x10.A VGND 1.39185f $ **FLOATING
C5806 single_9b_cdac_1.cdac_sw_9b_0.cdac_sw_3_5.tg_sw_3_3.SWN VGND 6.3475f $ **FLOATING
C5807 a_34814_17740# VGND 0.89548f $ **FLOATING
C5808 single_9b_cdac_1.cdac_sw_9b_0.cdac_sw_3_6.nooverlap_clk_0.CLK0 VGND 2.66683f $ **FLOATING
C5809 single_9b_cdac_1.cdac_sw_9b_0.cdac_sw_3_7.nooverlap_clk_0.x3.Y VGND 0.35827f $ **FLOATING
C5810 single_9b_cdac_1.cdac_sw_9b_0.cdac_sw_3_7.nooverlap_clk_0.sky130_fd_sc_hs__nand2_1_0.Y VGND 0.40523f $ **FLOATING
C5811 single_9b_cdac_1.cdac_sw_9b_0.cdac_sw_3_7.nooverlap_clk_0.x4.A VGND 0.42464f $ **FLOATING
C5812 single_9b_cdac_1.cdac_sw_9b_0.cdac_sw_3_7.nooverlap_clk_0.sky130_fd_sc_hs__inv_1_1.A VGND 0.44898f $ **FLOATING
C5813 single_9b_cdac_1.cdac_sw_9b_0.cdac_sw_3_7.nooverlap_clk_0.x6.A VGND 0.47224f $ **FLOATING
C5814 single_9b_cdac_1.cdac_sw_9b_0.cdac_sw_3_6.nooverlap_clk_0.CLKB0 VGND 3.16277f $ **FLOATING
C5815 a_33936_16877# VGND 0.16243f $ **FLOATING
C5816 single_9b_cdac_1.cdac_sw_9b_0.cdac_sw_3_7.nooverlap_clk_0.x1.A VGND 1.58505f $ **FLOATING
C5817 single_9b_cdac_1.cdac_sw_9b_0.cdac_sw_3_7.nooverlap_clk_0.x8.A VGND 1.56079f $ **FLOATING
C5818 single_9b_cdac_1.cdac_sw_9b_0.cdac_sw_3_6.tg_sw_3_3.SWP VGND 4.51252f $ **FLOATING
C5819 single_9b_cdac_1.cdac_sw_9b_0.S[6] VGND 16.6825f $ **FLOATING
C5820 single_9b_cdac_1.cdac_sw_9b_0.cdac_sw_3_7.nooverlap_clk_0.sky130_fd_sc_hs__inv_8_0.A VGND 1.37294f $ **FLOATING
C5821 single_9b_cdac_1.cdac_sw_9b_0.cdac_sw_3_7.nooverlap_clk_0.x10.A VGND 1.39185f $ **FLOATING
C5822 single_9b_cdac_1.cdac_sw_9b_0.cdac_sw_3_6.tg_sw_3_3.SWN VGND 6.3475f $ **FLOATING
C5823 a_30012_17740# VGND 0.89497f $ **FLOATING
C5824 single_9b_cdac_1.cdac_sw_9b_0.cdac_sw_3_7.nooverlap_clk_0.CLK0 VGND 2.66498f $ **FLOATING
C5825 single_9b_cdac_1.cdac_sw_9b_0.cdac_sw_3_8.nooverlap_clk_0.x3.Y VGND 0.35827f $ **FLOATING
C5826 single_9b_cdac_1.cdac_sw_9b_0.cdac_sw_3_8.nooverlap_clk_0.sky130_fd_sc_hs__nand2_1_0.Y VGND 0.40523f $ **FLOATING
C5827 single_9b_cdac_1.cdac_sw_9b_0.cdac_sw_3_8.nooverlap_clk_0.x4.A VGND 0.42464f $ **FLOATING
C5828 single_9b_cdac_1.cdac_sw_9b_0.cdac_sw_3_8.nooverlap_clk_0.sky130_fd_sc_hs__inv_1_1.A VGND 0.44898f $ **FLOATING
C5829 single_9b_cdac_1.cdac_sw_9b_0.cdac_sw_3_8.nooverlap_clk_0.x6.A VGND 0.47224f $ **FLOATING
C5830 single_9b_cdac_1.cdac_sw_9b_0.cdac_sw_3_7.nooverlap_clk_0.CLKB0 VGND 3.16277f $ **FLOATING
C5831 a_29134_16877# VGND 0.16243f $ **FLOATING
C5832 single_9b_cdac_1.cdac_sw_9b_0.cdac_sw_3_8.nooverlap_clk_0.x1.A VGND 1.58505f $ **FLOATING
C5833 single_9b_cdac_1.cdac_sw_9b_0.cdac_sw_3_8.nooverlap_clk_0.x8.A VGND 1.56079f $ **FLOATING
C5834 single_9b_cdac_1.cdac_sw_9b_0.cdac_sw_3_7.tg_sw_3_3.SWP VGND 4.51193f $ **FLOATING
C5835 single_9b_cdac_1.cdac_sw_9b_0.S[7] VGND 15.3302f $ **FLOATING
C5836 single_9b_cdac_1.cdac_sw_9b_0.cdac_sw_3_8.nooverlap_clk_0.sky130_fd_sc_hs__inv_8_0.A VGND 1.37294f $ **FLOATING
C5837 single_9b_cdac_1.cdac_sw_9b_0.cdac_sw_3_8.nooverlap_clk_0.x10.A VGND 1.39185f $ **FLOATING
C5838 single_9b_cdac_1.cdac_sw_9b_0.cdac_sw_3_7.tg_sw_3_3.SWN VGND 6.34748f $ **FLOATING
C5839 a_25210_17740# VGND 0.89548f $ **FLOATING
C5840 single_9b_cdac_1.cdac_sw_9b_0.cdac_sw_3_8.nooverlap_clk_0.CLK0 VGND 2.68106f $ **FLOATING
C5841 single_9b_cdac_1.cdac_sw_9b_0.cdac_sw_3_8.nooverlap_clk_0.CLKB0 VGND 3.16216f $ **FLOATING
C5842 a_24332_16877# VGND 0.16243f $ **FLOATING
C5843 single_9b_cdac_1.cdac_sw_9b_0.cdac_sw_3_8.tg_sw_3_3.SWP VGND 4.71828f $ **FLOATING
C5844 single_9b_cdac_1.cdac_sw_9b_0.S[8] VGND 13.9589f $ **FLOATING
C5845 th_dif_sw_0.CK VGND 10.0147f $ **FLOATING
C5846 th_dif_sw_0.CKB VGND 15.7171f $ **FLOATING
C5847 a_14451_17812# VGND 0.25205f $ **FLOATING
C5848 a_12427_17812# VGND 0.3849f $ **FLOATING
C5849 tdc_0.OUTP VGND 3.70273f $ **FLOATING
C5850 a_10311_17812# VGND 0.39371f $ **FLOATING
C5851 tdc_0.OUTN VGND 5.49137f $ **FLOATING
C5852 a_7735_17812# VGND 0.41192f $ **FLOATING
C5853 tdc_0.RDY VGND 5.8347f $ **FLOATING
C5854 a_5393_17977# VGND 0.28259f $ **FLOATING
C5855 single_9b_cdac_1.cdac_sw_9b_0.cdac_sw_3_8.tg_sw_3_3.SWN VGND 6.37641f $ **FLOATING
C5856 single_9b_cdac_1.SW[1] VGND 6.15308f $ **FLOATING
C5857 single_9b_cdac_1.SW[0] VGND 12.8807f $ **FLOATING
C5858 a_12683_18356# VGND 0.01579f $ **FLOATING
C5859 a_12671_18734# VGND 0.0106f $ **FLOATING
C5860 a_12480_18722# VGND 0.07603f $ **FLOATING
C5861 a_14451_18356# VGND 0.22242f $ **FLOATING
C5862 a_14175_18356# VGND 0.24991f $ **FLOATING
C5863 a_13140_18734# VGND 0.28257f $ **FLOATING
C5864 a_13315_18660# VGND 0.51045f $ **FLOATING
C5865 a_12575_18734# VGND 0.29032f $ **FLOATING
C5866 a_12793_18330# VGND 0.19824f $ **FLOATING
C5867 a_12225_18362# VGND 0.34243f $ **FLOATING
C5868 a_12059_18362# VGND 0.57378f $ **FLOATING
C5869 a_13308_18900# VGND 0.08265f $ **FLOATING
C5870 a_13968_18900# VGND 0.27657f $ **FLOATING
C5871 a_14143_18874# VGND 0.49929f $ **FLOATING
C5872 a_13403_18900# VGND 0.27111f $ **FLOATING
C5873 a_13621_19142# VGND 0.18765f $ **FLOATING
C5874 a_13053_18900# VGND 0.30493f $ **FLOATING
C5875 a_12887_18900# VGND 0.68687f $ **FLOATING
C5876 a_11376_18900# VGND 0.08006f $ **FLOATING
C5877 a_12036_18900# VGND 0.27208f $ **FLOATING
C5878 a_12211_18874# VGND 0.54027f $ **FLOATING
C5879 a_11471_18900# VGND 0.26966f $ **FLOATING
C5880 a_11689_19142# VGND 0.18885f $ **FLOATING
C5881 a_11121_18900# VGND 0.29792f $ **FLOATING
C5882 a_10955_18900# VGND 0.60302f $ **FLOATING
C5883 a_10406_19266# VGND 0.07821f $ **FLOATING
C5884 a_9774_19266# VGND 0.18733f $ **FLOATING
C5885 a_9843_19137# VGND 0.26375f $ **FLOATING
C5886 a_9687_19042# VGND 0.5192f $ **FLOATING
C5887 a_9648_19168# VGND 0.30086f $ **FLOATING
C5888 a_9370_19152# VGND 0.27461f $ **FLOATING
C5889 a_9167_18874# VGND 0.49952f $ **FLOATING
C5890 a_13308_19810# VGND 0.07652f $ **FLOATING
C5891 a_10732_19810# VGND 0.07386f $ **FLOATING
C5892 a_8708_19810# VGND 0.08078f $ **FLOATING
C5893 sar9b_0.clkload0.X VGND 0.30837f $ **FLOATING
C5894 a_6417_19822# VGND 0.07052f $ **FLOATING
C5895 a_13968_19822# VGND 0.27196f $ **FLOATING
C5896 a_14143_19748# VGND 0.49624f $ **FLOATING
C5897 a_13403_19822# VGND 0.26364f $ **FLOATING
C5898 a_13621_19418# VGND 0.18281f $ **FLOATING
C5899 a_13053_19450# VGND 0.29839f $ **FLOATING
C5900 a_12887_19450# VGND 0.60757f $ **FLOATING
C5901 a_11392_19822# VGND 0.26201f $ **FLOATING
C5902 a_11567_19748# VGND 0.48991f $ **FLOATING
C5903 a_10827_19822# VGND 0.25735f $ **FLOATING
C5904 a_11045_19418# VGND 0.17901f $ **FLOATING
C5905 a_10477_19450# VGND 0.28991f $ **FLOATING
C5906 a_10311_19450# VGND 0.54488f $ **FLOATING
C5907 a_9368_19822# VGND 0.26081f $ **FLOATING
C5908 a_9543_19748# VGND 0.47662f $ **FLOATING
C5909 a_8803_19822# VGND 0.26288f $ **FLOATING
C5910 a_9021_19418# VGND 0.1878f $ **FLOATING
C5911 a_8453_19450# VGND 0.30938f $ **FLOATING
C5912 a_8287_19450# VGND 0.71933f $ **FLOATING
C5913 a_6907_19444# VGND 0.61732f $ **FLOATING
C5914 a_5999_19822# VGND 0.26764f $ **FLOATING
C5915 a_6070_19721# VGND 0.21656f $ **FLOATING
C5916 a_5870_19566# VGND 0.46369f $ **FLOATING
C5917 a_5863_19662# VGND 0.57254f $ **FLOATING
C5918 a_5579_19676# VGND 0.28363f $ **FLOATING
C5919 a_5483_19676# VGND 0.37721f $ **FLOATING
C5920 a_13308_19988# VGND 0.08132f $ **FLOATING
C5921 a_13968_19988# VGND 0.2593f $ **FLOATING
C5922 a_14143_19962# VGND 0.4739f $ **FLOATING
C5923 a_13403_19988# VGND 0.26385f $ **FLOATING
C5924 a_13621_20230# VGND 0.18196f $ **FLOATING
C5925 a_13053_19988# VGND 0.30569f $ **FLOATING
C5926 a_12887_19988# VGND 0.70238f $ **FLOATING
C5927 a_10774_20354# VGND 0.07386f $ **FLOATING
C5928 a_6249_19988# VGND 0.06509f $ **FLOATING
C5929 a_10142_20354# VGND 0.17902f $ **FLOATING
C5930 a_10211_20225# VGND 0.26309f $ **FLOATING
C5931 a_10055_20130# VGND 0.57211f $ **FLOATING
C5932 a_10016_20256# VGND 0.31903f $ **FLOATING
C5933 a_9738_20240# VGND 0.27706f $ **FLOATING
C5934 a_9535_19962# VGND 0.50285f $ **FLOATING
C5935 a_6759_20354# VGND 0.28344f $ **FLOATING
C5936 a_6930_20241# VGND 0.67062f $ **FLOATING
C5937 a_6343_20354# VGND 0.23141f $ **FLOATING
C5938 a_6502_20124# VGND 0.28703f $ **FLOATING
C5939 a_6061_19988# VGND 0.59342f $ **FLOATING
C5940 a_5895_19988# VGND 0.5566f $ **FLOATING
C5941 single_9b_cdac_1.SW[7] VGND 5.44229f $ **FLOATING
C5942 single_9b_cdac_1.SW[6] VGND 5.54624f $ **FLOATING
C5943 single_9b_cdac_1.SW[5] VGND 5.6679f $ **FLOATING
C5944 single_9b_cdac_1.SW[4] VGND 5.89423f $ **FLOATING
C5945 single_9b_cdac_1.SW[3] VGND 6.37645f $ **FLOATING
C5946 single_9b_cdac_1.SW[2] VGND 6.24713f $ **FLOATING
C5947 a_11652_20898# VGND 0.07542f $ **FLOATING
C5948 a_8825_20532# VGND 0.06062f $ **FLOATING
C5949 a_14451_20532# VGND 0.22271f $ **FLOATING
C5950 a_14175_20532# VGND 0.21142f $ **FLOATING
C5951 a_13899_20532# VGND 0.2061f $ **FLOATING
C5952 a_13623_20532# VGND 0.21256f $ **FLOATING
C5953 a_13347_20532# VGND 0.20766f $ **FLOATING
C5954 a_13071_20532# VGND 0.20829f $ **FLOATING
C5955 a_12312_20910# VGND 0.28482f $ **FLOATING
C5956 a_12487_20836# VGND 0.52985f $ **FLOATING
C5957 a_11747_20910# VGND 0.27241f $ **FLOATING
C5958 a_11965_20506# VGND 0.19357f $ **FLOATING
C5959 a_11397_20538# VGND 0.31902f $ **FLOATING
C5960 a_11231_20538# VGND 0.54553f $ **FLOATING
C5961 a_9335_20532# VGND 0.25634f $ **FLOATING
C5962 a_9503_20506# VGND 0.35685f $ **FLOATING
C5963 a_8910_20532# VGND 0.21292f $ **FLOATING
C5964 a_9078_20506# VGND 0.24522f $ **FLOATING
C5965 a_8637_20538# VGND 0.32417f $ **FLOATING
C5966 a_8471_20538# VGND 0.49446f $ **FLOATING
C5967 sar9b_0.clknet_1_0__leaf_CLK VGND 2.34919f $ **FLOATING
C5968 a_6701_20506# VGND 2.08123f $ **FLOATING
C5969 a_13308_21076# VGND 0.07843f $ **FLOATING
C5970 a_13968_21076# VGND 0.26874f $ **FLOATING
C5971 a_14143_21050# VGND 0.50008f $ **FLOATING
C5972 a_13403_21076# VGND 0.26236f $ **FLOATING
C5973 a_13621_21318# VGND 0.17949f $ **FLOATING
C5974 a_13053_21076# VGND 0.29778f $ **FLOATING
C5975 a_12887_21076# VGND 0.56632f $ **FLOATING
C5976 a_11376_21076# VGND 0.07863f $ **FLOATING
C5977 a_12036_21076# VGND 0.26386f $ **FLOATING
C5978 a_12211_21050# VGND 0.51544f $ **FLOATING
C5979 a_11471_21076# VGND 0.26545f $ **FLOATING
C5980 a_11689_21318# VGND 0.17866f $ **FLOATING
C5981 a_11121_21076# VGND 0.31071f $ **FLOATING
C5982 a_10955_21076# VGND 0.54858f $ **FLOATING
C5983 a_9536_21076# VGND 0.08078f $ **FLOATING
C5984 a_10196_21076# VGND 0.27517f $ **FLOATING
C5985 a_10371_21050# VGND 0.4957f $ **FLOATING
C5986 a_9631_21076# VGND 0.26665f $ **FLOATING
C5987 a_9849_21318# VGND 0.18683f $ **FLOATING
C5988 a_9281_21076# VGND 0.3084f $ **FLOATING
C5989 a_9115_21076# VGND 0.70416f $ **FLOATING
C5990 sar9b_0._05_ VGND 0.98369f $ **FLOATING
C5991 a_5711_21076# VGND 0.16127f $ **FLOATING
C5992 sar9b_0._01_ VGND 0.4074f $ **FLOATING
C5993 sar9b_0._00_ VGND 0.77926f $ **FLOATING
C5994 a_7735_21076# VGND 0.28042f $ **FLOATING
C5995 a_7059_21228# VGND 0.24953f $ **FLOATING
C5996 a_6674_21050# VGND 0.2441f $ **FLOATING
C5997 a_6315_21050# VGND 0.40632f $ **FLOATING
C5998 a_5884_21326# VGND 0.25773f $ **FLOATING
C5999 sar9b_0.net16 VGND 1.56277f $ **FLOATING
C6000 single_9b_cdac_1.SW[8] VGND 5.08544f $ **FLOATING
C6001 a_14451_21620# VGND 0.2226f $ **FLOATING
C6002 a_14175_21620# VGND 0.20712f $ **FLOATING
C6003 a_13899_21620# VGND 0.20608f $ **FLOATING
C6004 sar9b_0.net7 VGND 1.37654f $ **FLOATING
C6005 a_13623_21620# VGND 0.20522f $ **FLOATING
C6006 sar9b_0.net6 VGND 1.39762f $ **FLOATING
C6007 a_13347_21620# VGND 0.20001f $ **FLOATING
C6008 sar9b_0.net5 VGND 1.00952f $ **FLOATING
C6009 a_13071_21620# VGND 0.24393f $ **FLOATING
C6010 a_7345_21594# VGND 2.08046f $ **FLOATING
C6011 a_6859_21710# VGND 0.22801f $ **FLOATING
C6012 sar9b_0._08_ VGND 0.58051f $ **FLOATING
C6013 a_6587_21852# VGND 0.38679f $ **FLOATING
C6014 a_13308_22164# VGND 0.0814f $ **FLOATING
C6015 a_13968_22164# VGND 0.27609f $ **FLOATING
C6016 a_14143_22138# VGND 0.49839f $ **FLOATING
C6017 a_13403_22164# VGND 0.26804f $ **FLOATING
C6018 a_13621_22406# VGND 0.18649f $ **FLOATING
C6019 a_13053_22164# VGND 0.3058f $ **FLOATING
C6020 a_12887_22164# VGND 0.66699f $ **FLOATING
C6021 sar9b_0.net8 VGND 2.64634f $ **FLOATING
C6022 a_11192_22164# VGND 0.08015f $ **FLOATING
C6023 a_11852_22164# VGND 0.26805f $ **FLOATING
C6024 a_12027_22138# VGND 0.49932f $ **FLOATING
C6025 a_11287_22164# VGND 0.2759f $ **FLOATING
C6026 a_11505_22406# VGND 0.18835f $ **FLOATING
C6027 a_10937_22164# VGND 0.31564f $ **FLOATING
C6028 a_10771_22164# VGND 0.51993f $ **FLOATING
C6029 a_9352_22164# VGND 0.08f $ **FLOATING
C6030 a_10012_22164# VGND 0.26612f $ **FLOATING
C6031 a_10187_22138# VGND 0.48918f $ **FLOATING
C6032 a_9447_22164# VGND 0.26812f $ **FLOATING
C6033 a_9665_22406# VGND 0.1835f $ **FLOATING
C6034 a_9097_22164# VGND 0.29274f $ **FLOATING
C6035 a_8931_22164# VGND 0.67662f $ **FLOATING
C6036 sar9b_0._15_ VGND 0.66308f $ **FLOATING
C6037 sar9b_0._14_ VGND 0.41958f $ **FLOATING
C6038 a_6943_22316# VGND 0.21223f $ **FLOATING
C6039 sar9b_0._06_ VGND 0.39499f $ **FLOATING
C6040 sar9b_0.clk_div_0.COUNT\[3\] VGND 2.12998f $ **FLOATING
C6041 a_7813_22316# VGND 0.22486f $ **FLOATING
C6042 sar9b_0._09_ VGND 1.09469f $ **FLOATING
C6043 sar9b_0._07_ VGND 0.94112f $ **FLOATING
C6044 a_7039_22138# VGND 0.24243f $ **FLOATING
C6045 a_6679_22316# VGND 0.35943f $ **FLOATING
C6046 a_6219_22316# VGND 0.25108f $ **FLOATING
C6047 a_13308_23074# VGND 0.08223f $ **FLOATING
C6048 a_9670_22708# VGND 0.07822f $ **FLOATING
C6049 sar9b_0._12_ VGND 0.87247f $ **FLOATING
C6050 a_6736_23086# VGND 0.01095f $ **FLOATING
C6051 a_6525_22708# VGND 0.0697f $ **FLOATING
C6052 a_13968_23086# VGND 0.27738f $ **FLOATING
C6053 a_14143_23012# VGND 0.50064f $ **FLOATING
C6054 a_13403_23086# VGND 0.26792f $ **FLOATING
C6055 a_13621_22682# VGND 0.18624f $ **FLOATING
C6056 a_13053_22714# VGND 0.31122f $ **FLOATING
C6057 a_12887_22714# VGND 0.7033f $ **FLOATING
C6058 sar9b_0.net9 VGND 1.28105f $ **FLOATING
C6059 a_9038_22708# VGND 0.18563f $ **FLOATING
C6060 a_9107_22682# VGND 0.26467f $ **FLOATING
C6061 a_8912_22824# VGND 0.2977f $ **FLOATING
C6062 a_8951_22950# VGND 0.55965f $ **FLOATING
C6063 a_8634_22840# VGND 0.27137f $ **FLOATING
C6064 a_8431_22682# VGND 0.50723f $ **FLOATING
C6065 a_7035_22708# VGND 0.26974f $ **FLOATING
C6066 a_7203_22682# VGND 0.34581f $ **FLOATING
C6067 a_6610_22708# VGND 0.2386f $ **FLOATING
C6068 a_6778_22682# VGND 0.27392f $ **FLOATING
C6069 a_6337_22714# VGND 0.36462f $ **FLOATING
C6070 sar9b_0._04_ VGND 0.35411f $ **FLOATING
C6071 a_6171_22714# VGND 0.53776f $ **FLOATING
C6072 sar9b_0._10_ VGND 1.19295f $ **FLOATING
C6073 a_10732_23252# VGND 0.07937f $ **FLOATING
C6074 a_14451_23252# VGND 0.22344f $ **FLOATING
C6075 a_14175_23252# VGND 0.20779f $ **FLOATING
C6076 a_13899_23252# VGND 0.2064f $ **FLOATING
C6077 a_13623_23252# VGND 0.23375f $ **FLOATING
C6078 a_11392_23252# VGND 0.26792f $ **FLOATING
C6079 a_11567_23226# VGND 0.5107f $ **FLOATING
C6080 a_10827_23252# VGND 0.25185f $ **FLOATING
C6081 a_11045_23494# VGND 0.18548f $ **FLOATING
C6082 a_10477_23252# VGND 0.30305f $ **FLOATING
C6083 a_10311_23252# VGND 0.5222f $ **FLOATING
C6084 a_7817_23252# VGND 0.19725f $ **FLOATING
C6085 a_8892_23252# VGND 0.07386f $ **FLOATING
C6086 a_9552_23252# VGND 0.26229f $ **FLOATING
C6087 a_9727_23226# VGND 0.49082f $ **FLOATING
C6088 a_8987_23252# VGND 0.27162f $ **FLOATING
C6089 a_9205_23494# VGND 0.181f $ **FLOATING
C6090 a_8637_23252# VGND 0.295f $ **FLOATING
C6091 a_8471_23252# VGND 0.54088f $ **FLOATING
C6092 sar9b_0._13_ VGND 0.47132f $ **FLOATING
C6093 a_5973_23252# VGND 0.0652f $ **FLOATING
C6094 sar9b_0.clk_div_0.COUNT\[2\] VGND 0.87754f $ **FLOATING
C6095 a_7145_23226# VGND 0.28833f $ **FLOATING
C6096 a_6483_23618# VGND 0.3055f $ **FLOATING
C6097 a_6651_23520# VGND 0.41027f $ **FLOATING
C6098 a_6058_23618# VGND 0.20681f $ **FLOATING
C6099 a_6226_23364# VGND 0.25924f $ **FLOATING
C6100 a_5785_23252# VGND 0.32179f $ **FLOATING
C6101 sar9b_0._02_ VGND 0.55018f $ **FLOATING
C6102 a_5619_23252# VGND 0.52547f $ **FLOATING
C6103 a_13216_24162# VGND 0.08157f $ **FLOATING
C6104 a_11376_24162# VGND 0.07386f $ **FLOATING
C6105 a_8273_23796# VGND 0.06138f $ **FLOATING
C6106 a_13876_24174# VGND 0.27662f $ **FLOATING
C6107 a_14051_24100# VGND 0.50295f $ **FLOATING
C6108 a_13311_24174# VGND 0.26684f $ **FLOATING
C6109 a_13529_23770# VGND 0.19046f $ **FLOATING
C6110 a_12961_23802# VGND 0.33079f $ **FLOATING
C6111 a_12795_23802# VGND 0.56454f $ **FLOATING
C6112 sar9b_0.net10 VGND 2.65902f $ **FLOATING
C6113 a_12036_24174# VGND 0.26943f $ **FLOATING
C6114 a_12211_24100# VGND 0.51045f $ **FLOATING
C6115 a_11471_24174# VGND 0.25905f $ **FLOATING
C6116 a_11689_23770# VGND 0.1744f $ **FLOATING
C6117 a_11121_23802# VGND 0.29427f $ **FLOATING
C6118 sar9b_0.net2 VGND 4.58167f $ **FLOATING
C6119 a_10955_23802# VGND 0.52816f $ **FLOATING
C6120 a_8783_23796# VGND 0.26013f $ **FLOATING
C6121 a_8951_23770# VGND 0.35528f $ **FLOATING
C6122 a_8358_23796# VGND 0.20141f $ **FLOATING
C6123 a_8526_23770# VGND 0.24151f $ **FLOATING
C6124 a_8085_23802# VGND 0.30953f $ **FLOATING
C6125 a_7919_23802# VGND 0.48008f $ **FLOATING
C6126 sar9b_0.clknet_1_1__leaf_CLK VGND 2.64129f $ **FLOATING
C6127 sar9b_0.clknet_0_CLK VGND 2.72371f $ **FLOATING
C6128 a_6149_23770# VGND 2.10647f $ **FLOATING
C6129 a_8800_24340# VGND 0.07464f $ **FLOATING
C6130 a_14451_24340# VGND 0.22067f $ **FLOATING
C6131 sar9b_0.net29 VGND 0.48649f $ **FLOATING
C6132 a_14175_24340# VGND 0.20794f $ **FLOATING
C6133 sar9b_0.net28 VGND 0.58102f $ **FLOATING
C6134 a_13899_24340# VGND 0.20677f $ **FLOATING
C6135 sar9b_0.net27 VGND 0.97547f $ **FLOATING
C6136 a_13623_24340# VGND 0.23182f $ **FLOATING
C6137 sar9b_0.net26 VGND 2.15903f $ **FLOATING
C6138 a_9460_24340# VGND 0.27897f $ **FLOATING
C6139 a_9635_24314# VGND 0.49344f $ **FLOATING
C6140 a_8895_24340# VGND 0.26698f $ **FLOATING
C6141 a_9113_24582# VGND 0.18023f $ **FLOATING
C6142 a_8545_24340# VGND 0.30537f $ **FLOATING
C6143 a_8379_24340# VGND 0.55283f $ **FLOATING
C6144 sar9b_0._03_ VGND 0.50751f $ **FLOATING
C6145 a_6631_24590# VGND 0.04015f $ **FLOATING
C6146 sar9b_0._11_ VGND 0.86423f $ **FLOATING
C6147 sar9b_0.clk_div_0.COUNT\[0\] VGND 2.0647f $ **FLOATING
C6148 sar9b_0.clk_div_0.COUNT\[1\] VGND 2.17775f $ **FLOATING
C6149 a_13308_25250# VGND 0.08216f $ **FLOATING
C6150 a_10732_25250# VGND 0.08f $ **FLOATING
C6151 a_13968_25262# VGND 0.26283f $ **FLOATING
C6152 a_14143_25188# VGND 0.47488f $ **FLOATING
C6153 a_13403_25262# VGND 0.26444f $ **FLOATING
C6154 a_13621_24858# VGND 0.17863f $ **FLOATING
C6155 a_13053_24890# VGND 0.29808f $ **FLOATING
C6156 a_12887_24890# VGND 0.66172f $ **FLOATING
C6157 sar9b_0.net11 VGND 1.59413f $ **FLOATING
C6158 a_11392_25262# VGND 0.27202f $ **FLOATING
C6159 a_11567_25188# VGND 0.52446f $ **FLOATING
C6160 a_10827_25262# VGND 0.26575f $ **FLOATING
C6161 a_11045_24858# VGND 0.18572f $ **FLOATING
C6162 a_10477_24890# VGND 0.32051f $ **FLOATING
C6163 a_10311_24890# VGND 0.73445f $ **FLOATING
C6164 a_13308_25428# VGND 0.07824f $ **FLOATING
C6165 a_13968_25428# VGND 0.2727f $ **FLOATING
C6166 a_14143_25402# VGND 0.49657f $ **FLOATING
C6167 a_13403_25428# VGND 0.2628f $ **FLOATING
C6168 a_13621_25670# VGND 0.18235f $ **FLOATING
C6169 a_13053_25428# VGND 0.29813f $ **FLOATING
C6170 a_12887_25428# VGND 0.56496f $ **FLOATING
C6171 sar9b_0.net12 VGND 1.71611f $ **FLOATING
C6172 a_11100_25428# VGND 0.08004f $ **FLOATING
C6173 a_11760_25428# VGND 0.26479f $ **FLOATING
C6174 a_11935_25402# VGND 0.58807f $ **FLOATING
C6175 a_11195_25428# VGND 0.26836f $ **FLOATING
C6176 a_11413_25670# VGND 0.18762f $ **FLOATING
C6177 a_10845_25428# VGND 0.30798f $ **FLOATING
C6178 a_10679_25428# VGND 0.69178f $ **FLOATING
C6179 sar9b_0.net4 VGND 4.5509f $ **FLOATING
C6180 a_6427_25794# VGND 0.01211f $ **FLOATING
C6181 a_6224_25428# VGND 0.08124f $ **FLOATING
C6182 a_6884_25428# VGND 0.29121f $ **FLOATING
C6183 a_7059_25402# VGND 0.511f $ **FLOATING
C6184 a_6319_25428# VGND 0.28694f $ **FLOATING
C6185 a_6537_25670# VGND 0.21252f $ **FLOATING
C6186 a_5969_25428# VGND 0.34845f $ **FLOATING
C6187 sar9b_0.net37 VGND 1.93588f $ **FLOATING
C6188 a_5803_25428# VGND 0.58731f $ **FLOATING
C6189 a_12112_26338# VGND 0.08f $ **FLOATING
C6190 a_8800_26338# VGND 0.07475f $ **FLOATING
C6191 a_6960_26338# VGND 0.09338f $ **FLOATING
C6192 a_14451_25972# VGND 0.21918f $ **FLOATING
C6193 sar9b_0.net30 VGND 1.02073f $ **FLOATING
C6194 a_14175_25972# VGND 0.21183f $ **FLOATING
C6195 sar9b_0.net31 VGND 0.51232f $ **FLOATING
C6196 a_13899_25972# VGND 0.21265f $ **FLOATING
C6197 sar9b_0.net32 VGND 0.82232f $ **FLOATING
C6198 a_13623_25972# VGND 0.22506f $ **FLOATING
C6199 sar9b_0.net33 VGND 0.34062f $ **FLOATING
C6200 a_12772_26350# VGND 0.307f $ **FLOATING
C6201 a_12947_26276# VGND 0.50324f $ **FLOATING
C6202 a_12207_26350# VGND 0.28478f $ **FLOATING
C6203 a_12425_25946# VGND 0.20971f $ **FLOATING
C6204 a_11857_25978# VGND 0.34575f $ **FLOATING
C6205 sar9b_0.net43 VGND 1.59631f $ **FLOATING
C6206 a_11691_25978# VGND 0.73866f $ **FLOATING
C6207 a_9460_26350# VGND 0.26612f $ **FLOATING
C6208 a_9635_26276# VGND 0.5134f $ **FLOATING
C6209 a_8895_26350# VGND 0.2649f $ **FLOATING
C6210 a_9113_25946# VGND 0.18178f $ **FLOATING
C6211 a_8545_25978# VGND 0.30219f $ **FLOATING
C6212 sar9b_0.net40 VGND 3.38463f $ **FLOATING
C6213 a_8379_25978# VGND 0.53953f $ **FLOATING
C6214 a_7620_26350# VGND 0.27991f $ **FLOATING
C6215 a_7795_26276# VGND 0.50746f $ **FLOATING
C6216 a_7055_26350# VGND 0.2722f $ **FLOATING
C6217 a_7273_25946# VGND 0.18905f $ **FLOATING
C6218 a_6705_25978# VGND 0.3404f $ **FLOATING
C6219 sar9b_0.net38 VGND 4.1022f $ **FLOATING
C6220 a_6539_25978# VGND 0.73806f $ **FLOATING
C6221 a_5945_26191# VGND 0.25679f $ **FLOATING
C6222 a_5343_25972# VGND 0.59522f $ **FLOATING
C6223 a_63626_26990# VGND 0.89497f $ **FLOATING
C6224 single_9b_cdac_0.cdac_sw_9b_0.cdac_sw_3_2.nooverlap_clk_0.CLK0 VGND 2.68117f $ **FLOATING
C6225 single_9b_cdac_0.cdac_sw_9b_0.cdac_sw_3_2.nooverlap_clk_0.CLKB0 VGND 3.19275f $ **FLOATING
C6226 a_62748_26999# VGND 0.16243f $ **FLOATING
C6227 single_9b_cdac_0.SW[0] VGND 10.4125f $ **FLOATING
C6228 a_58824_26990# VGND 0.89548f $ **FLOATING
C6229 single_9b_cdac_0.cdac_sw_9b_0.cdac_sw_3_1.nooverlap_clk_0.CLK0 VGND 2.66663f $ **FLOATING
C6230 single_9b_cdac_0.cdac_sw_9b_0.cdac_sw_3_2.tg_sw_3_3.SWN VGND 6.36459f $ **FLOATING
C6231 single_9b_cdac_0.cdac_sw_9b_0.cdac_sw_3_2.nooverlap_clk_0.sky130_fd_sc_hs__inv_8_0.A VGND 1.39423f $ **FLOATING
C6232 single_9b_cdac_0.cdac_sw_9b_0.cdac_sw_3_2.nooverlap_clk_0.x10.A VGND 1.39185f $ **FLOATING
C6233 single_9b_cdac_0.cdac_sw_9b_0.cdac_sw_3_2.nooverlap_clk_0.sky130_fd_sc_hs__inv_1_1.A VGND 0.45426f $ **FLOATING
C6234 single_9b_cdac_0.cdac_sw_9b_0.cdac_sw_3_2.nooverlap_clk_0.x6.A VGND 0.47224f $ **FLOATING
C6235 single_9b_cdac_0.cdac_sw_9b_0.cdac_sw_3_2.nooverlap_clk_0.x8.A VGND 1.57322f $ **FLOATING
C6236 single_9b_cdac_0.cdac_sw_9b_0.cdac_sw_3_2.nooverlap_clk_0.x1.A VGND 1.60512f $ **FLOATING
C6237 single_9b_cdac_0.cdac_sw_9b_0.S[0] VGND 94.7196f $ **FLOATING
C6238 single_9b_cdac_0.cdac_sw_9b_0.cdac_sw_3_1.nooverlap_clk_0.CLKB0 VGND 3.16256f $ **FLOATING
C6239 a_57946_26999# VGND 0.16243f $ **FLOATING
C6240 single_9b_cdac_0.SW[1] VGND 7.24534f $ **FLOATING
C6241 a_54032_26990# VGND 0.89543f $ **FLOATING
C6242 single_9b_cdac_0.cdac_sw_9b_0.cdac_sw_3_0.nooverlap_clk_0.CLK0 VGND 2.66664f $ **FLOATING
C6243 single_9b_cdac_0.cdac_sw_9b_0.cdac_sw_3_1.tg_sw_3_3.SWN VGND 6.34807f $ **FLOATING
C6244 single_9b_cdac_0.cdac_sw_9b_0.cdac_sw_3_1.nooverlap_clk_0.sky130_fd_sc_hs__inv_8_0.A VGND 1.3729f $ **FLOATING
C6245 single_9b_cdac_0.cdac_sw_9b_0.cdac_sw_3_1.nooverlap_clk_0.x10.A VGND 1.39185f $ **FLOATING
C6246 single_9b_cdac_0.cdac_sw_9b_0.cdac_sw_3_1.nooverlap_clk_0.sky130_fd_sc_hs__inv_1_1.A VGND 0.44898f $ **FLOATING
C6247 single_9b_cdac_0.cdac_sw_9b_0.cdac_sw_3_1.nooverlap_clk_0.x6.A VGND 0.47224f $ **FLOATING
C6248 single_9b_cdac_0.cdac_sw_9b_0.cdac_sw_3_2.tg_sw_3_3.SWP VGND 4.52773f $ **FLOATING
C6249 single_9b_cdac_0.cdac_sw_9b_0.cdac_sw_3_1.nooverlap_clk_0.x8.A VGND 1.56079f $ **FLOATING
C6250 single_9b_cdac_0.cdac_sw_9b_0.cdac_sw_3_2.nooverlap_clk_0.x4.A VGND 0.42464f $ **FLOATING
C6251 single_9b_cdac_0.cdac_sw_9b_0.cdac_sw_3_2.nooverlap_clk_0.sky130_fd_sc_hs__nand2_1_0.Y VGND 0.41378f $ **FLOATING
C6252 single_9b_cdac_0.cdac_sw_9b_0.cdac_sw_3_1.nooverlap_clk_0.x1.A VGND 1.58505f $ **FLOATING
C6253 single_9b_cdac_0.cdac_sw_9b_0.S[1] VGND 47.9705f $ **FLOATING
C6254 single_9b_cdac_0.cdac_sw_9b_0.cdac_sw_3_0.nooverlap_clk_0.CLKB0 VGND 3.16255f $ **FLOATING
C6255 a_53154_26999# VGND 0.16243f $ **FLOATING
C6256 single_9b_cdac_0.SW[2] VGND 6.81276f $ **FLOATING
C6257 a_49221_26990# VGND 0.89502f $ **FLOATING
C6258 single_9b_cdac_0.cdac_sw_9b_0.cdac_sw_3_4.nooverlap_clk_0.CLK0 VGND 2.66535f $ **FLOATING
C6259 single_9b_cdac_0.cdac_sw_9b_0.cdac_sw_3_0.tg_sw_3_3.SWN VGND 6.34853f $ **FLOATING
C6260 single_9b_cdac_0.cdac_sw_9b_0.cdac_sw_3_0.nooverlap_clk_0.sky130_fd_sc_hs__inv_8_0.A VGND 1.37221f $ **FLOATING
C6261 single_9b_cdac_0.cdac_sw_9b_0.cdac_sw_3_0.nooverlap_clk_0.x10.A VGND 1.39185f $ **FLOATING
C6262 single_9b_cdac_0.cdac_sw_9b_0.cdac_sw_3_0.nooverlap_clk_0.sky130_fd_sc_hs__inv_1_1.A VGND 0.44881f $ **FLOATING
C6263 single_9b_cdac_0.cdac_sw_9b_0.cdac_sw_3_0.nooverlap_clk_0.x6.A VGND 0.47224f $ **FLOATING
C6264 single_9b_cdac_0.cdac_sw_9b_0.cdac_sw_3_1.tg_sw_3_3.SWP VGND 4.51045f $ **FLOATING
C6265 single_9b_cdac_0.cdac_sw_9b_0.cdac_sw_3_0.nooverlap_clk_0.x8.A VGND 1.56057f $ **FLOATING
C6266 single_9b_cdac_0.cdac_sw_9b_0.cdac_sw_3_1.nooverlap_clk_0.x4.A VGND 0.42464f $ **FLOATING
C6267 single_9b_cdac_0.cdac_sw_9b_0.cdac_sw_3_1.nooverlap_clk_0.sky130_fd_sc_hs__nand2_1_0.Y VGND 0.40523f $ **FLOATING
C6268 single_9b_cdac_0.cdac_sw_9b_0.cdac_sw_3_0.nooverlap_clk_0.x1.A VGND 1.58431f $ **FLOATING
C6269 single_9b_cdac_0.cdac_sw_9b_0.S[2] VGND 30.361f $ **FLOATING
C6270 single_9b_cdac_0.cdac_sw_9b_0.cdac_sw_3_4.nooverlap_clk_0.CLKB0 VGND 3.16311f $ **FLOATING
C6271 a_48343_26999# VGND 0.16243f $ **FLOATING
C6272 single_9b_cdac_0.SW[3] VGND 6.56516f $ **FLOATING
C6273 a_44418_26990# VGND 0.89497f $ **FLOATING
C6274 single_9b_cdac_0.cdac_sw_9b_0.cdac_sw_3_3.nooverlap_clk_0.CLK0 VGND 2.665f $ **FLOATING
C6275 single_9b_cdac_0.cdac_sw_9b_0.cdac_sw_3_4.tg_sw_3_3.SWN VGND 6.34862f $ **FLOATING
C6276 single_9b_cdac_0.cdac_sw_9b_0.cdac_sw_3_4.nooverlap_clk_0.sky130_fd_sc_hs__inv_8_0.A VGND 1.37348f $ **FLOATING
C6277 single_9b_cdac_0.cdac_sw_9b_0.cdac_sw_3_4.nooverlap_clk_0.x10.A VGND 1.39185f $ **FLOATING
C6278 single_9b_cdac_0.cdac_sw_9b_0.cdac_sw_3_4.nooverlap_clk_0.sky130_fd_sc_hs__inv_1_1.A VGND 0.44912f $ **FLOATING
C6279 single_9b_cdac_0.cdac_sw_9b_0.cdac_sw_3_4.nooverlap_clk_0.x6.A VGND 0.47224f $ **FLOATING
C6280 single_9b_cdac_0.cdac_sw_9b_0.cdac_sw_3_0.tg_sw_3_3.SWP VGND 4.51335f $ **FLOATING
C6281 single_9b_cdac_0.cdac_sw_9b_0.cdac_sw_3_4.nooverlap_clk_0.x8.A VGND 1.56099f $ **FLOATING
C6282 single_9b_cdac_0.cdac_sw_9b_0.cdac_sw_3_0.nooverlap_clk_0.x4.A VGND 0.42464f $ **FLOATING
C6283 single_9b_cdac_0.cdac_sw_9b_0.cdac_sw_3_0.nooverlap_clk_0.sky130_fd_sc_hs__nand2_1_0.Y VGND 0.405f $ **FLOATING
C6284 single_9b_cdac_0.cdac_sw_9b_0.cdac_sw_3_4.nooverlap_clk_0.x1.A VGND 1.5857f $ **FLOATING
C6285 single_9b_cdac_0.cdac_sw_9b_0.S[3] VGND 21.9682f $ **FLOATING
C6286 single_9b_cdac_0.cdac_sw_9b_0.cdac_sw_3_3.nooverlap_clk_0.CLKB0 VGND 3.16279f $ **FLOATING
C6287 a_43540_26999# VGND 0.16243f $ **FLOATING
C6288 single_9b_cdac_0.SW[4] VGND 6.37521f $ **FLOATING
C6289 a_39616_26990# VGND 0.89497f $ **FLOATING
C6290 single_9b_cdac_0.cdac_sw_9b_0.cdac_sw_3_5.nooverlap_clk_0.CLK0 VGND 2.66616f $ **FLOATING
C6291 single_9b_cdac_0.cdac_sw_9b_0.cdac_sw_3_3.tg_sw_3_3.SWN VGND 6.34842f $ **FLOATING
C6292 single_9b_cdac_0.cdac_sw_9b_0.cdac_sw_3_3.nooverlap_clk_0.sky130_fd_sc_hs__inv_8_0.A VGND 1.37296f $ **FLOATING
C6293 single_9b_cdac_0.cdac_sw_9b_0.cdac_sw_3_3.nooverlap_clk_0.x10.A VGND 1.39185f $ **FLOATING
C6294 single_9b_cdac_0.cdac_sw_9b_0.cdac_sw_3_3.nooverlap_clk_0.sky130_fd_sc_hs__inv_1_1.A VGND 0.44899f $ **FLOATING
C6295 single_9b_cdac_0.cdac_sw_9b_0.cdac_sw_3_3.nooverlap_clk_0.x6.A VGND 0.47224f $ **FLOATING
C6296 single_9b_cdac_0.cdac_sw_9b_0.cdac_sw_3_4.tg_sw_3_3.SWP VGND 4.51193f $ **FLOATING
C6297 single_9b_cdac_0.cdac_sw_9b_0.cdac_sw_3_3.nooverlap_clk_0.x8.A VGND 1.56081f $ **FLOATING
C6298 single_9b_cdac_0.cdac_sw_9b_0.cdac_sw_3_4.nooverlap_clk_0.x4.A VGND 0.42464f $ **FLOATING
C6299 single_9b_cdac_0.cdac_sw_9b_0.cdac_sw_3_4.nooverlap_clk_0.sky130_fd_sc_hs__nand2_1_0.Y VGND 0.40542f $ **FLOATING
C6300 single_9b_cdac_0.cdac_sw_9b_0.cdac_sw_3_3.nooverlap_clk_0.x1.A VGND 1.58513f $ **FLOATING
C6301 single_9b_cdac_0.cdac_sw_9b_0.S[4] VGND 22.6775f $ **FLOATING
C6302 single_9b_cdac_0.cdac_sw_9b_0.cdac_sw_3_5.nooverlap_clk_0.CLKB0 VGND 3.16276f $ **FLOATING
C6303 a_38738_26999# VGND 0.16243f $ **FLOATING
C6304 single_9b_cdac_0.SW[5] VGND 6.06253f $ **FLOATING
C6305 a_34814_26990# VGND 0.89548f $ **FLOATING
C6306 single_9b_cdac_0.cdac_sw_9b_0.cdac_sw_3_6.nooverlap_clk_0.CLK0 VGND 2.66683f $ **FLOATING
C6307 single_9b_cdac_0.cdac_sw_9b_0.cdac_sw_3_5.tg_sw_3_3.SWN VGND 6.34843f $ **FLOATING
C6308 single_9b_cdac_0.cdac_sw_9b_0.cdac_sw_3_5.nooverlap_clk_0.sky130_fd_sc_hs__inv_8_0.A VGND 1.3729f $ **FLOATING
C6309 single_9b_cdac_0.cdac_sw_9b_0.cdac_sw_3_5.nooverlap_clk_0.x10.A VGND 1.39185f $ **FLOATING
C6310 single_9b_cdac_0.cdac_sw_9b_0.cdac_sw_3_5.nooverlap_clk_0.sky130_fd_sc_hs__inv_1_1.A VGND 0.44898f $ **FLOATING
C6311 single_9b_cdac_0.cdac_sw_9b_0.cdac_sw_3_5.nooverlap_clk_0.x6.A VGND 0.47224f $ **FLOATING
C6312 single_9b_cdac_0.cdac_sw_9b_0.cdac_sw_3_3.tg_sw_3_3.SWP VGND 4.51156f $ **FLOATING
C6313 single_9b_cdac_0.cdac_sw_9b_0.cdac_sw_3_5.nooverlap_clk_0.x8.A VGND 1.56079f $ **FLOATING
C6314 single_9b_cdac_0.cdac_sw_9b_0.cdac_sw_3_3.nooverlap_clk_0.x4.A VGND 0.42464f $ **FLOATING
C6315 single_9b_cdac_0.cdac_sw_9b_0.cdac_sw_3_3.nooverlap_clk_0.sky130_fd_sc_hs__nand2_1_0.Y VGND 0.40525f $ **FLOATING
C6316 single_9b_cdac_0.cdac_sw_9b_0.cdac_sw_3_5.nooverlap_clk_0.x1.A VGND 1.58505f $ **FLOATING
C6317 single_9b_cdac_0.cdac_sw_9b_0.S[5] VGND 17.533f $ **FLOATING
C6318 single_9b_cdac_0.cdac_sw_9b_0.cdac_sw_3_6.nooverlap_clk_0.CLKB0 VGND 3.16276f $ **FLOATING
C6319 a_33936_26999# VGND 0.16243f $ **FLOATING
C6320 single_9b_cdac_0.SW[6] VGND 5.5865f $ **FLOATING
C6321 a_30012_26990# VGND 0.89497f $ **FLOATING
C6322 single_9b_cdac_0.cdac_sw_9b_0.cdac_sw_3_7.nooverlap_clk_0.CLK0 VGND 2.66498f $ **FLOATING
C6323 single_9b_cdac_0.cdac_sw_9b_0.cdac_sw_3_6.tg_sw_3_3.SWN VGND 6.34843f $ **FLOATING
C6324 single_9b_cdac_0.cdac_sw_9b_0.cdac_sw_3_6.nooverlap_clk_0.sky130_fd_sc_hs__inv_8_0.A VGND 1.3729f $ **FLOATING
C6325 single_9b_cdac_0.cdac_sw_9b_0.cdac_sw_3_6.nooverlap_clk_0.x10.A VGND 1.39185f $ **FLOATING
C6326 single_9b_cdac_0.cdac_sw_9b_0.cdac_sw_3_6.nooverlap_clk_0.sky130_fd_sc_hs__inv_1_1.A VGND 0.44898f $ **FLOATING
C6327 single_9b_cdac_0.cdac_sw_9b_0.cdac_sw_3_6.nooverlap_clk_0.x6.A VGND 0.47224f $ **FLOATING
C6328 single_9b_cdac_0.cdac_sw_9b_0.cdac_sw_3_5.tg_sw_3_3.SWP VGND 4.51162f $ **FLOATING
C6329 single_9b_cdac_0.cdac_sw_9b_0.cdac_sw_3_6.nooverlap_clk_0.x8.A VGND 1.56079f $ **FLOATING
C6330 single_9b_cdac_0.cdac_sw_9b_0.cdac_sw_3_5.nooverlap_clk_0.x4.A VGND 0.42464f $ **FLOATING
C6331 single_9b_cdac_0.cdac_sw_9b_0.cdac_sw_3_5.nooverlap_clk_0.sky130_fd_sc_hs__nand2_1_0.Y VGND 0.40523f $ **FLOATING
C6332 single_9b_cdac_0.cdac_sw_9b_0.cdac_sw_3_6.nooverlap_clk_0.x1.A VGND 1.58505f $ **FLOATING
C6333 single_9b_cdac_0.cdac_sw_9b_0.S[6] VGND 16.6825f $ **FLOATING
C6334 single_9b_cdac_0.cdac_sw_9b_0.cdac_sw_3_7.nooverlap_clk_0.CLKB0 VGND 3.16276f $ **FLOATING
C6335 a_29134_26999# VGND 0.16243f $ **FLOATING
C6336 single_9b_cdac_0.SW[7] VGND 5.50572f $ **FLOATING
C6337 a_25210_26990# VGND 0.89548f $ **FLOATING
C6338 single_9b_cdac_0.cdac_sw_9b_0.cdac_sw_3_8.nooverlap_clk_0.CLK0 VGND 2.68106f $ **FLOATING
C6339 single_9b_cdac_0.cdac_sw_9b_0.cdac_sw_3_7.tg_sw_3_3.SWN VGND 6.3484f $ **FLOATING
C6340 single_9b_cdac_0.cdac_sw_9b_0.cdac_sw_3_7.nooverlap_clk_0.sky130_fd_sc_hs__inv_8_0.A VGND 1.3729f $ **FLOATING
C6341 single_9b_cdac_0.cdac_sw_9b_0.cdac_sw_3_7.nooverlap_clk_0.x10.A VGND 1.39185f $ **FLOATING
C6342 single_9b_cdac_0.cdac_sw_9b_0.cdac_sw_3_7.nooverlap_clk_0.sky130_fd_sc_hs__inv_1_1.A VGND 0.44898f $ **FLOATING
C6343 single_9b_cdac_0.cdac_sw_9b_0.cdac_sw_3_7.nooverlap_clk_0.x6.A VGND 0.47224f $ **FLOATING
C6344 single_9b_cdac_0.cdac_sw_9b_0.cdac_sw_3_6.tg_sw_3_3.SWP VGND 4.51212f $ **FLOATING
C6345 single_9b_cdac_0.cdac_sw_9b_0.cdac_sw_3_7.nooverlap_clk_0.x8.A VGND 1.56079f $ **FLOATING
C6346 single_9b_cdac_0.cdac_sw_9b_0.cdac_sw_3_6.nooverlap_clk_0.x4.A VGND 0.42464f $ **FLOATING
C6347 single_9b_cdac_0.cdac_sw_9b_0.cdac_sw_3_6.nooverlap_clk_0.sky130_fd_sc_hs__nand2_1_0.Y VGND 0.40523f $ **FLOATING
C6348 single_9b_cdac_0.cdac_sw_9b_0.cdac_sw_3_7.nooverlap_clk_0.x1.A VGND 1.58505f $ **FLOATING
C6349 single_9b_cdac_0.cdac_sw_9b_0.S[7] VGND 15.3302f $ **FLOATING
C6350 single_9b_cdac_0.cdac_sw_9b_0.cdac_sw_3_8.nooverlap_clk_0.CLKB0 VGND 3.17698f $ **FLOATING
C6351 a_24332_26999# VGND 0.16243f $ **FLOATING
C6352 a_13308_26516# VGND 0.08223f $ **FLOATING
C6353 a_13968_26516# VGND 0.2796f $ **FLOATING
C6354 a_14143_26490# VGND 0.50188f $ **FLOATING
C6355 a_13403_26516# VGND 0.27063f $ **FLOATING
C6356 a_13621_26758# VGND 0.18733f $ **FLOATING
C6357 a_13053_26516# VGND 0.31318f $ **FLOATING
C6358 sar9b_0.net1 VGND 3.46999f $ **FLOATING
C6359 a_12887_26516# VGND 0.71276f $ **FLOATING
C6360 sar9b_0.net13 VGND 3.68682f $ **FLOATING
C6361 a_11376_26516# VGND 0.08f $ **FLOATING
C6362 a_12036_26516# VGND 0.27213f $ **FLOATING
C6363 a_12211_26490# VGND 0.53148f $ **FLOATING
C6364 a_11471_26516# VGND 0.28111f $ **FLOATING
C6365 a_11689_26758# VGND 0.1867f $ **FLOATING
C6366 a_11121_26516# VGND 0.30545f $ **FLOATING
C6367 sar9b_0.net42 VGND 1.31494f $ **FLOATING
C6368 a_10955_26516# VGND 0.65127f $ **FLOATING
C6369 a_9536_26516# VGND 0.07389f $ **FLOATING
C6370 a_10196_26516# VGND 0.26519f $ **FLOATING
C6371 a_10371_26490# VGND 0.48253f $ **FLOATING
C6372 a_9631_26516# VGND 0.26066f $ **FLOATING
C6373 a_9849_26758# VGND 0.17731f $ **FLOATING
C6374 a_9281_26516# VGND 0.29904f $ **FLOATING
C6375 sar9b_0.net41 VGND 3.61062f $ **FLOATING
C6376 a_9115_26516# VGND 0.55791f $ **FLOATING
C6377 a_5856_26516# VGND 0.08f $ **FLOATING
C6378 sar9b_0.net20 VGND 0.6728f $ **FLOATING
C6379 a_8613_26681# VGND 0.25775f $ **FLOATING
C6380 sar9b_0.net18 VGND 0.24815f $ **FLOATING
C6381 a_7325_26681# VGND 0.24266f $ **FLOATING
C6382 a_6516_26516# VGND 0.31023f $ **FLOATING
C6383 a_6691_26490# VGND 0.51101f $ **FLOATING
C6384 a_5951_26516# VGND 0.26871f $ **FLOATING
C6385 a_6169_26758# VGND 0.19146f $ **FLOATING
C6386 a_5601_26516# VGND 0.31857f $ **FLOATING
C6387 sar9b_0.net36 VGND 8.62606f $ **FLOATING
C6388 a_5435_26516# VGND 0.661f $ **FLOATING
C6389 single_9b_cdac_0.SW[8] VGND 6.77644f $ **FLOATING
C6390 sar9b_0.net15 VGND 21.5844f $ **FLOATING
C6391 a_8340_27426# VGND 0.076f $ **FLOATING
C6392 a_6726_27060# VGND 0.0995f $ **FLOATING
C6393 sar9b_0.net17 VGND 0.49267f $ **FLOATING
C6394 a_14451_27060# VGND 0.21809f $ **FLOATING
C6395 sar9b_0.net34 VGND 0.36765f $ **FLOATING
C6396 a_14175_27060# VGND 0.22515f $ **FLOATING
C6397 sar9b_0.net14 VGND 0.39229f $ **FLOATING
C6398 sar9b_0.net25 VGND 0.37858f $ **FLOATING
C6399 a_13857_27279# VGND 0.22396f $ **FLOATING
C6400 a_13379_27398# VGND 0.24227f $ **FLOATING
C6401 sar9b_0.net24 VGND 0.47256f $ **FLOATING
C6402 a_12937_27279# VGND 0.25704f $ **FLOATING
C6403 sar9b_0.net23 VGND 0.61698f $ **FLOATING
C6404 a_11649_27279# VGND 0.2703f $ **FLOATING
C6405 sar9b_0.net22 VGND 1.00053f $ **FLOATING
C6406 a_10637_27279# VGND 0.27099f $ **FLOATING
C6407 sar9b_0.net21 VGND 0.23586f $ **FLOATING
C6408 a_9809_27279# VGND 0.23844f $ **FLOATING
C6409 a_9000_27438# VGND 0.26254f $ **FLOATING
C6410 a_9175_27364# VGND 0.48376f $ **FLOATING
C6411 a_8435_27438# VGND 0.27875f $ **FLOATING
C6412 a_8653_27034# VGND 0.18369f $ **FLOATING
C6413 a_8085_27066# VGND 0.31915f $ **FLOATING
C6414 sar9b_0.net39 VGND 1.31184f $ **FLOATING
C6415 a_7919_27066# VGND 0.55608f $ **FLOATING
C6416 sar9b_0.net19 VGND 0.4807f $ **FLOATING
C6417 a_7417_27279# VGND 0.25395f $ **FLOATING
C6418 sar9b_0.FINAL VGND 4.26602f $ **FLOATING
C6419 sar9b_0.net35 VGND 1.87585f $ **FLOATING
C6420 a_6094_27060# VGND 0.18864f $ **FLOATING
C6421 a_6163_27034# VGND 0.28598f $ **FLOATING
C6422 a_5968_27176# VGND 0.34348f $ **FLOATING
C6423 a_6007_27302# VGND 0.57371f $ **FLOATING
C6424 sar9b_0.net3 VGND 9.19519f $ **FLOATING
C6425 a_5690_27192# VGND 0.27748f $ **FLOATING
C6426 a_5487_27034# VGND 0.51409f $ **FLOATING
C6427 single_9b_cdac_0.cdac_sw_9b_0.cdac_sw_3_8.tg_sw_3_3.SWN VGND 6.37207f $ **FLOATING
C6428 single_9b_cdac_0.cdac_sw_9b_0.cdac_sw_3_8.nooverlap_clk_0.sky130_fd_sc_hs__inv_8_0.A VGND 1.3729f $ **FLOATING
C6429 single_9b_cdac_0.cdac_sw_9b_0.cdac_sw_3_8.nooverlap_clk_0.x10.A VGND 1.39185f $ **FLOATING
C6430 single_9b_cdac_0.cdac_sw_9b_0.cdac_sw_3_8.nooverlap_clk_0.sky130_fd_sc_hs__inv_1_1.A VGND 0.44898f $ **FLOATING
C6431 single_9b_cdac_0.cdac_sw_9b_0.cdac_sw_3_8.nooverlap_clk_0.x6.A VGND 0.47224f $ **FLOATING
C6432 single_9b_cdac_0.cdac_sw_9b_0.cdac_sw_3_7.tg_sw_3_3.SWP VGND 4.51154f $ **FLOATING
C6433 single_9b_cdac_0.cdac_sw_9b_0.cdac_sw_3_8.nooverlap_clk_0.x8.A VGND 1.56079f $ **FLOATING
C6434 single_9b_cdac_0.cdac_sw_9b_0.cdac_sw_3_7.nooverlap_clk_0.x4.A VGND 0.42464f $ **FLOATING
C6435 single_9b_cdac_0.cdac_sw_9b_0.cdac_sw_3_7.nooverlap_clk_0.sky130_fd_sc_hs__nand2_1_0.Y VGND 0.40523f $ **FLOATING
C6436 single_9b_cdac_0.cdac_sw_9b_0.cdac_sw_3_8.nooverlap_clk_0.x1.A VGND 1.58505f $ **FLOATING
C6437 single_9b_cdac_0.cdac_sw_9b_0.S[8] VGND 13.9589f $ **FLOATING
C6438 single_9b_cdac_0.cdac_sw_9b_0.cdac_sw_3_8.tg_sw_3_3.SWP VGND 4.71478f $ **FLOATING
C6439 single_9b_cdac_0.cdac_sw_9b_0.cdac_sw_3_8.nooverlap_clk_0.x4.A VGND 0.42464f $ **FLOATING
C6440 single_9b_cdac_0.cdac_sw_9b_0.cdac_sw_3_8.nooverlap_clk_0.sky130_fd_sc_hs__nand2_1_0.Y VGND 0.40523f $ **FLOATING
C6441 single_9b_cdac_0.cdac_sw_9b_0.cdac_sw_3_2.nooverlap_clk_0.x3.Y VGND 0.35827f $ **FLOATING
C6442 single_9b_cdac_0.cdac_sw_9b_0.cdac_sw_3_1.nooverlap_clk_0.x3.Y VGND 0.35827f $ **FLOATING
C6443 single_9b_cdac_0.cdac_sw_9b_0.cdac_sw_3_0.nooverlap_clk_0.x3.Y VGND 0.35827f $ **FLOATING
C6444 single_9b_cdac_1.CF[0] VGND 15.1352f $ **FLOATING
C6445 single_9b_cdac_0.cdac_sw_9b_0.cdac_sw_3_4.nooverlap_clk_0.x3.Y VGND 0.35827f $ **FLOATING
C6446 single_9b_cdac_1.CF[1] VGND 10.8967f $ **FLOATING
C6447 single_9b_cdac_0.cdac_sw_9b_0.cdac_sw_3_3.nooverlap_clk_0.x3.Y VGND 0.35827f $ **FLOATING
C6448 single_9b_cdac_1.CF[2] VGND 10.7524f $ **FLOATING
C6449 single_9b_cdac_0.cdac_sw_9b_0.cdac_sw_3_5.nooverlap_clk_0.x3.Y VGND 0.35827f $ **FLOATING
C6450 single_9b_cdac_1.CF[3] VGND 10.3785f $ **FLOATING
C6451 single_9b_cdac_0.cdac_sw_9b_0.cdac_sw_3_6.nooverlap_clk_0.x3.Y VGND 0.35827f $ **FLOATING
C6452 single_9b_cdac_1.CF[4] VGND 10.1915f $ **FLOATING
C6453 single_9b_cdac_0.cdac_sw_9b_0.cdac_sw_3_7.nooverlap_clk_0.x3.Y VGND 0.35827f $ **FLOATING
C6454 single_9b_cdac_1.CF[5] VGND 9.96629f $ **FLOATING
C6455 single_9b_cdac_0.cdac_sw_9b_0.cdac_sw_3_8.nooverlap_clk_0.x3.Y VGND 0.35827f $ **FLOATING
C6456 single_9b_cdac_1.CF[6] VGND 9.68145f $ **FLOATING
C6457 single_9b_cdac_1.CF[7] VGND 9.20979f $ **FLOATING
C6458 single_9b_cdac_1.CF[8] VGND 8.17347f $ **FLOATING
C6459 dw_17224_1400# VGND 28.103f $ **FLOATING
C6460 dw_12589_1395# VGND 28.3101f $ **FLOATING
.ends
